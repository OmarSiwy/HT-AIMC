// 8-input translinear softmax — behavioural golden model, ports 1:1 with
// netlist/translinear_softmax.
// Tail sink: ib = ib0 * e^((V(vb_tail) - vbt) / (nt*vt)), vbt = vb0 + tcv*(T - tnom):
//            the tail device's weak-inversion law, with its VT tempco.
// Split:     branch k carries ib * e^(beta*vin_k) / sum_j e^(beta*vin_j),
//            beta = 1/(n*vt) (KCL on the shared source node is the normalisation).
// Outputs:   each branch current, delayed by a first-order pole (tau: the mirror's
//            diode node), sourced from vdd into iout_k with a tanh compliance knee.
// Supply:    ib (branch side, returns through vss) + the mirrored outputs.
// Not modelled: the per-branch pole slowing as a branch current falls, the winner's
// drift out of weak inversion (beta bends at large spreads), mirror error, mismatch.
`include "disciplines.vams"
`include "constants.vams"

module translinear_softmax(vin0, vin1, vin2, vin3, vin4, vin5, vin6, vin7,
                           iout0, iout1, iout2, iout3, iout4, iout5, iout6, iout7,
                           vb_tail, vdd, vss);
    inout vin0, vin1, vin2, vin3, vin4, vin5, vin6, vin7;
    inout iout0, iout1, iout2, iout3, iout4, iout5, iout6, iout7;
    inout vb_tail, vdd, vss;
    electrical vin0, vin1, vin2, vin3, vin4, vin5, vin6, vin7;
    electrical iout0, iout1, iout2, iout3, iout4, iout5, iout6, iout7;
    electrical vb_tail, vdd, vss;
    electrical x0, x1, x2, x3, x4, x5, x6, x7;      // delayed branch currents (1 V = 1 uA)

    parameter real ib0 = 500e-9 from (0:inf);       // tail current at vb0, tnom (A)
    parameter real vb0 = 0.44 from (0:inf);         // vb_tail for ib0 at tnom (V)
    parameter real tcv = -1.0e-3;                   // tail VGS tempco at ib0 (V/K)
    parameter real tnom = 27.0;                     // C
    parameter real nt = 1.4 from (1:inf);           // tail slope factor
    parameter real n = 1.4 from (1:inf);            // branch slope factor: beta = 1/(n*vt)
    parameter real tau = 200e-9 from (0:inf);       // output pole (s)
    parameter real vknee = 0.1 from (0:inf);        // output compliance knee (V)

    real vt, ib, e0, e1, e2, e3, e4, e5, e6, e7, k, r;

    analog begin
        vt = $vt;
        ib = ib0 * limexp((V(vb_tail, vss) - vb0 - tcv * ($temperature - `P_CELSIUS0 - tnom))
                          / (nt * vt));
        // weights relative to vin0 (bounded: the score window is a few hundred mV)
        e0 = 1.0;
        e1 = limexp((V(vin1, vss) - V(vin0, vss)) / (n * vt));
        e2 = limexp((V(vin2, vss) - V(vin0, vss)) / (n * vt));
        e3 = limexp((V(vin3, vss) - V(vin0, vss)) / (n * vt));
        e4 = limexp((V(vin4, vss) - V(vin0, vss)) / (n * vt));
        e5 = limexp((V(vin5, vss) - V(vin0, vss)) / (n * vt));
        e6 = limexp((V(vin6, vss) - V(vin0, vss)) / (n * vt));
        e7 = limexp((V(vin7, vss) - V(vin0, vss)) / (n * vt));
        k = ib * 1e6 / (e0 + e1 + e2 + e3 + e4 + e5 + e6 + e7);
        r = 1e3;
        I(x0, vss) <+ (V(x0, vss) - k * e0) / r + tau / r * ddt(V(x0, vss));
        I(x1, vss) <+ (V(x1, vss) - k * e1) / r + tau / r * ddt(V(x1, vss));
        I(x2, vss) <+ (V(x2, vss) - k * e2) / r + tau / r * ddt(V(x2, vss));
        I(x3, vss) <+ (V(x3, vss) - k * e3) / r + tau / r * ddt(V(x3, vss));
        I(x4, vss) <+ (V(x4, vss) - k * e4) / r + tau / r * ddt(V(x4, vss));
        I(x5, vss) <+ (V(x5, vss) - k * e5) / r + tau / r * ddt(V(x5, vss));
        I(x6, vss) <+ (V(x6, vss) - k * e6) / r + tau / r * ddt(V(x6, vss));
        I(x7, vss) <+ (V(x7, vss) - k * e7) / r + tau / r * ddt(V(x7, vss));
        I(vdd, iout0) <+ V(x0, vss) * 1e-6 * tanh(V(vdd, iout0) / vknee);
        I(vdd, iout1) <+ V(x1, vss) * 1e-6 * tanh(V(vdd, iout1) / vknee);
        I(vdd, iout2) <+ V(x2, vss) * 1e-6 * tanh(V(vdd, iout2) / vknee);
        I(vdd, iout3) <+ V(x3, vss) * 1e-6 * tanh(V(vdd, iout3) / vknee);
        I(vdd, iout4) <+ V(x4, vss) * 1e-6 * tanh(V(vdd, iout4) / vknee);
        I(vdd, iout5) <+ V(x5, vss) * 1e-6 * tanh(V(vdd, iout5) / vknee);
        I(vdd, iout6) <+ V(x6, vss) * 1e-6 * tanh(V(vdd, iout6) / vknee);
        I(vdd, iout7) <+ V(x7, vss) * 1e-6 * tanh(V(vdd, iout7) / vknee);
        I(vdd, vss) <+ ib;
    end
endmodule
