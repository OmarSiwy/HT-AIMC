// 4-bit R-string write DAC — behavioural golden model, ports 1:1 with netlist/write_dac.
// out = Thevenin source: code*vref/15 behind the ladder's tap resistance plus the tap
// TG's on resistance; the ladder draws vref / (15*rseg) from vref.
//
// Continuous form (OpenVAF subset): each bit is a tanh threshold at vdd/2, so the code
// moves smoothly across an input edge (the netlist's decoder can glitch through other
// taps there too). Not modelled: decoder delay (~ns, far below the settling budget),
// TG charge injection and leakage, poly-resistor mismatch and voltage coefficient,
// logic supply current.
`include "disciplines.vams"
`include "constants.vams"

module write_dac(b0, b1, b2, b3, out, vref, vdd, vss);
    inout b0, b1, b2, b3, out, vref, vdd, vss;
    electrical b0, b1, b2, b3, out, vref, vdd, vss;

    parameter real rseg = 35.8e3 from (0:inf);   // ladder segment (ohm)
    parameter real ron = 10e3 from [0:inf);      // tap TG on resistance (ohm)
    parameter real cout = 10e-15 from [0:inf);   // out node: 16 TG junctions (F)
    parameter real vsw = 0.02 from (0:inf);      // logic threshold width (V)

    real vth, code, rth;

    analog begin
        vth = V(vdd, vss) / 2;
        code = 0.5 * (1.0 + tanh((V(b0, vss) - vth) / vsw))
             + 1.0 * (1.0 + tanh((V(b1, vss) - vth) / vsw))
             + 2.0 * (1.0 + tanh((V(b2, vss) - vth) / vsw))
             + 4.0 * (1.0 + tanh((V(b3, vss) - vth) / vsw));
        rth = rseg * code * (15.0 - code) / 15.0 + ron;
        I(out, vss) <+ (V(out, vss) - V(vref, vss) * code / 15.0) / rth;
        I(out, vss) <+ cout * ddt(V(out, vss));
        I(vref, vss) <+ V(vref, vss) / (15.0 * rseg);
    end
endmodule
