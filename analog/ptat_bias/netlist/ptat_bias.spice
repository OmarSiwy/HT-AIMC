.subckt ptat_bias vb_tail vdd vss
Xmpl0 nl vb_p vdd vdd sky130_fd_pr__pfet_01v8 W=48.53 L=1
Xmpl1 nl vb_p vdd vdd sky130_fd_pr__pfet_01v8 W=48.53 L=1
Xmpl2 nl vb_p vdd vdd sky130_fd_pr__pfet_01v8 W=48.53 L=1
Xmpl3 nl vb_p vdd vdd sky130_fd_pr__pfet_01v8 W=48.53 L=1
Xmpr vb_p vb_p vdd vdd sky130_fd_pr__pfet_01v8 W=48.53 L=1
Xmpo vb_tail vb_p vdd vdd sky130_fd_pr__pfet_01v8 W=48.53 L=1
Xmnl nl nl vss vss sky130_fd_pr__nfet_01v8 W=35.99 L=1
Xmnr vb_p nl src_r vss sky130_fd_pr__nfet_01v8 W=35.99 L=1
Xrptat src_r vss vss sky130_fd_pr__res_high_po_0p35 L=69.69
Xmtailrep vb_tail vb_tail vss vss sky130_fd_pr__nfet_01v8 W=35.99 L=1
Xmpu0 pu vss vdd vdd sky130_fd_pr__pfet_01v8 W=0.42 L=16.2
Xmpu1 su vss pu vdd sky130_fd_pr__pfet_01v8 W=0.42 L=16.2
Xmsn su nl vss vss sky130_fd_pr__nfet_01v8 W=35.99 L=1
Xmstart vb_p su vss vss sky130_fd_pr__nfet_01v8 W=0.42 L=1
.ends ptat_bias
