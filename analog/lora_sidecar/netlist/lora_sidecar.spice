.subckt lora_sidecar_cell wdata wsel rd col vss
Xw wdata wsel store vss sky130_fd_pr__nfet_01v8 W=0.54 L=0.3
Xr col store rd vss sky130_fd_pr__nfet_01v8 W=0.43 L=19.2
.ends lora_sidecar_cell

.subckt lora_sidecar_dac_sw in_ out ctrl ctrl_b vdd vss
Xlora_sidecar_dac_sw_n in_ ctrl out vss sky130_fd_pr__nfet_01v8 W=0.58 L=0.15
Xlora_sidecar_dac_sw_p in_ ctrl_b out vdd sky130_fd_pr__pfet_01v8 W=0.42 L=0.15
.ends lora_sidecar_dac_sw

.subckt lora_sidecar_dac b0 b1 b2 b3 out vref vdd vss
Xtg0 vss out sel0 seln0 vdd vss lora_sidecar_dac_sw
Xtg1 tap1 out sel1 seln1 vdd vss lora_sidecar_dac_sw
Xtg2 tap2 out sel2 seln2 vdd vss lora_sidecar_dac_sw
Xtg3 tap3 out sel3 seln3 vdd vss lora_sidecar_dac_sw
Xtg4 tap4 out sel4 seln4 vdd vss lora_sidecar_dac_sw
Xtg5 tap5 out sel5 seln5 vdd vss lora_sidecar_dac_sw
Xtg6 tap6 out sel6 seln6 vdd vss lora_sidecar_dac_sw
Xtg7 tap7 out sel7 seln7 vdd vss lora_sidecar_dac_sw
Xtg8 tap8 out sel8 seln8 vdd vss lora_sidecar_dac_sw
Xtg9 tap9 out sel9 seln9 vdd vss lora_sidecar_dac_sw
Xtg10 tap10 out sel10 seln10 vdd vss lora_sidecar_dac_sw
Xtg11 tap11 out sel11 seln11 vdd vss lora_sidecar_dac_sw
Xtg12 tap12 out sel12 seln12 vdd vss lora_sidecar_dac_sw
Xtg13 tap13 out sel13 seln13 vdd vss lora_sidecar_dac_sw
Xtg14 tap14 out sel14 seln14 vdd vss lora_sidecar_dac_sw
Xtg15 vref out sel15 seln15 vdd vss lora_sidecar_dac_sw
Xseg1_0 tap1 vss vss sky130_fd_pr__res_high_po_0p35 L=61.42
Xseg1_1 tap1 vss vss sky130_fd_pr__res_high_po_0p35 L=61.42
Xseg2_0 tap2 tap1 vss sky130_fd_pr__res_high_po_0p35 L=61.42
Xseg2_1 tap2 tap1 vss sky130_fd_pr__res_high_po_0p35 L=61.42
Xseg3_0 tap3 tap2 vss sky130_fd_pr__res_high_po_0p35 L=61.42
Xseg3_1 tap3 tap2 vss sky130_fd_pr__res_high_po_0p35 L=61.42
Xseg4_0 tap4 tap3 vss sky130_fd_pr__res_high_po_0p35 L=61.42
Xseg4_1 tap4 tap3 vss sky130_fd_pr__res_high_po_0p35 L=61.42
Xseg5_0 tap5 tap4 vss sky130_fd_pr__res_high_po_0p35 L=61.42
Xseg5_1 tap5 tap4 vss sky130_fd_pr__res_high_po_0p35 L=61.42
Xseg6_0 tap6 tap5 vss sky130_fd_pr__res_high_po_0p35 L=61.42
Xseg6_1 tap6 tap5 vss sky130_fd_pr__res_high_po_0p35 L=61.42
Xseg7_0 tap7 tap6 vss sky130_fd_pr__res_high_po_0p35 L=61.42
Xseg7_1 tap7 tap6 vss sky130_fd_pr__res_high_po_0p35 L=61.42
Xseg8_0 tap8 tap7 vss sky130_fd_pr__res_high_po_0p35 L=61.42
Xseg8_1 tap8 tap7 vss sky130_fd_pr__res_high_po_0p35 L=61.42
Xseg9_0 tap9 tap8 vss sky130_fd_pr__res_high_po_0p35 L=61.42
Xseg9_1 tap9 tap8 vss sky130_fd_pr__res_high_po_0p35 L=61.42
Xseg10_0 tap10 tap9 vss sky130_fd_pr__res_high_po_0p35 L=61.42
Xseg10_1 tap10 tap9 vss sky130_fd_pr__res_high_po_0p35 L=61.42
Xseg11_0 tap11 tap10 vss sky130_fd_pr__res_high_po_0p35 L=61.42
Xseg11_1 tap11 tap10 vss sky130_fd_pr__res_high_po_0p35 L=61.42
Xseg12_0 tap12 tap11 vss sky130_fd_pr__res_high_po_0p35 L=61.42
Xseg12_1 tap12 tap11 vss sky130_fd_pr__res_high_po_0p35 L=61.42
Xseg13_0 tap13 tap12 vss sky130_fd_pr__res_high_po_0p35 L=61.42
Xseg13_1 tap13 tap12 vss sky130_fd_pr__res_high_po_0p35 L=61.42
Xseg14_0 tap14 tap13 vss sky130_fd_pr__res_high_po_0p35 L=61.42
Xseg14_1 tap14 tap13 vss sky130_fd_pr__res_high_po_0p35 L=61.42
Xseg15_0 vref tap14 vss sky130_fd_pr__res_high_po_0p35 L=61.42
Xseg15_1 vref tap14 vss sky130_fd_pr__res_high_po_0p35 L=61.42
Xinvb0_n b0_n b0 vss vss sky130_fd_pr__nfet_01v8 W=0.42 L=0.3
Xinvb0_p b0_n b0 vdd vdd sky130_fd_pr__pfet_01v8 W=1.74 L=0.3
Xinvb1_n b1_n b1 vss vss sky130_fd_pr__nfet_01v8 W=0.42 L=0.3
Xinvb1_p b1_n b1 vdd vdd sky130_fd_pr__pfet_01v8 W=1.74 L=0.3
Xinvb2_n b2_n b2 vss vss sky130_fd_pr__nfet_01v8 W=0.42 L=0.3
Xinvb2_p b2_n b2 vdd vdd sky130_fd_pr__pfet_01v8 W=1.74 L=0.3
Xinvb3_n b3_n b3 vss vss sky130_fd_pr__nfet_01v8 W=0.42 L=0.3
Xinvb3_p b3_n b3 vdd vdd sky130_fd_pr__pfet_01v8 W=1.74 L=0.3
Xdh0_p1 nh0 b3_n vdd vdd sky130_fd_pr__pfet_01v8 W=1.74 L=0.3
Xdh0_p2 nh0 b2_n vdd vdd sky130_fd_pr__pfet_01v8 W=1.74 L=0.3
Xdh0_n1 nh0 b3_n dh0_mid vss sky130_fd_pr__nfet_01v8 W=0.42 L=0.3
Xdh0_n2 dh0_mid b2_n vss vss sky130_fd_pr__nfet_01v8 W=0.42 L=0.3
Xdl0_p1 sel0 nh0 dl0_mid vdd sky130_fd_pr__pfet_01v8 W=1.74 L=0.3
Xdl0_p2 dl0_mid nl0 vdd vdd sky130_fd_pr__pfet_01v8 W=1.74 L=0.3
Xdl0_n1 sel0 nh0 vss vss sky130_fd_pr__nfet_01v8 W=0.42 L=0.3
Xdl0_n2 sel0 nl0 vss vss sky130_fd_pr__nfet_01v8 W=0.42 L=0.3
Xdg0_p1 nl0 b1_n vdd vdd sky130_fd_pr__pfet_01v8 W=1.74 L=0.3
Xdg0_p2 nl0 b0_n vdd vdd sky130_fd_pr__pfet_01v8 W=1.74 L=0.3
Xdg0_n1 nl0 b1_n dg0_mid vss sky130_fd_pr__nfet_01v8 W=0.42 L=0.3
Xdg0_n2 dg0_mid b0_n vss vss sky130_fd_pr__nfet_01v8 W=0.42 L=0.3
Xdinv0_n seln0 sel0 vss vss sky130_fd_pr__nfet_01v8 W=0.42 L=0.3
Xdinv0_p seln0 sel0 vdd vdd sky130_fd_pr__pfet_01v8 W=1.74 L=0.3
Xdh1_p1 nh1 b3_n vdd vdd sky130_fd_pr__pfet_01v8 W=1.74 L=0.3
Xdh1_p2 nh1 b2_n vdd vdd sky130_fd_pr__pfet_01v8 W=1.74 L=0.3
Xdh1_n1 nh1 b3_n dh1_mid vss sky130_fd_pr__nfet_01v8 W=0.42 L=0.3
Xdh1_n2 dh1_mid b2_n vss vss sky130_fd_pr__nfet_01v8 W=0.42 L=0.3
Xdl1_p1 sel1 nh1 dl1_mid vdd sky130_fd_pr__pfet_01v8 W=1.74 L=0.3
Xdl1_p2 dl1_mid nl1 vdd vdd sky130_fd_pr__pfet_01v8 W=1.74 L=0.3
Xdl1_n1 sel1 nh1 vss vss sky130_fd_pr__nfet_01v8 W=0.42 L=0.3
Xdl1_n2 sel1 nl1 vss vss sky130_fd_pr__nfet_01v8 W=0.42 L=0.3
Xdg1_p1 nl1 b1_n vdd vdd sky130_fd_pr__pfet_01v8 W=1.74 L=0.3
Xdg1_p2 nl1 b0 vdd vdd sky130_fd_pr__pfet_01v8 W=1.74 L=0.3
Xdg1_n1 nl1 b1_n dg1_mid vss sky130_fd_pr__nfet_01v8 W=0.42 L=0.3
Xdg1_n2 dg1_mid b0 vss vss sky130_fd_pr__nfet_01v8 W=0.42 L=0.3
Xdinv1_n seln1 sel1 vss vss sky130_fd_pr__nfet_01v8 W=0.42 L=0.3
Xdinv1_p seln1 sel1 vdd vdd sky130_fd_pr__pfet_01v8 W=1.74 L=0.3
Xdh2_p1 nh2 b3_n vdd vdd sky130_fd_pr__pfet_01v8 W=1.74 L=0.3
Xdh2_p2 nh2 b2_n vdd vdd sky130_fd_pr__pfet_01v8 W=1.74 L=0.3
Xdh2_n1 nh2 b3_n dh2_mid vss sky130_fd_pr__nfet_01v8 W=0.42 L=0.3
Xdh2_n2 dh2_mid b2_n vss vss sky130_fd_pr__nfet_01v8 W=0.42 L=0.3
Xdl2_p1 sel2 nh2 dl2_mid vdd sky130_fd_pr__pfet_01v8 W=1.74 L=0.3
Xdl2_p2 dl2_mid nl2 vdd vdd sky130_fd_pr__pfet_01v8 W=1.74 L=0.3
Xdl2_n1 sel2 nh2 vss vss sky130_fd_pr__nfet_01v8 W=0.42 L=0.3
Xdl2_n2 sel2 nl2 vss vss sky130_fd_pr__nfet_01v8 W=0.42 L=0.3
Xdg2_p1 nl2 b1 vdd vdd sky130_fd_pr__pfet_01v8 W=1.74 L=0.3
Xdg2_p2 nl2 b0_n vdd vdd sky130_fd_pr__pfet_01v8 W=1.74 L=0.3
Xdg2_n1 nl2 b1 dg2_mid vss sky130_fd_pr__nfet_01v8 W=0.42 L=0.3
Xdg2_n2 dg2_mid b0_n vss vss sky130_fd_pr__nfet_01v8 W=0.42 L=0.3
Xdinv2_n seln2 sel2 vss vss sky130_fd_pr__nfet_01v8 W=0.42 L=0.3
Xdinv2_p seln2 sel2 vdd vdd sky130_fd_pr__pfet_01v8 W=1.74 L=0.3
Xdh3_p1 nh3 b3_n vdd vdd sky130_fd_pr__pfet_01v8 W=1.74 L=0.3
Xdh3_p2 nh3 b2_n vdd vdd sky130_fd_pr__pfet_01v8 W=1.74 L=0.3
Xdh3_n1 nh3 b3_n dh3_mid vss sky130_fd_pr__nfet_01v8 W=0.42 L=0.3
Xdh3_n2 dh3_mid b2_n vss vss sky130_fd_pr__nfet_01v8 W=0.42 L=0.3
Xdl3_p1 sel3 nh3 dl3_mid vdd sky130_fd_pr__pfet_01v8 W=1.74 L=0.3
Xdl3_p2 dl3_mid nl3 vdd vdd sky130_fd_pr__pfet_01v8 W=1.74 L=0.3
Xdl3_n1 sel3 nh3 vss vss sky130_fd_pr__nfet_01v8 W=0.42 L=0.3
Xdl3_n2 sel3 nl3 vss vss sky130_fd_pr__nfet_01v8 W=0.42 L=0.3
Xdg3_p1 nl3 b1 vdd vdd sky130_fd_pr__pfet_01v8 W=1.74 L=0.3
Xdg3_p2 nl3 b0 vdd vdd sky130_fd_pr__pfet_01v8 W=1.74 L=0.3
Xdg3_n1 nl3 b1 dg3_mid vss sky130_fd_pr__nfet_01v8 W=0.42 L=0.3
Xdg3_n2 dg3_mid b0 vss vss sky130_fd_pr__nfet_01v8 W=0.42 L=0.3
Xdinv3_n seln3 sel3 vss vss sky130_fd_pr__nfet_01v8 W=0.42 L=0.3
Xdinv3_p seln3 sel3 vdd vdd sky130_fd_pr__pfet_01v8 W=1.74 L=0.3
Xdh4_p1 nh4 b3_n vdd vdd sky130_fd_pr__pfet_01v8 W=1.74 L=0.3
Xdh4_p2 nh4 b2 vdd vdd sky130_fd_pr__pfet_01v8 W=1.74 L=0.3
Xdh4_n1 nh4 b3_n dh4_mid vss sky130_fd_pr__nfet_01v8 W=0.42 L=0.3
Xdh4_n2 dh4_mid b2 vss vss sky130_fd_pr__nfet_01v8 W=0.42 L=0.3
Xdl4_p1 sel4 nh4 dl4_mid vdd sky130_fd_pr__pfet_01v8 W=1.74 L=0.3
Xdl4_p2 dl4_mid nl4 vdd vdd sky130_fd_pr__pfet_01v8 W=1.74 L=0.3
Xdl4_n1 sel4 nh4 vss vss sky130_fd_pr__nfet_01v8 W=0.42 L=0.3
Xdl4_n2 sel4 nl4 vss vss sky130_fd_pr__nfet_01v8 W=0.42 L=0.3
Xdg4_p1 nl4 b1_n vdd vdd sky130_fd_pr__pfet_01v8 W=1.74 L=0.3
Xdg4_p2 nl4 b0_n vdd vdd sky130_fd_pr__pfet_01v8 W=1.74 L=0.3
Xdg4_n1 nl4 b1_n dg4_mid vss sky130_fd_pr__nfet_01v8 W=0.42 L=0.3
Xdg4_n2 dg4_mid b0_n vss vss sky130_fd_pr__nfet_01v8 W=0.42 L=0.3
Xdinv4_n seln4 sel4 vss vss sky130_fd_pr__nfet_01v8 W=0.42 L=0.3
Xdinv4_p seln4 sel4 vdd vdd sky130_fd_pr__pfet_01v8 W=1.74 L=0.3
Xdh5_p1 nh5 b3_n vdd vdd sky130_fd_pr__pfet_01v8 W=1.74 L=0.3
Xdh5_p2 nh5 b2 vdd vdd sky130_fd_pr__pfet_01v8 W=1.74 L=0.3
Xdh5_n1 nh5 b3_n dh5_mid vss sky130_fd_pr__nfet_01v8 W=0.42 L=0.3
Xdh5_n2 dh5_mid b2 vss vss sky130_fd_pr__nfet_01v8 W=0.42 L=0.3
Xdl5_p1 sel5 nh5 dl5_mid vdd sky130_fd_pr__pfet_01v8 W=1.74 L=0.3
Xdl5_p2 dl5_mid nl5 vdd vdd sky130_fd_pr__pfet_01v8 W=1.74 L=0.3
Xdl5_n1 sel5 nh5 vss vss sky130_fd_pr__nfet_01v8 W=0.42 L=0.3
Xdl5_n2 sel5 nl5 vss vss sky130_fd_pr__nfet_01v8 W=0.42 L=0.3
Xdg5_p1 nl5 b1_n vdd vdd sky130_fd_pr__pfet_01v8 W=1.74 L=0.3
Xdg5_p2 nl5 b0 vdd vdd sky130_fd_pr__pfet_01v8 W=1.74 L=0.3
Xdg5_n1 nl5 b1_n dg5_mid vss sky130_fd_pr__nfet_01v8 W=0.42 L=0.3
Xdg5_n2 dg5_mid b0 vss vss sky130_fd_pr__nfet_01v8 W=0.42 L=0.3
Xdinv5_n seln5 sel5 vss vss sky130_fd_pr__nfet_01v8 W=0.42 L=0.3
Xdinv5_p seln5 sel5 vdd vdd sky130_fd_pr__pfet_01v8 W=1.74 L=0.3
Xdh6_p1 nh6 b3_n vdd vdd sky130_fd_pr__pfet_01v8 W=1.74 L=0.3
Xdh6_p2 nh6 b2 vdd vdd sky130_fd_pr__pfet_01v8 W=1.74 L=0.3
Xdh6_n1 nh6 b3_n dh6_mid vss sky130_fd_pr__nfet_01v8 W=0.42 L=0.3
Xdh6_n2 dh6_mid b2 vss vss sky130_fd_pr__nfet_01v8 W=0.42 L=0.3
Xdl6_p1 sel6 nh6 dl6_mid vdd sky130_fd_pr__pfet_01v8 W=1.74 L=0.3
Xdl6_p2 dl6_mid nl6 vdd vdd sky130_fd_pr__pfet_01v8 W=1.74 L=0.3
Xdl6_n1 sel6 nh6 vss vss sky130_fd_pr__nfet_01v8 W=0.42 L=0.3
Xdl6_n2 sel6 nl6 vss vss sky130_fd_pr__nfet_01v8 W=0.42 L=0.3
Xdg6_p1 nl6 b1 vdd vdd sky130_fd_pr__pfet_01v8 W=1.74 L=0.3
Xdg6_p2 nl6 b0_n vdd vdd sky130_fd_pr__pfet_01v8 W=1.74 L=0.3
Xdg6_n1 nl6 b1 dg6_mid vss sky130_fd_pr__nfet_01v8 W=0.42 L=0.3
Xdg6_n2 dg6_mid b0_n vss vss sky130_fd_pr__nfet_01v8 W=0.42 L=0.3
Xdinv6_n seln6 sel6 vss vss sky130_fd_pr__nfet_01v8 W=0.42 L=0.3
Xdinv6_p seln6 sel6 vdd vdd sky130_fd_pr__pfet_01v8 W=1.74 L=0.3
Xdh7_p1 nh7 b3_n vdd vdd sky130_fd_pr__pfet_01v8 W=1.74 L=0.3
Xdh7_p2 nh7 b2 vdd vdd sky130_fd_pr__pfet_01v8 W=1.74 L=0.3
Xdh7_n1 nh7 b3_n dh7_mid vss sky130_fd_pr__nfet_01v8 W=0.42 L=0.3
Xdh7_n2 dh7_mid b2 vss vss sky130_fd_pr__nfet_01v8 W=0.42 L=0.3
Xdl7_p1 sel7 nh7 dl7_mid vdd sky130_fd_pr__pfet_01v8 W=1.74 L=0.3
Xdl7_p2 dl7_mid nl7 vdd vdd sky130_fd_pr__pfet_01v8 W=1.74 L=0.3
Xdl7_n1 sel7 nh7 vss vss sky130_fd_pr__nfet_01v8 W=0.42 L=0.3
Xdl7_n2 sel7 nl7 vss vss sky130_fd_pr__nfet_01v8 W=0.42 L=0.3
Xdg7_p1 nl7 b1 vdd vdd sky130_fd_pr__pfet_01v8 W=1.74 L=0.3
Xdg7_p2 nl7 b0 vdd vdd sky130_fd_pr__pfet_01v8 W=1.74 L=0.3
Xdg7_n1 nl7 b1 dg7_mid vss sky130_fd_pr__nfet_01v8 W=0.42 L=0.3
Xdg7_n2 dg7_mid b0 vss vss sky130_fd_pr__nfet_01v8 W=0.42 L=0.3
Xdinv7_n seln7 sel7 vss vss sky130_fd_pr__nfet_01v8 W=0.42 L=0.3
Xdinv7_p seln7 sel7 vdd vdd sky130_fd_pr__pfet_01v8 W=1.74 L=0.3
Xdh8_p1 nh8 b3 vdd vdd sky130_fd_pr__pfet_01v8 W=1.74 L=0.3
Xdh8_p2 nh8 b2_n vdd vdd sky130_fd_pr__pfet_01v8 W=1.74 L=0.3
Xdh8_n1 nh8 b3 dh8_mid vss sky130_fd_pr__nfet_01v8 W=0.42 L=0.3
Xdh8_n2 dh8_mid b2_n vss vss sky130_fd_pr__nfet_01v8 W=0.42 L=0.3
Xdl8_p1 sel8 nh8 dl8_mid vdd sky130_fd_pr__pfet_01v8 W=1.74 L=0.3
Xdl8_p2 dl8_mid nl8 vdd vdd sky130_fd_pr__pfet_01v8 W=1.74 L=0.3
Xdl8_n1 sel8 nh8 vss vss sky130_fd_pr__nfet_01v8 W=0.42 L=0.3
Xdl8_n2 sel8 nl8 vss vss sky130_fd_pr__nfet_01v8 W=0.42 L=0.3
Xdg8_p1 nl8 b1_n vdd vdd sky130_fd_pr__pfet_01v8 W=1.74 L=0.3
Xdg8_p2 nl8 b0_n vdd vdd sky130_fd_pr__pfet_01v8 W=1.74 L=0.3
Xdg8_n1 nl8 b1_n dg8_mid vss sky130_fd_pr__nfet_01v8 W=0.42 L=0.3
Xdg8_n2 dg8_mid b0_n vss vss sky130_fd_pr__nfet_01v8 W=0.42 L=0.3
Xdinv8_n seln8 sel8 vss vss sky130_fd_pr__nfet_01v8 W=0.42 L=0.3
Xdinv8_p seln8 sel8 vdd vdd sky130_fd_pr__pfet_01v8 W=1.74 L=0.3
Xdh9_p1 nh9 b3 vdd vdd sky130_fd_pr__pfet_01v8 W=1.74 L=0.3
Xdh9_p2 nh9 b2_n vdd vdd sky130_fd_pr__pfet_01v8 W=1.74 L=0.3
Xdh9_n1 nh9 b3 dh9_mid vss sky130_fd_pr__nfet_01v8 W=0.42 L=0.3
Xdh9_n2 dh9_mid b2_n vss vss sky130_fd_pr__nfet_01v8 W=0.42 L=0.3
Xdl9_p1 sel9 nh9 dl9_mid vdd sky130_fd_pr__pfet_01v8 W=1.74 L=0.3
Xdl9_p2 dl9_mid nl9 vdd vdd sky130_fd_pr__pfet_01v8 W=1.74 L=0.3
Xdl9_n1 sel9 nh9 vss vss sky130_fd_pr__nfet_01v8 W=0.42 L=0.3
Xdl9_n2 sel9 nl9 vss vss sky130_fd_pr__nfet_01v8 W=0.42 L=0.3
Xdg9_p1 nl9 b1_n vdd vdd sky130_fd_pr__pfet_01v8 W=1.74 L=0.3
Xdg9_p2 nl9 b0 vdd vdd sky130_fd_pr__pfet_01v8 W=1.74 L=0.3
Xdg9_n1 nl9 b1_n dg9_mid vss sky130_fd_pr__nfet_01v8 W=0.42 L=0.3
Xdg9_n2 dg9_mid b0 vss vss sky130_fd_pr__nfet_01v8 W=0.42 L=0.3
Xdinv9_n seln9 sel9 vss vss sky130_fd_pr__nfet_01v8 W=0.42 L=0.3
Xdinv9_p seln9 sel9 vdd vdd sky130_fd_pr__pfet_01v8 W=1.74 L=0.3
Xdh10_p1 nh10 b3 vdd vdd sky130_fd_pr__pfet_01v8 W=1.74 L=0.3
Xdh10_p2 nh10 b2_n vdd vdd sky130_fd_pr__pfet_01v8 W=1.74 L=0.3
Xdh10_n1 nh10 b3 dh10_mid vss sky130_fd_pr__nfet_01v8 W=0.42 L=0.3
Xdh10_n2 dh10_mid b2_n vss vss sky130_fd_pr__nfet_01v8 W=0.42 L=0.3
Xdl10_p1 sel10 nh10 dl10_mid vdd sky130_fd_pr__pfet_01v8 W=1.74 L=0.3
Xdl10_p2 dl10_mid nl10 vdd vdd sky130_fd_pr__pfet_01v8 W=1.74 L=0.3
Xdl10_n1 sel10 nh10 vss vss sky130_fd_pr__nfet_01v8 W=0.42 L=0.3
Xdl10_n2 sel10 nl10 vss vss sky130_fd_pr__nfet_01v8 W=0.42 L=0.3
Xdg10_p1 nl10 b1 vdd vdd sky130_fd_pr__pfet_01v8 W=1.74 L=0.3
Xdg10_p2 nl10 b0_n vdd vdd sky130_fd_pr__pfet_01v8 W=1.74 L=0.3
Xdg10_n1 nl10 b1 dg10_mid vss sky130_fd_pr__nfet_01v8 W=0.42 L=0.3
Xdg10_n2 dg10_mid b0_n vss vss sky130_fd_pr__nfet_01v8 W=0.42 L=0.3
Xdinv10_n seln10 sel10 vss vss sky130_fd_pr__nfet_01v8 W=0.42 L=0.3
Xdinv10_p seln10 sel10 vdd vdd sky130_fd_pr__pfet_01v8 W=1.74 L=0.3
Xdh11_p1 nh11 b3 vdd vdd sky130_fd_pr__pfet_01v8 W=1.74 L=0.3
Xdh11_p2 nh11 b2_n vdd vdd sky130_fd_pr__pfet_01v8 W=1.74 L=0.3
Xdh11_n1 nh11 b3 dh11_mid vss sky130_fd_pr__nfet_01v8 W=0.42 L=0.3
Xdh11_n2 dh11_mid b2_n vss vss sky130_fd_pr__nfet_01v8 W=0.42 L=0.3
Xdl11_p1 sel11 nh11 dl11_mid vdd sky130_fd_pr__pfet_01v8 W=1.74 L=0.3
Xdl11_p2 dl11_mid nl11 vdd vdd sky130_fd_pr__pfet_01v8 W=1.74 L=0.3
Xdl11_n1 sel11 nh11 vss vss sky130_fd_pr__nfet_01v8 W=0.42 L=0.3
Xdl11_n2 sel11 nl11 vss vss sky130_fd_pr__nfet_01v8 W=0.42 L=0.3
Xdg11_p1 nl11 b1 vdd vdd sky130_fd_pr__pfet_01v8 W=1.74 L=0.3
Xdg11_p2 nl11 b0 vdd vdd sky130_fd_pr__pfet_01v8 W=1.74 L=0.3
Xdg11_n1 nl11 b1 dg11_mid vss sky130_fd_pr__nfet_01v8 W=0.42 L=0.3
Xdg11_n2 dg11_mid b0 vss vss sky130_fd_pr__nfet_01v8 W=0.42 L=0.3
Xdinv11_n seln11 sel11 vss vss sky130_fd_pr__nfet_01v8 W=0.42 L=0.3
Xdinv11_p seln11 sel11 vdd vdd sky130_fd_pr__pfet_01v8 W=1.74 L=0.3
Xdh12_p1 nh12 b3 vdd vdd sky130_fd_pr__pfet_01v8 W=1.74 L=0.3
Xdh12_p2 nh12 b2 vdd vdd sky130_fd_pr__pfet_01v8 W=1.74 L=0.3
Xdh12_n1 nh12 b3 dh12_mid vss sky130_fd_pr__nfet_01v8 W=0.42 L=0.3
Xdh12_n2 dh12_mid b2 vss vss sky130_fd_pr__nfet_01v8 W=0.42 L=0.3
Xdl12_p1 sel12 nh12 dl12_mid vdd sky130_fd_pr__pfet_01v8 W=1.74 L=0.3
Xdl12_p2 dl12_mid nl12 vdd vdd sky130_fd_pr__pfet_01v8 W=1.74 L=0.3
Xdl12_n1 sel12 nh12 vss vss sky130_fd_pr__nfet_01v8 W=0.42 L=0.3
Xdl12_n2 sel12 nl12 vss vss sky130_fd_pr__nfet_01v8 W=0.42 L=0.3
Xdg12_p1 nl12 b1_n vdd vdd sky130_fd_pr__pfet_01v8 W=1.74 L=0.3
Xdg12_p2 nl12 b0_n vdd vdd sky130_fd_pr__pfet_01v8 W=1.74 L=0.3
Xdg12_n1 nl12 b1_n dg12_mid vss sky130_fd_pr__nfet_01v8 W=0.42 L=0.3
Xdg12_n2 dg12_mid b0_n vss vss sky130_fd_pr__nfet_01v8 W=0.42 L=0.3
Xdinv12_n seln12 sel12 vss vss sky130_fd_pr__nfet_01v8 W=0.42 L=0.3
Xdinv12_p seln12 sel12 vdd vdd sky130_fd_pr__pfet_01v8 W=1.74 L=0.3
Xdh13_p1 nh13 b3 vdd vdd sky130_fd_pr__pfet_01v8 W=1.74 L=0.3
Xdh13_p2 nh13 b2 vdd vdd sky130_fd_pr__pfet_01v8 W=1.74 L=0.3
Xdh13_n1 nh13 b3 dh13_mid vss sky130_fd_pr__nfet_01v8 W=0.42 L=0.3
Xdh13_n2 dh13_mid b2 vss vss sky130_fd_pr__nfet_01v8 W=0.42 L=0.3
Xdl13_p1 sel13 nh13 dl13_mid vdd sky130_fd_pr__pfet_01v8 W=1.74 L=0.3
Xdl13_p2 dl13_mid nl13 vdd vdd sky130_fd_pr__pfet_01v8 W=1.74 L=0.3
Xdl13_n1 sel13 nh13 vss vss sky130_fd_pr__nfet_01v8 W=0.42 L=0.3
Xdl13_n2 sel13 nl13 vss vss sky130_fd_pr__nfet_01v8 W=0.42 L=0.3
Xdg13_p1 nl13 b1_n vdd vdd sky130_fd_pr__pfet_01v8 W=1.74 L=0.3
Xdg13_p2 nl13 b0 vdd vdd sky130_fd_pr__pfet_01v8 W=1.74 L=0.3
Xdg13_n1 nl13 b1_n dg13_mid vss sky130_fd_pr__nfet_01v8 W=0.42 L=0.3
Xdg13_n2 dg13_mid b0 vss vss sky130_fd_pr__nfet_01v8 W=0.42 L=0.3
Xdinv13_n seln13 sel13 vss vss sky130_fd_pr__nfet_01v8 W=0.42 L=0.3
Xdinv13_p seln13 sel13 vdd vdd sky130_fd_pr__pfet_01v8 W=1.74 L=0.3
Xdh14_p1 nh14 b3 vdd vdd sky130_fd_pr__pfet_01v8 W=1.74 L=0.3
Xdh14_p2 nh14 b2 vdd vdd sky130_fd_pr__pfet_01v8 W=1.74 L=0.3
Xdh14_n1 nh14 b3 dh14_mid vss sky130_fd_pr__nfet_01v8 W=0.42 L=0.3
Xdh14_n2 dh14_mid b2 vss vss sky130_fd_pr__nfet_01v8 W=0.42 L=0.3
Xdl14_p1 sel14 nh14 dl14_mid vdd sky130_fd_pr__pfet_01v8 W=1.74 L=0.3
Xdl14_p2 dl14_mid nl14 vdd vdd sky130_fd_pr__pfet_01v8 W=1.74 L=0.3
Xdl14_n1 sel14 nh14 vss vss sky130_fd_pr__nfet_01v8 W=0.42 L=0.3
Xdl14_n2 sel14 nl14 vss vss sky130_fd_pr__nfet_01v8 W=0.42 L=0.3
Xdg14_p1 nl14 b1 vdd vdd sky130_fd_pr__pfet_01v8 W=1.74 L=0.3
Xdg14_p2 nl14 b0_n vdd vdd sky130_fd_pr__pfet_01v8 W=1.74 L=0.3
Xdg14_n1 nl14 b1 dg14_mid vss sky130_fd_pr__nfet_01v8 W=0.42 L=0.3
Xdg14_n2 dg14_mid b0_n vss vss sky130_fd_pr__nfet_01v8 W=0.42 L=0.3
Xdinv14_n seln14 sel14 vss vss sky130_fd_pr__nfet_01v8 W=0.42 L=0.3
Xdinv14_p seln14 sel14 vdd vdd sky130_fd_pr__pfet_01v8 W=1.74 L=0.3
Xdh15_p1 nh15 b3 vdd vdd sky130_fd_pr__pfet_01v8 W=1.74 L=0.3
Xdh15_p2 nh15 b2 vdd vdd sky130_fd_pr__pfet_01v8 W=1.74 L=0.3
Xdh15_n1 nh15 b3 dh15_mid vss sky130_fd_pr__nfet_01v8 W=0.42 L=0.3
Xdh15_n2 dh15_mid b2 vss vss sky130_fd_pr__nfet_01v8 W=0.42 L=0.3
Xdl15_p1 sel15 nh15 dl15_mid vdd sky130_fd_pr__pfet_01v8 W=1.74 L=0.3
Xdl15_p2 dl15_mid nl15 vdd vdd sky130_fd_pr__pfet_01v8 W=1.74 L=0.3
Xdl15_n1 sel15 nh15 vss vss sky130_fd_pr__nfet_01v8 W=0.42 L=0.3
Xdl15_n2 sel15 nl15 vss vss sky130_fd_pr__nfet_01v8 W=0.42 L=0.3
Xdg15_p1 nl15 b1 vdd vdd sky130_fd_pr__pfet_01v8 W=1.74 L=0.3
Xdg15_p2 nl15 b0 vdd vdd sky130_fd_pr__pfet_01v8 W=1.74 L=0.3
Xdg15_n1 nl15 b1 dg15_mid vss sky130_fd_pr__nfet_01v8 W=0.42 L=0.3
Xdg15_n2 dg15_mid b0 vss vss sky130_fd_pr__nfet_01v8 W=0.42 L=0.3
Xdinv15_n seln15 sel15 vss vss sky130_fd_pr__nfet_01v8 W=0.42 L=0.3
Xdinv15_p seln15 sel15 vdd vdd sky130_fd_pr__pfet_01v8 W=1.74 L=0.3
.ends lora_sidecar_dac

.subckt lora_sidecar_ota inp inn out vb_nc vb_pc vb_tail vdd vss
Xtail ts vb_tail vss vss sky130_fd_pr__nfet_01v8 W=6.99 L=0.5
Xin_p d1 inp ts vss sky130_fd_pr__nfet_01v8 W=0.54 L=0.3
Xin_n d2 inn ts vss sky130_fd_pr__nfet_01v8 W=0.54 L=0.3
Xnc_l x1 vb_nc d1 vss sky130_fd_pr__nfet_01v8 W=0.42 L=0.3
Xnc_r out vb_nc d2 vss sky130_fd_pr__nfet_01v8 W=0.42 L=0.3
Xpc_l x1 vb_pc y1 vdd sky130_fd_pr__pfet_01v8 W=2.61 L=0.5
Xpc_r out vb_pc y2 vdd sky130_fd_pr__pfet_01v8 W=2.61 L=0.5
Xpm_l y1 x1 vdd vdd sky130_fd_pr__pfet_01v8 W=2.61 L=0.5
Xpm_r y2 x1 vdd vdd sky130_fd_pr__pfet_01v8 W=2.61 L=0.5
.ends lora_sidecar_ota

.subckt lora_sidecar_wsw in_ out ctrl ctrl_b vdd vss
Xlora_sidecar_wsw_n in_ ctrl out vss sky130_fd_pr__nfet_01v8 W=0.58 L=0.15
Xlora_sidecar_wsw_p in_ ctrl_b out vdd sky130_fd_pr__pfet_01v8 W=0.42 L=0.15
.ends lora_sidecar_wsw

.subckt lora_sidecar_sw in_ out ctrl ctrl_b vdd vss
Xlora_sidecar_sw_n in_ ctrl out vss sky130_fd_pr__nfet_01v8 W=0.42 L=0.15
Xlora_sidecar_sw_p in_ ctrl_b out vdd sky130_fd_pr__pfet_01v8 W=0.42 L=0.15
.ends lora_sidecar_sw

.subckt lora_sidecar_rsw in_ out ctrl ctrl_b vdd vss
Xlora_sidecar_rsw_n in_ ctrl out vss sky130_fd_pr__nfet_01v8 W=0.42 L=0.15
Xlora_sidecar_rsw_p in_ ctrl_b out vdd sky130_fd_pr__pfet_01v8 W=0.42 L=0.15
.ends lora_sidecar_rsw

.subckt lora_sidecar_rstsw in_ out ctrl ctrl_b vdd vss
Xlora_sidecar_rstsw_n in_ ctrl out vss sky130_fd_pr__nfet_01v8 W=3.36 L=0.15
Xlora_sidecar_rstsw_p in_ ctrl_b out vdd sky130_fd_pr__pfet_01v8 W=10.08 L=0.15
.ends lora_sidecar_rstsw

.subckt lora_sidecar_arow xen xneg wsel wdp wdn colp coln vcm vdd vss
Xap wdp wsel vss d_ap vss lora_sidecar_cell
Xap_s d_ap colp ep ep_b vdd vss lora_sidecar_sw
Xap_x d_ap coln en en_b vdd vss lora_sidecar_sw
Xap_d d_ap vcm xen_b xen vdd vss lora_sidecar_sw
Xan wdn wsel vss d_an vss lora_sidecar_cell
Xan_s d_an coln ep ep_b vdd vss lora_sidecar_sw
Xan_x d_an colp en en_b vdd vss lora_sidecar_sw
Xan_d d_an vcm xen_b xen vdd vss lora_sidecar_sw
Xixen_n xen_b xen vss vss sky130_fd_pr__nfet_01v8 W=0.42 L=0.15
Xixen_p xen_b xen vdd vdd sky130_fd_pr__pfet_01v8 W=1.16 L=0.15
Xixng_n xneg_b xneg vss vss sky130_fd_pr__nfet_01v8 W=0.42 L=0.15
Xixng_p xneg_b xneg vdd vdd sky130_fd_pr__pfet_01v8 W=1.16 L=0.15
Xnep_p0 nep_m0 xen_b vdd vdd sky130_fd_pr__pfet_01v8 W=2.32 L=0.15
Xnep_n0 ep xen_b vss vss sky130_fd_pr__nfet_01v8 W=0.42 L=0.15
Xnep_p1 ep xneg nep_m0 vdd sky130_fd_pr__pfet_01v8 W=2.32 L=0.15
Xnep_n1 ep xneg vss vss sky130_fd_pr__nfet_01v8 W=0.42 L=0.15
Xnen_p0 nen_m0 xen_b vdd vdd sky130_fd_pr__pfet_01v8 W=2.32 L=0.15
Xnen_n0 en xen_b vss vss sky130_fd_pr__nfet_01v8 W=0.42 L=0.15
Xnen_p1 en xneg_b nen_m0 vdd sky130_fd_pr__pfet_01v8 W=2.32 L=0.15
Xnen_n1 en xneg_b vss vss sky130_fd_pr__nfet_01v8 W=0.42 L=0.15
Xiep_n ep_b ep vss vss sky130_fd_pr__nfet_01v8 W=0.42 L=0.15
Xiep_p ep_b ep vdd vdd sky130_fd_pr__pfet_01v8 W=1.16 L=0.15
Xien_n en_b en vss vss sky130_fd_pr__nfet_01v8 W=0.42 L=0.15
Xien_p en_b en vdd vdd sky130_fd_pr__pfet_01v8 W=1.16 L=0.15
.ends lora_sidecar_arow

.subckt lora_sidecar_bcol wsel wdp wdn colb pos pos_b neg neg_b vcm vb_tail vdd vss
Xbpd wdp wsel vss n_pos vss lora_sidecar_cell
Xbnm wdn wsel vss m_bnm vss lora_sidecar_cell
Xpos_c n_pos colb pos pos_b vdd vss lora_sidecar_sw
Xpos_d n_pos vcm pos_b pos vdd vss lora_sidecar_sw
Xbnd wdn wsel vss n_neg vss lora_sidecar_cell
Xbpm wdp wsel vss m_bpm vss lora_sidecar_cell
Xneg_c n_neg colb neg neg_b vdd vss lora_sidecar_sw
Xneg_d n_neg vcm neg_b neg vdd vss lora_sidecar_sw
Xbnm_md m_bnm m_bnm vdd vdd sky130_fd_pr__pfet_01v8 W=3.65 L=9.6
Xbnm_mo n_pos m_bnm vdd vdd sky130_fd_pr__pfet_01v8 W=3.65 L=9.6
Xbnm_bi m_bnm vb_tail vss vss sky130_fd_pr__nfet_01v8 W=0.52 L=28.8
Xbnm_bo n_pos vb_tail vss vss sky130_fd_pr__nfet_01v8 W=0.52 L=28.8
Xbpm_md m_bpm m_bpm vdd vdd sky130_fd_pr__pfet_01v8 W=3.65 L=9.6
Xbpm_mo n_neg m_bpm vdd vdd sky130_fd_pr__pfet_01v8 W=3.65 L=9.6
Xbpm_bi m_bpm vb_tail vss vss sky130_fd_pr__nfet_01v8 W=0.52 L=28.8
Xbpm_bo n_neg vb_tail vss vss sky130_fd_pr__nfet_01v8 W=0.52 L=28.8
.ends lora_sidecar_bcol

.subckt lora_sidecar_wbus d0 d1 d2 d3 wdp wdn vref vdd vss
Xdac d0 d1 d2 nz dac vref vdd vss lora_sidecar_dac
Xtp dac wdp d3_b d3 vdd vss lora_sidecar_wsw
Xtn dac wdn d3 d3_b vdd vss lora_sidecar_wsw
Xnor3_p0 nor3_m0 d0 vdd vdd sky130_fd_pr__pfet_01v8 W=3.48 L=0.15
Xnor3_n0 nz_b d0 vss vss sky130_fd_pr__nfet_01v8 W=0.42 L=0.15
Xnor3_p1 nor3_m1 d1 nor3_m0 vdd sky130_fd_pr__pfet_01v8 W=3.48 L=0.15
Xnor3_n1 nz_b d1 vss vss sky130_fd_pr__nfet_01v8 W=0.42 L=0.15
Xnor3_p2 nz_b d2 nor3_m1 vdd sky130_fd_pr__pfet_01v8 W=3.48 L=0.15
Xnor3_n2 nz_b d2 vss vss sky130_fd_pr__nfet_01v8 W=0.42 L=0.15
Xinz_n nz nz_b vss vss sky130_fd_pr__nfet_01v8 W=0.42 L=0.15
Xinz_p nz nz_b vdd vdd sky130_fd_pr__pfet_01v8 W=1.16 L=0.15
Xisg_n d3_b d3 vss vss sky130_fd_pr__nfet_01v8 W=0.42 L=0.15
Xisg_p d3_b d3 vdd vdd sky130_fd_pr__pfet_01v8 W=1.16 L=0.15
Xgp wdp d3 vss vss sky130_fd_pr__nfet_01v8 W=0.42 L=0.15
Xgn wdn d3_b vss vss sky130_fd_pr__nfet_01v8 W=0.42 L=0.15
.ends lora_sidecar_wbus

.subckt lora_sidecar_vt colp coln rst ramp_en vaxp vaxn pos pos_b neg neg_b vcm vb_ramp vb_nc vb_pc vb_tail vdd vss
Xintp vcm colp vaxp vb_nc vb_pc vb_tail vdd vss lora_sidecar_ota
Xrsp colp vaxp rst rst_b vdd vss lora_sidecar_rstsw
Xcmpp vth vaxp cop vb_nc vb_pc vb_tail vdd vss lora_sidecar_ota
Xrcp rp colp renp renp_b vdd vss lora_sidecar_rsw
Xrdp rp vcm renp_b renp vdd vss lora_sidecar_rsw
Xintn vcm coln vaxn vb_nc vb_pc vb_tail vdd vss lora_sidecar_ota
Xrsn coln vaxn rst rst_b vdd vss lora_sidecar_rstsw
Xcmpn vth vaxn con vb_nc vb_pc vb_tail vdd vss lora_sidecar_ota
Xrcn rn coln renn renn_b vdd vss lora_sidecar_rsw
Xrdn rn vcm renn_b renn vdd vss lora_sidecar_rsw
Xirst_n rst_b rst vss vss sky130_fd_pr__nfet_01v8 W=0.42 L=0.15
Xirst_p rst_b rst vdd vdd sky130_fd_pr__pfet_01v8 W=1.16 L=0.15
Xcintp colp vaxp sky130_fd_pr__cap_mim_m3_1 W=21.04 L=21.04
Xic1p_n cpb cop vss vss sky130_fd_pr__nfet_01v8 W=0.42 L=0.15
Xic1p_p cpb cop vdd vdd sky130_fd_pr__pfet_01v8 W=1.16 L=0.15
Xic2p_n cp cpb vss vss sky130_fd_pr__nfet_01v8 W=0.42 L=0.15
Xic2p_p cp cpb vdd vdd sky130_fd_pr__pfet_01v8 W=1.16 L=0.15
Xrampp rp vb_ramp vdd vdd sky130_fd_pr__pfet_01v8 W=7.02 L=7.2
Xnrp_n0 nrp_m0 ramp_en vss vss sky130_fd_pr__nfet_01v8 W=0.84 L=0.15
Xnrp_p0 renp_b ramp_en vdd vdd sky130_fd_pr__pfet_01v8 W=1.16 L=0.15
Xnrp_n1 renp_b cpb nrp_m0 vss sky130_fd_pr__nfet_01v8 W=0.84 L=0.15
Xnrp_p1 renp_b cpb vdd vdd sky130_fd_pr__pfet_01v8 W=1.16 L=0.15
Xirp_n renp renp_b vss vss sky130_fd_pr__nfet_01v8 W=0.42 L=0.15
Xirp_p renp renp_b vdd vdd sky130_fd_pr__pfet_01v8 W=1.16 L=0.15
Xcintn coln vaxn sky130_fd_pr__cap_mim_m3_1 W=21.04 L=21.04
Xic1n_n cnb con vss vss sky130_fd_pr__nfet_01v8 W=0.42 L=0.15
Xic1n_p cnb con vdd vdd sky130_fd_pr__pfet_01v8 W=1.16 L=0.15
Xic2n_n cn cnb vss vss sky130_fd_pr__nfet_01v8 W=0.42 L=0.15
Xic2n_p cn cnb vdd vdd sky130_fd_pr__pfet_01v8 W=1.16 L=0.15
Xrampn rn vb_ramp vdd vdd sky130_fd_pr__pfet_01v8 W=7.02 L=7.2
Xnrn_n0 nrn_m0 ramp_en vss vss sky130_fd_pr__nfet_01v8 W=0.84 L=0.15
Xnrn_p0 renn_b ramp_en vdd vdd sky130_fd_pr__pfet_01v8 W=1.16 L=0.15
Xnrn_n1 renn_b cnb nrn_m0 vss sky130_fd_pr__nfet_01v8 W=0.84 L=0.15
Xnrn_p1 renn_b cnb vdd vdd sky130_fd_pr__pfet_01v8 W=1.16 L=0.15
Xirn_n renn renn_b vss vss sky130_fd_pr__nfet_01v8 W=0.42 L=0.15
Xirn_p renn renn_b vdd vdd sky130_fd_pr__pfet_01v8 W=1.16 L=0.15
Xrtop vcm vth vss sky130_fd_pr__res_xhigh_po_0p35 L=1.65
Xrbot vth vss vss sky130_fd_pr__res_xhigh_po_0p35 L=24.34
Xcth vth vss sky130_fd_pr__cap_mim_m3_1 W=21.04 L=21.04
Xnpos_n0 npos_m0 ramp_en vss vss sky130_fd_pr__nfet_01v8 W=1.26 L=0.15
Xnpos_p0 pos0_b ramp_en vdd vdd sky130_fd_pr__pfet_01v8 W=1.16 L=0.15
Xnpos_n1 npos_m1 cn npos_m0 vss sky130_fd_pr__nfet_01v8 W=1.26 L=0.15
Xnpos_p1 pos0_b cn vdd vdd sky130_fd_pr__pfet_01v8 W=1.16 L=0.15
Xnpos_n2 pos0_b cpb npos_m1 vss sky130_fd_pr__nfet_01v8 W=1.26 L=0.15
Xnpos_p2 pos0_b cpb vdd vdd sky130_fd_pr__pfet_01v8 W=1.16 L=0.15
Xnneg_n0 nneg_m0 ramp_en vss vss sky130_fd_pr__nfet_01v8 W=1.26 L=0.15
Xnneg_p0 neg0_b ramp_en vdd vdd sky130_fd_pr__pfet_01v8 W=1.16 L=0.15
Xnneg_n1 nneg_m1 cp nneg_m0 vss sky130_fd_pr__nfet_01v8 W=1.26 L=0.15
Xnneg_p1 neg0_b cp vdd vdd sky130_fd_pr__pfet_01v8 W=1.16 L=0.15
Xnneg_n2 neg0_b cnb nneg_m1 vss sky130_fd_pr__nfet_01v8 W=1.26 L=0.15
Xnneg_p2 neg0_b cnb vdd vdd sky130_fd_pr__pfet_01v8 W=1.16 L=0.15
Xbpos_1_n bpos_a1 pos0_b vss vss sky130_fd_pr__nfet_01v8 W=0.866174 L=0.15
Xbpos_1_p bpos_a1 pos0_b vdd vdd sky130_fd_pr__pfet_01v8 W=2.39229 L=0.15
Xbpos_2_n bpos_a2 bpos_a1 vss vss sky130_fd_pr__nfet_01v8 W=0.866174 L=0.15
Xbpos_2_p bpos_a2 bpos_a1 vdd vdd sky130_fd_pr__pfet_01v8 W=2.39229 L=0.15
Xbpos_3_n pos_b bpos_a1 vss vss sky130_fd_pr__nfet_01v8 W=1.78633 L=0.15
Xbpos_3_p pos_b bpos_a1 vdd vdd sky130_fd_pr__pfet_01v8 W=4.93367 L=0.15
Xbpos_4_n pos bpos_a2 vss vss sky130_fd_pr__nfet_01v8 W=1.78633 L=0.15
Xbpos_4_p pos bpos_a2 vdd vdd sky130_fd_pr__pfet_01v8 W=4.93367 L=0.15
Xbneg_1_n bneg_a1 neg0_b vss vss sky130_fd_pr__nfet_01v8 W=0.866174 L=0.15
Xbneg_1_p bneg_a1 neg0_b vdd vdd sky130_fd_pr__pfet_01v8 W=2.39229 L=0.15
Xbneg_2_n bneg_a2 bneg_a1 vss vss sky130_fd_pr__nfet_01v8 W=0.866174 L=0.15
Xbneg_2_p bneg_a2 bneg_a1 vdd vdd sky130_fd_pr__pfet_01v8 W=2.39229 L=0.15
Xbneg_3_n neg_b bneg_a1 vss vss sky130_fd_pr__nfet_01v8 W=1.78633 L=0.15
Xbneg_3_p neg_b bneg_a1 vdd vdd sky130_fd_pr__pfet_01v8 W=4.93367 L=0.15
Xbneg_4_n neg bneg_a2 vss vss sky130_fd_pr__nfet_01v8 W=1.78633 L=0.15
Xbneg_4_p neg bneg_a2 vdd vdd sky130_fd_pr__pfet_01v8 W=4.93367 L=0.15
.ends lora_sidecar_vt

.subckt lora_sidecar xen0 xen1 xen2 xen3 xen4 xen5 xen6 xen7 xen8 xen9 xen10 xen11 xen12 xen13 xen14 xen15 xneg0 xneg1 xneg2 xneg3 xneg4 xneg5 xneg6 xneg7 xneg8 xneg9 xneg10 xneg11 xneg12 xneg13 xneg14 xneg15 colb0 colb1 colb2 colb3 colb4 colb5 colb6 colb7 colb8 colb9 colb10 colb11 colb12 colb13 colb14 colb15 wa_sel0 wa_sel1 wa_sel2 wa_sel3 wa_sel4 wa_sel5 wa_sel6 wa_sel7 wa_sel8 wa_sel9 wa_sel10 wa_sel11 wa_sel12 wa_sel13 wa_sel14 wa_sel15 wb_sel0 wb_sel1 wb_sel2 wb_sel3 wb_sel4 wb_sel5 wb_sel6 wb_sel7 wb_sel8 wb_sel9 wb_sel10 wb_sel11 wb_sel12 wb_sel13 wb_sel14 wb_sel15 da0 da1 da2 da3 db0 db1 db2 db3 rst ramp_en vaxp vaxn vcm vb_ramp vb_nc vb_pc vb_tail vdd vss
Xa0 xen0 xneg0 wa_sel0 wdap wdan colp coln vcm vdd vss lora_sidecar_arow
Xa1 xen1 xneg1 wa_sel1 wdap wdan colp coln vcm vdd vss lora_sidecar_arow
Xa2 xen2 xneg2 wa_sel2 wdap wdan colp coln vcm vdd vss lora_sidecar_arow
Xa3 xen3 xneg3 wa_sel3 wdap wdan colp coln vcm vdd vss lora_sidecar_arow
Xa4 xen4 xneg4 wa_sel4 wdap wdan colp coln vcm vdd vss lora_sidecar_arow
Xa5 xen5 xneg5 wa_sel5 wdap wdan colp coln vcm vdd vss lora_sidecar_arow
Xa6 xen6 xneg6 wa_sel6 wdap wdan colp coln vcm vdd vss lora_sidecar_arow
Xa7 xen7 xneg7 wa_sel7 wdap wdan colp coln vcm vdd vss lora_sidecar_arow
Xa8 xen8 xneg8 wa_sel8 wdap wdan colp coln vcm vdd vss lora_sidecar_arow
Xa9 xen9 xneg9 wa_sel9 wdap wdan colp coln vcm vdd vss lora_sidecar_arow
Xa10 xen10 xneg10 wa_sel10 wdap wdan colp coln vcm vdd vss lora_sidecar_arow
Xa11 xen11 xneg11 wa_sel11 wdap wdan colp coln vcm vdd vss lora_sidecar_arow
Xa12 xen12 xneg12 wa_sel12 wdap wdan colp coln vcm vdd vss lora_sidecar_arow
Xa13 xen13 xneg13 wa_sel13 wdap wdan colp coln vcm vdd vss lora_sidecar_arow
Xa14 xen14 xneg14 wa_sel14 wdap wdan colp coln vcm vdd vss lora_sidecar_arow
Xa15 xen15 xneg15 wa_sel15 wdap wdan colp coln vcm vdd vss lora_sidecar_arow
Xb0 wb_sel0 wdbp wdbn colb0 pos pos_b neg neg_b vcm vb_tail vdd vss lora_sidecar_bcol
Xb1 wb_sel1 wdbp wdbn colb1 pos pos_b neg neg_b vcm vb_tail vdd vss lora_sidecar_bcol
Xb2 wb_sel2 wdbp wdbn colb2 pos pos_b neg neg_b vcm vb_tail vdd vss lora_sidecar_bcol
Xb3 wb_sel3 wdbp wdbn colb3 pos pos_b neg neg_b vcm vb_tail vdd vss lora_sidecar_bcol
Xb4 wb_sel4 wdbp wdbn colb4 pos pos_b neg neg_b vcm vb_tail vdd vss lora_sidecar_bcol
Xb5 wb_sel5 wdbp wdbn colb5 pos pos_b neg neg_b vcm vb_tail vdd vss lora_sidecar_bcol
Xb6 wb_sel6 wdbp wdbn colb6 pos pos_b neg neg_b vcm vb_tail vdd vss lora_sidecar_bcol
Xb7 wb_sel7 wdbp wdbn colb7 pos pos_b neg neg_b vcm vb_tail vdd vss lora_sidecar_bcol
Xb8 wb_sel8 wdbp wdbn colb8 pos pos_b neg neg_b vcm vb_tail vdd vss lora_sidecar_bcol
Xb9 wb_sel9 wdbp wdbn colb9 pos pos_b neg neg_b vcm vb_tail vdd vss lora_sidecar_bcol
Xb10 wb_sel10 wdbp wdbn colb10 pos pos_b neg neg_b vcm vb_tail vdd vss lora_sidecar_bcol
Xb11 wb_sel11 wdbp wdbn colb11 pos pos_b neg neg_b vcm vb_tail vdd vss lora_sidecar_bcol
Xb12 wb_sel12 wdbp wdbn colb12 pos pos_b neg neg_b vcm vb_tail vdd vss lora_sidecar_bcol
Xb13 wb_sel13 wdbp wdbn colb13 pos pos_b neg neg_b vcm vb_tail vdd vss lora_sidecar_bcol
Xb14 wb_sel14 wdbp wdbn colb14 pos pos_b neg neg_b vcm vb_tail vdd vss lora_sidecar_bcol
Xb15 wb_sel15 wdbp wdbn colb15 pos pos_b neg neg_b vcm vb_tail vdd vss lora_sidecar_bcol
Xwa da0 da1 da2 da3 wdap wdan vcm vdd vss lora_sidecar_wbus
Xwb db0 db1 db2 db3 wdbp wdbn vcm vdd vss lora_sidecar_wbus
Xvt colp coln rst ramp_en vaxp vaxn pos pos_b neg neg_b vcm vb_ramp vb_nc vb_pc vb_tail vdd vss lora_sidecar_vt
.ends lora_sidecar
