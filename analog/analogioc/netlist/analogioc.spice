* STUB -- ports-only .subckt analogioc, generated from analogioc.ports (519 pins, same order).
* NOT a circuit: phase 2 (analog top) replaces this file with the real netlist.
* It exists so `macros.py check` can compare the .subckt pins with the Verilog views.
.subckt analogioc
+ seq_rst_n integ_req integ_ack win_hi x_mag<0> x_mag<1> x_mag<2> x_mag<3> x_mag<4> x_mag<5> x_mag<6> x_mag<7>
+ x_mag<8> x_mag<9> x_mag<10> x_mag<11> x_mag<12> x_mag<13> x_mag<14> x_mag<15> x_mag<16> x_mag<17> x_mag<18> x_mag<19>
+ x_mag<20> x_mag<21> x_mag<22> x_mag<23> x_mag<24> x_mag<25> x_mag<26> x_mag<27> x_mag<28> x_mag<29> x_mag<30> x_mag<31>
+ x_mag<32> x_mag<33> x_mag<34> x_mag<35> x_mag<36> x_mag<37> x_mag<38> x_mag<39> x_mag<40> x_mag<41> x_mag<42> x_mag<43>
+ x_mag<44> x_mag<45> x_mag<46> x_mag<47> x_mag<48> x_mag<49> x_mag<50> x_mag<51> x_mag<52> x_mag<53> x_mag<54> x_mag<55>
+ x_mag<56> x_mag<57> x_mag<58> x_mag<59> x_mag<60> x_mag<61> x_mag<62> x_mag<63> x_neg<0> x_neg<1> x_neg<2> x_neg<3>
+ x_neg<4> x_neg<5> x_neg<6> x_neg<7> x_neg<8> x_neg<9> x_neg<10> x_neg<11> x_neg<12> x_neg<13> x_neg<14> x_neg<15>
+ pkt_d<0> pkt_d<1> pkt_d<2> lora_en col_sign<0> col_sign<1> col_sign<2> col_sign<3> col_sign<4> col_sign<5> col_sign<6> col_sign<7>
+ col_sign<8> col_sign<9> col_sign<10> col_sign<11> col_sign<12> col_sign<13> col_sign<14> col_sign<15> col_sign<16> coarse_en<0> coarse_en<1> coarse_en<2>
+ coarse_en<3> coarse_en<4> coarse_en<5> coarse_en<6> coarse_en<7> coarse_en<8> coarse_en<9> coarse_en<10> coarse_en<11> coarse_en<12> coarse_en<13> coarse_en<14>
+ coarse_en<15> coarse_en<16> cb_req<0> cb_req<1> cb_req<2> cb_req<3> cb_req<4> cb_req<5> cb_req<6> cb_req<7> cb_req<8> cb_req<9>
+ cb_req<10> cb_req<11> cb_req<12> cb_req<13> cb_req<14> cb_req<15> cb_req<16> cb_cross<0> cb_cross<1> cb_cross<2> cb_cross<3> cb_cross<4>
+ cb_cross<5> cb_cross<6> cb_cross<7> cb_cross<8> cb_cross<9> cb_cross<10> cb_cross<11> cb_cross<12> cb_cross<13> cb_cross<14> cb_cross<15> cb_cross<16>
+ cb_ack<0> cb_ack<1> cb_ack<2> cb_ack<3> cb_ack<4> cb_ack<5> cb_ack<6> cb_ack<7> cb_ack<8> cb_ack<9> cb_ack<10> cb_ack<11>
+ cb_ack<12> cb_ack<13> cb_ack<14> cb_ack<15> cb_ack<16> cmp_req<0> cmp_req<1> cmp_req<2> cmp_req<3> cmp_req<4> cmp_req<5> cmp_req<6>
+ cmp_req<7> cmp_req<8> cmp_req<9> cmp_req<10> cmp_req<11> cmp_req<12> cmp_req<13> cmp_req<14> cmp_req<15> cmp_req<16> cmp_ack<0> cmp_ack<1>
+ cmp_ack<2> cmp_ack<3> cmp_ack<4> cmp_ack<5> cmp_ack<6> cmp_ack<7> cmp_ack<8> cmp_ack<9> cmp_ack<10> cmp_ack<11> cmp_ack<12> cmp_ack<13>
+ cmp_ack<14> cmp_ack<15> cmp_ack<16> cmp_result<0> cmp_result<1> cmp_result<2> cmp_result<3> cmp_result<4> cmp_result<5> cmp_result<6> cmp_result<7> cmp_result<8>
+ cmp_result<9> cmp_result<10> cmp_result<11> cmp_result<12> cmp_result<13> cmp_result<14> cmp_result<15> cmp_result<16> dac_code<0> dac_code<1> dac_code<2> dac_code<3>
+ dac_code<4> dac_code<5> dac_code<6> dac_code<7> dac_code<8> dac_code<9> dac_code<10> dac_code<11> dac_code<12> dac_code<13> dac_code<14> dac_code<15>
+ dac_code<16> dac_code<17> dac_code<18> dac_code<19> dac_code<20> dac_code<21> dac_code<22> dac_code<23> dac_code<24> dac_code<25> dac_code<26> dac_code<27>
+ dac_code<28> dac_code<29> dac_code<30> dac_code<31> dac_code<32> dac_code<33> dac_code<34> dac_code<35> dac_code<36> dac_code<37> dac_code<38> dac_code<39>
+ dac_code<40> dac_code<41> dac_code<42> dac_code<43> dac_code<44> dac_code<45> dac_code<46> dac_code<47> dac_code<48> dac_code<49> dac_code<50> dac_code<51>
+ dac_code<52> dac_code<53> dac_code<54> dac_code<55> dac_code<56> dac_code<57> dac_code<58> dac_code<59> dac_code<60> dac_code<61> dac_code<62> dac_code<63>
+ dac_code<64> dac_code<65> dac_code<66> dac_code<67> ota_en<0> ota_en<1> ota_en<2> ota_en<3> ota_en<4> ota_en<5> ota_en<6> ota_en<7>
+ ota_en<8> ota_en<9> ota_en<10> ota_en<11> ota_en<12> ota_en<13> ota_en<14> ota_en<15> ota_en<16> lora_wa_sel<0> lora_wa_sel<1> lora_wa_sel<2>
+ lora_wa_sel<3> lora_wa_sel<4> lora_wa_sel<5> lora_wa_sel<6> lora_wa_sel<7> lora_wa_sel<8> lora_wa_sel<9> lora_wa_sel<10> lora_wa_sel<11> lora_wa_sel<12> lora_wa_sel<13> lora_wa_sel<14>
+ lora_wa_sel<15> lora_wb_sel<0> lora_wb_sel<1> lora_wb_sel<2> lora_wb_sel<3> lora_wb_sel<4> lora_wb_sel<5> lora_wb_sel<6> lora_wb_sel<7> lora_wb_sel<8> lora_wb_sel<9> lora_wb_sel<10>
+ lora_wb_sel<11> lora_wb_sel<12> lora_wb_sel<13> lora_wb_sel<14> lora_wb_sel<15> lora_da<0> lora_da<1> lora_da<2> lora_da<3> lora_db<0> lora_db<1> lora_db<2>
+ lora_db<3> w_wl<0> w_wl<1> w_wl<2> w_wl<3> w_wl<4> w_wl<5> w_wl<6> w_wl<7> w_wl<8> w_wl<9> w_wl<10>
+ w_wl<11> w_wl<12> w_wl<13> w_wl<14> w_wl<15> w_data<0> w_data<1> w_data<2> w_data<3> w_data<4> w_data<5> w_data<6>
+ w_data<7> w_data<8> w_data<9> w_data<10> w_data<11> w_data<12> w_data<13> w_data<14> w_data<15> w_data<16> w_data<17> w_data<18>
+ w_data<19> w_data<20> w_data<21> w_data<22> w_data<23> w_data<24> w_data<25> w_data<26> w_data<27> w_data<28> w_data<29> w_data<30>
+ w_data<31> w_data<32> w_data<33> w_data<34> w_data<35> w_data<36> w_data<37> w_data<38> w_data<39> w_data<40> w_data<41> w_data<42>
+ w_data<43> w_data<44> w_data<45> w_data<46> w_data<47> w_data<48> w_data<49> w_data<50> w_data<51> w_data<52> w_data<53> w_data<54>
+ w_data<55> w_data<56> w_data<57> w_data<58> w_data<59> w_data<60> w_data<61> w_data<62> w_data<63> w_data<64> w_data<65> w_data<66>
+ w_data<67> w_data<68> w_data<69> w_data<70> w_data<71> w_data<72> w_data<73> w_data<74> w_data<75> w_data<76> w_data<77> w_data<78>
+ w_data<79> w_data<80> w_data<81> w_data<82> w_data<83> w_data<84> w_data<85> w_data<86> w_data<87> w_data<88> w_data<89> w_data<90>
+ w_data<91> w_data<92> w_data<93> w_data<94> w_data<95> w_data<96> w_data<97> w_data<98> w_data<99> w_data<100> w_data<101> w_data<102>
+ w_data<103> w_data<104> w_data<105> w_data<106> w_data<107> w_data<108> w_data<109> w_data<110> w_data<111> w_data<112> w_data<113> w_data<114>
+ w_data<115> w_data<116> w_data<117> w_data<118> w_data<119> w_data<120> w_data<121> w_data<122> w_data<123> w_data<124> w_data<125> w_data<126>
+ w_data<127> w_data<128> w_data<129> w_data<130> w_data<131> w_data<132> w_data<133> w_data<134> w_data<135> vcm vrn_thrp vrp_thrp
+ vrn_thrn vrp_thrn vrn_sarp vrp_sarp vrn_sarn vrp_sarn vb_nc vb_pc vb_tail vb_ramp vdd vdd_ota
+ vdd_cmp vdd_pkt vss
.ends analogioc
