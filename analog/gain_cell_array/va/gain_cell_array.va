// 8x8 2T gain-cell array — behavioural golden model, ports 1:1 with netlist/gain_cell_array.
// Cell (r, c): write switch wdata<r> -> store s<r>_<c> while wsel<c> is high; storage cap cs;
// read device sinks I_read(store) from col<c> into rd<r> (rd idle at VCM = off, 0 = read).
//
// Continuous form (OpenVAF subset): the write switch is a tanh-gated conductance gon
// (on above vsel) with an off-state leakage gleak; injection is the switch's gate overlap
// cinj coupling wsel onto the store (the charge left when wsel falls with the switch off);
// the read device is an EKV-style forward-minus-reverse law, so it is off at Vds = 0 and
// runs subthreshold -> square law with the stored level.
// ngspice 44 takes at most 18 terminals on an OSDI (N) instance, so this 33-port module
// compiles (OpenVAF) but cannot be instantiated there: DUT=va simulates the same CELL
// law per cell from gain_cell_array_cell.va (keep the two CELL macros identical).
// Not modelled: the write switch's source-follower dead zone near VDD - Vth (the store
// range stops at the 0.9 V write ceiling instead), read-device gate coupling of the rd
// pulse onto the store (reads are non-destructive by construction here), mismatch.
`include "disciplines.vams"
`include "constants.vams"

// one cell: wd = wdata<r>, ws = wsel<c>, rn = rd<r>, cl = col<c>, s = its store node
`define CELL(wd, ws, rn, cl, s) \
        I(s, vss) <+ cs * ddt(V(s, vss)); \
        I(s, wd) <+ V(s, wd) * (gon * 0.5 * (1.0 + tanh((V(ws, vss) - vsel) / vsw)) + gleak); \
        I(s, ws) <+ cinj * ddt(V(s, ws)); \
        I(cl, rn) <+ is * (ekv(V(s, rn) - vt, nut) - ekv(V(s, cl) - vt, nut));

module gain_cell_array(wdata0, wdata1, wdata2, wdata3, wdata4, wdata5, wdata6, wdata7, wsel0, wsel1, wsel2, wsel3, wsel4, wsel5, wsel6, wsel7, rd0, rd1, rd2, rd3, rd4, rd5, rd6, rd7, col0, col1, col2, col3, col4, col5, col6, col7, vss);
    inout wdata0, wdata1, wdata2, wdata3, wdata4, wdata5, wdata6, wdata7, wsel0, wsel1, wsel2, wsel3, wsel4, wsel5, wsel6, wsel7, rd0, rd1, rd2, rd3, rd4, rd5, rd6, rd7, col0, col1, col2, col3, col4, col5, col6, col7, vss;
    electrical wdata0, wdata1, wdata2, wdata3, wdata4, wdata5, wdata6, wdata7, wsel0, wsel1, wsel2, wsel3, wsel4, wsel5, wsel6, wsel7, rd0, rd1, rd2, rd3, rd4, rd5, rd6, rd7, col0, col1, col2, col3, col4, col5, col6, col7, vss;
    electrical s0_0, s0_1, s0_2, s0_3, s0_4, s0_5, s0_6, s0_7,
        s1_0, s1_1, s1_2, s1_3, s1_4, s1_5, s1_6, s1_7,
        s2_0, s2_1, s2_2, s2_3, s2_4, s2_5, s2_6, s2_7,
        s3_0, s3_1, s3_2, s3_3, s3_4, s3_5, s3_6, s3_7,
        s4_0, s4_1, s4_2, s4_3, s4_4, s4_5, s4_6, s4_7,
        s5_0, s5_1, s5_2, s5_3, s5_4, s5_5, s5_6, s5_7,
        s6_0, s6_1, s6_2, s6_3, s6_4, s6_5, s6_6, s6_7,
        s7_0, s7_1, s7_2, s7_3, s7_4, s7_5, s7_6, s7_7;

    // defaults: sky130 tt 27 C fit to DUT=sch (tb_gain_cell levels, R_on, pedestal)
    parameter real cs = 30e-15 from (0:inf);        // storage cap (F)
    parameter real gon = 1.0 / 34e3 from (0:inf);   // write switch on-conductance (S)
    parameter real gleak = 1e-12 from [0:inf);      // write switch off leakage (S)
    parameter real vsel = 0.9 from (0:inf);         // wsel on threshold (V)
    parameter real vsw = 0.05 from (0:inf);         // wsel switching width (V)
    parameter real cinj = 0.28e-15 from [0:inf);    // wsel -> store overlap (F)
    parameter real is = 0.39e-6 from (0:inf);       // read specific current (A)
    parameter real vt = 0.63 from (0:inf);          // read threshold (V)
    parameter real nut = 0.0413 from (0:inf);       // read n * kT/q (V)

    analog function real ekv;                       // ln(1 + exp(v / 2nUt))^2
        input v, u;
        real v, u, x;
        begin
            x = v / (2.0 * u);
            x = x > 30.0 ? x : ln(1.0 + exp(x));    // softplus, overflow-safe
            ekv = x * x;
        end
    endfunction

    analog begin
        `CELL(wdata0, wsel0, rd0, col0, s0_0)
        `CELL(wdata0, wsel1, rd0, col1, s0_1)
        `CELL(wdata0, wsel2, rd0, col2, s0_2)
        `CELL(wdata0, wsel3, rd0, col3, s0_3)
        `CELL(wdata0, wsel4, rd0, col4, s0_4)
        `CELL(wdata0, wsel5, rd0, col5, s0_5)
        `CELL(wdata0, wsel6, rd0, col6, s0_6)
        `CELL(wdata0, wsel7, rd0, col7, s0_7)
        `CELL(wdata1, wsel0, rd1, col0, s1_0)
        `CELL(wdata1, wsel1, rd1, col1, s1_1)
        `CELL(wdata1, wsel2, rd1, col2, s1_2)
        `CELL(wdata1, wsel3, rd1, col3, s1_3)
        `CELL(wdata1, wsel4, rd1, col4, s1_4)
        `CELL(wdata1, wsel5, rd1, col5, s1_5)
        `CELL(wdata1, wsel6, rd1, col6, s1_6)
        `CELL(wdata1, wsel7, rd1, col7, s1_7)
        `CELL(wdata2, wsel0, rd2, col0, s2_0)
        `CELL(wdata2, wsel1, rd2, col1, s2_1)
        `CELL(wdata2, wsel2, rd2, col2, s2_2)
        `CELL(wdata2, wsel3, rd2, col3, s2_3)
        `CELL(wdata2, wsel4, rd2, col4, s2_4)
        `CELL(wdata2, wsel5, rd2, col5, s2_5)
        `CELL(wdata2, wsel6, rd2, col6, s2_6)
        `CELL(wdata2, wsel7, rd2, col7, s2_7)
        `CELL(wdata3, wsel0, rd3, col0, s3_0)
        `CELL(wdata3, wsel1, rd3, col1, s3_1)
        `CELL(wdata3, wsel2, rd3, col2, s3_2)
        `CELL(wdata3, wsel3, rd3, col3, s3_3)
        `CELL(wdata3, wsel4, rd3, col4, s3_4)
        `CELL(wdata3, wsel5, rd3, col5, s3_5)
        `CELL(wdata3, wsel6, rd3, col6, s3_6)
        `CELL(wdata3, wsel7, rd3, col7, s3_7)
        `CELL(wdata4, wsel0, rd4, col0, s4_0)
        `CELL(wdata4, wsel1, rd4, col1, s4_1)
        `CELL(wdata4, wsel2, rd4, col2, s4_2)
        `CELL(wdata4, wsel3, rd4, col3, s4_3)
        `CELL(wdata4, wsel4, rd4, col4, s4_4)
        `CELL(wdata4, wsel5, rd4, col5, s4_5)
        `CELL(wdata4, wsel6, rd4, col6, s4_6)
        `CELL(wdata4, wsel7, rd4, col7, s4_7)
        `CELL(wdata5, wsel0, rd5, col0, s5_0)
        `CELL(wdata5, wsel1, rd5, col1, s5_1)
        `CELL(wdata5, wsel2, rd5, col2, s5_2)
        `CELL(wdata5, wsel3, rd5, col3, s5_3)
        `CELL(wdata5, wsel4, rd5, col4, s5_4)
        `CELL(wdata5, wsel5, rd5, col5, s5_5)
        `CELL(wdata5, wsel6, rd5, col6, s5_6)
        `CELL(wdata5, wsel7, rd5, col7, s5_7)
        `CELL(wdata6, wsel0, rd6, col0, s6_0)
        `CELL(wdata6, wsel1, rd6, col1, s6_1)
        `CELL(wdata6, wsel2, rd6, col2, s6_2)
        `CELL(wdata6, wsel3, rd6, col3, s6_3)
        `CELL(wdata6, wsel4, rd6, col4, s6_4)
        `CELL(wdata6, wsel5, rd6, col5, s6_5)
        `CELL(wdata6, wsel6, rd6, col6, s6_6)
        `CELL(wdata6, wsel7, rd6, col7, s6_7)
        `CELL(wdata7, wsel0, rd7, col0, s7_0)
        `CELL(wdata7, wsel1, rd7, col1, s7_1)
        `CELL(wdata7, wsel2, rd7, col2, s7_2)
        `CELL(wdata7, wsel3, rd7, col3, s7_3)
        `CELL(wdata7, wsel4, rd7, col4, s7_4)
        `CELL(wdata7, wsel5, rd7, col5, s7_5)
        `CELL(wdata7, wsel6, rd7, col6, s7_6)
        `CELL(wdata7, wsel7, rd7, col7, s7_7)
    end
endmodule
