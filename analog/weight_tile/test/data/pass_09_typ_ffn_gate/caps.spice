* pass typ_ffn_gate ffn_gate tile(c=5,r=12)
.param wcp_r0c0=0
.param wcn_r0c0=0
.param wcp_r0c1=0
.param wcn_r0c1=1
.param wcp_r0c2=2
.param wcn_r0c2=0
.param wcp_r0c3=0
.param wcn_r0c3=1
.param wcp_r0c4=1
.param wcn_r0c4=0
.param wcp_r0c5=1
.param wcn_r0c5=0
.param wcp_r0c6=0
.param wcn_r0c6=1
.param wcp_r0c7=0
.param wcn_r0c7=5
.param wcp_r0c8=2
.param wcn_r0c8=0
.param wcp_r0c9=0
.param wcn_r0c9=4
.param wcp_r0c10=1
.param wcn_r0c10=0
.param wcp_r0c11=2
.param wcn_r0c11=0
.param wcp_r0c12=0
.param wcn_r0c12=1
.param wcp_r0c13=0
.param wcn_r0c13=1
.param wcp_r0c14=1
.param wcn_r0c14=0
.param wcp_r0c15=0
.param wcn_r0c15=1
.param wcp_r1c0=0
.param wcn_r1c0=0
.param wcp_r1c1=0
.param wcn_r1c1=2
.param wcp_r1c2=0
.param wcn_r1c2=1
.param wcp_r1c3=3
.param wcn_r1c3=0
.param wcp_r1c4=0
.param wcn_r1c4=1
.param wcp_r1c5=1
.param wcn_r1c5=0
.param wcp_r1c6=1
.param wcn_r1c6=0
.param wcp_r1c7=0
.param wcn_r1c7=1
.param wcp_r1c8=0
.param wcn_r1c8=0
.param wcp_r1c9=0
.param wcn_r1c9=1
.param wcp_r1c10=1
.param wcn_r1c10=0
.param wcp_r1c11=1
.param wcn_r1c11=0
.param wcp_r1c12=2
.param wcn_r1c12=0
.param wcp_r1c13=1
.param wcn_r1c13=0
.param wcp_r1c14=1
.param wcn_r1c14=0
.param wcp_r1c15=2
.param wcn_r1c15=0
.param wcp_r2c0=0
.param wcn_r2c0=3
.param wcp_r2c1=0
.param wcn_r2c1=1
.param wcp_r2c2=0
.param wcn_r2c2=1
.param wcp_r2c3=0
.param wcn_r2c3=1
.param wcp_r2c4=0
.param wcn_r2c4=0
.param wcp_r2c5=0
.param wcn_r2c5=2
.param wcp_r2c6=0
.param wcn_r2c6=2
.param wcp_r2c7=0
.param wcn_r2c7=1
.param wcp_r2c8=1
.param wcn_r2c8=0
.param wcp_r2c9=0
.param wcn_r2c9=2
.param wcp_r2c10=0
.param wcn_r2c10=1
.param wcp_r2c11=2
.param wcn_r2c11=0
.param wcp_r2c12=1
.param wcn_r2c12=0
.param wcp_r2c13=0
.param wcn_r2c13=3
.param wcp_r2c14=0
.param wcn_r2c14=2
.param wcp_r2c15=0
.param wcn_r2c15=1
.param wcp_r3c0=0
.param wcn_r3c0=1
.param wcp_r3c1=0
.param wcn_r3c1=1
.param wcp_r3c2=0
.param wcn_r3c2=2
.param wcp_r3c3=1
.param wcn_r3c3=0
.param wcp_r3c4=0
.param wcn_r3c4=1
.param wcp_r3c5=1
.param wcn_r3c5=0
.param wcp_r3c6=0
.param wcn_r3c6=0
.param wcp_r3c7=0
.param wcn_r3c7=0
.param wcp_r3c8=1
.param wcn_r3c8=0
.param wcp_r3c9=2
.param wcn_r3c9=0
.param wcp_r3c10=0
.param wcn_r3c10=1
.param wcp_r3c11=0
.param wcn_r3c11=1
.param wcp_r3c12=0
.param wcn_r3c12=1
.param wcp_r3c13=0
.param wcn_r3c13=1
.param wcp_r3c14=0
.param wcn_r3c14=0
.param wcp_r3c15=0
.param wcn_r3c15=3
.param wcp_r4c0=1
.param wcn_r4c0=0
.param wcp_r4c1=3
.param wcn_r4c1=0
.param wcp_r4c2=0
.param wcn_r4c2=0
.param wcp_r4c3=0
.param wcn_r4c3=2
.param wcp_r4c4=4
.param wcn_r4c4=0
.param wcp_r4c5=0
.param wcn_r4c5=4
.param wcp_r4c6=2
.param wcn_r4c6=0
.param wcp_r4c7=0
.param wcn_r4c7=3
.param wcp_r4c8=0
.param wcn_r4c8=2
.param wcp_r4c9=0
.param wcn_r4c9=1
.param wcp_r4c10=2
.param wcn_r4c10=0
.param wcp_r4c11=1
.param wcn_r4c11=0
.param wcp_r4c12=0
.param wcn_r4c12=4
.param wcp_r4c13=0
.param wcn_r4c13=0
.param wcp_r4c14=3
.param wcn_r4c14=0
.param wcp_r4c15=1
.param wcn_r4c15=0
.param wcp_r5c0=0
.param wcn_r5c0=3
.param wcp_r5c1=0
.param wcn_r5c1=2
.param wcp_r5c2=0
.param wcn_r5c2=1
.param wcp_r5c3=0
.param wcn_r5c3=0
.param wcp_r5c4=1
.param wcn_r5c4=0
.param wcp_r5c5=1
.param wcn_r5c5=0
.param wcp_r5c6=0
.param wcn_r5c6=2
.param wcp_r5c7=0
.param wcn_r5c7=1
.param wcp_r5c8=1
.param wcn_r5c8=0
.param wcp_r5c9=3
.param wcn_r5c9=0
.param wcp_r5c10=1
.param wcn_r5c10=0
.param wcp_r5c11=0
.param wcn_r5c11=2
.param wcp_r5c12=3
.param wcn_r5c12=0
.param wcp_r5c13=1
.param wcn_r5c13=0
.param wcp_r5c14=0
.param wcn_r5c14=1
.param wcp_r5c15=0
.param wcn_r5c15=1
.param wcp_r6c0=0
.param wcn_r6c0=2
.param wcp_r6c1=2
.param wcn_r6c1=0
.param wcp_r6c2=0
.param wcn_r6c2=2
.param wcp_r6c3=0
.param wcn_r6c3=2
.param wcp_r6c4=2
.param wcn_r6c4=0
.param wcp_r6c5=1
.param wcn_r6c5=0
.param wcp_r6c6=0
.param wcn_r6c6=2
.param wcp_r6c7=0
.param wcn_r6c7=4
.param wcp_r6c8=2
.param wcn_r6c8=0
.param wcp_r6c9=2
.param wcn_r6c9=0
.param wcp_r6c10=0
.param wcn_r6c10=0
.param wcp_r6c11=1
.param wcn_r6c11=0
.param wcp_r6c12=0
.param wcn_r6c12=0
.param wcp_r6c13=2
.param wcn_r6c13=0
.param wcp_r6c14=0
.param wcn_r6c14=0
.param wcp_r6c15=0
.param wcn_r6c15=1
.param wcp_r7c0=3
.param wcn_r7c0=0
.param wcp_r7c1=0
.param wcn_r7c1=4
.param wcp_r7c2=2
.param wcn_r7c2=0
.param wcp_r7c3=0
.param wcn_r7c3=2
.param wcp_r7c4=0
.param wcn_r7c4=4
.param wcp_r7c5=0
.param wcn_r7c5=1
.param wcp_r7c6=0
.param wcn_r7c6=6
.param wcp_r7c7=0
.param wcn_r7c7=4
.param wcp_r7c8=0
.param wcn_r7c8=4
.param wcp_r7c9=0
.param wcn_r7c9=7
.param wcp_r7c10=0
.param wcn_r7c10=0
.param wcp_r7c11=0
.param wcn_r7c11=0
.param wcp_r7c12=3
.param wcn_r7c12=0
.param wcp_r7c13=0
.param wcn_r7c13=5
.param wcp_r7c14=0
.param wcn_r7c14=1
.param wcp_r7c15=0
.param wcn_r7c15=7
.param wcp_r8c0=1
.param wcn_r8c0=0
.param wcp_r8c1=0
.param wcn_r8c1=1
.param wcp_r8c2=0
.param wcn_r8c2=1
.param wcp_r8c3=1
.param wcn_r8c3=0
.param wcp_r8c4=0
.param wcn_r8c4=3
.param wcp_r8c5=2
.param wcn_r8c5=0
.param wcp_r8c6=2
.param wcn_r8c6=0
.param wcp_r8c7=0
.param wcn_r8c7=1
.param wcp_r8c8=0
.param wcn_r8c8=0
.param wcp_r8c9=0
.param wcn_r8c9=1
.param wcp_r8c10=0
.param wcn_r8c10=1
.param wcp_r8c11=0
.param wcn_r8c11=1
.param wcp_r8c12=0
.param wcn_r8c12=0
.param wcp_r8c13=0
.param wcn_r8c13=0
.param wcp_r8c14=0
.param wcn_r8c14=2
.param wcp_r8c15=0
.param wcn_r8c15=1
.param wcp_r9c0=0
.param wcn_r9c0=0
.param wcp_r9c1=0
.param wcn_r9c1=0
.param wcp_r9c2=0
.param wcn_r9c2=0
.param wcp_r9c3=0
.param wcn_r9c3=2
.param wcp_r9c4=0
.param wcn_r9c4=3
.param wcp_r9c5=0
.param wcn_r9c5=0
.param wcp_r9c6=2
.param wcn_r9c6=0
.param wcp_r9c7=2
.param wcn_r9c7=0
.param wcp_r9c8=0
.param wcn_r9c8=1
.param wcp_r9c9=0
.param wcn_r9c9=1
.param wcp_r9c10=0
.param wcn_r9c10=0
.param wcp_r9c11=0
.param wcn_r9c11=0
.param wcp_r9c12=0
.param wcn_r9c12=3
.param wcp_r9c13=2
.param wcn_r9c13=0
.param wcp_r9c14=3
.param wcn_r9c14=0
.param wcp_r9c15=0
.param wcn_r9c15=0
.param wcp_r10c0=0
.param wcn_r10c0=5
.param wcp_r10c1=0
.param wcn_r10c1=1
.param wcp_r10c2=1
.param wcn_r10c2=0
.param wcp_r10c3=4
.param wcn_r10c3=0
.param wcp_r10c4=0
.param wcn_r10c4=1
.param wcp_r10c5=0
.param wcn_r10c5=2
.param wcp_r10c6=0
.param wcn_r10c6=3
.param wcp_r10c7=2
.param wcn_r10c7=0
.param wcp_r10c8=0
.param wcn_r10c8=1
.param wcp_r10c9=0
.param wcn_r10c9=2
.param wcp_r10c10=1
.param wcn_r10c10=0
.param wcp_r10c11=1
.param wcn_r10c11=0
.param wcp_r10c12=5
.param wcn_r10c12=0
.param wcp_r10c13=0
.param wcn_r10c13=5
.param wcp_r10c14=3
.param wcn_r10c14=0
.param wcp_r10c15=0
.param wcn_r10c15=3
.param wcp_r11c0=2
.param wcn_r11c0=0
.param wcp_r11c1=2
.param wcn_r11c1=0
.param wcp_r11c2=1
.param wcn_r11c2=0
.param wcp_r11c3=2
.param wcn_r11c3=0
.param wcp_r11c4=0
.param wcn_r11c4=2
.param wcp_r11c5=0
.param wcn_r11c5=3
.param wcp_r11c6=2
.param wcn_r11c6=0
.param wcp_r11c7=0
.param wcn_r11c7=0
.param wcp_r11c8=2
.param wcn_r11c8=0
.param wcp_r11c9=0
.param wcn_r11c9=5
.param wcp_r11c10=0
.param wcn_r11c10=3
.param wcp_r11c11=2
.param wcn_r11c11=0
.param wcp_r11c12=0
.param wcn_r11c12=4
.param wcp_r11c13=1
.param wcn_r11c13=0
.param wcp_r11c14=1
.param wcn_r11c14=0
.param wcp_r11c15=0
.param wcn_r11c15=3
.param wcp_r12c0=0
.param wcn_r12c0=1
.param wcp_r12c1=0
.param wcn_r12c1=1
.param wcp_r12c2=1
.param wcn_r12c2=0
.param wcp_r12c3=0
.param wcn_r12c3=5
.param wcp_r12c4=0
.param wcn_r12c4=2
.param wcp_r12c5=0
.param wcn_r12c5=1
.param wcp_r12c6=1
.param wcn_r12c6=0
.param wcp_r12c7=0
.param wcn_r12c7=2
.param wcp_r12c8=0
.param wcn_r12c8=1
.param wcp_r12c9=0
.param wcn_r12c9=0
.param wcp_r12c10=2
.param wcn_r12c10=0
.param wcp_r12c11=2
.param wcn_r12c11=0
.param wcp_r12c12=0
.param wcn_r12c12=1
.param wcp_r12c13=0
.param wcn_r12c13=0
.param wcp_r12c14=1
.param wcn_r12c14=0
.param wcp_r12c15=0
.param wcn_r12c15=3
.param wcp_r13c0=0
.param wcn_r13c0=1
.param wcp_r13c1=0
.param wcn_r13c1=0
.param wcp_r13c2=0
.param wcn_r13c2=0
.param wcp_r13c3=0
.param wcn_r13c3=0
.param wcp_r13c4=0
.param wcn_r13c4=3
.param wcp_r13c5=0
.param wcn_r13c5=1
.param wcp_r13c6=0
.param wcn_r13c6=2
.param wcp_r13c7=0
.param wcn_r13c7=0
.param wcp_r13c8=2
.param wcn_r13c8=0
.param wcp_r13c9=0
.param wcn_r13c9=2
.param wcp_r13c10=1
.param wcn_r13c10=0
.param wcp_r13c11=2
.param wcn_r13c11=0
.param wcp_r13c12=3
.param wcn_r13c12=0
.param wcp_r13c13=0
.param wcn_r13c13=1
.param wcp_r13c14=1
.param wcn_r13c14=0
.param wcp_r13c15=0
.param wcn_r13c15=0
.param wcp_r14c0=0
.param wcn_r14c0=3
.param wcp_r14c1=0
.param wcn_r14c1=0
.param wcp_r14c2=0
.param wcn_r14c2=0
.param wcp_r14c3=0
.param wcn_r14c3=0
.param wcp_r14c4=3
.param wcn_r14c4=0
.param wcp_r14c5=2
.param wcn_r14c5=0
.param wcp_r14c6=0
.param wcn_r14c6=0
.param wcp_r14c7=0
.param wcn_r14c7=1
.param wcp_r14c8=2
.param wcn_r14c8=0
.param wcp_r14c9=5
.param wcn_r14c9=0
.param wcp_r14c10=0
.param wcn_r14c10=1
.param wcp_r14c11=0
.param wcn_r14c11=0
.param wcp_r14c12=0
.param wcn_r14c12=3
.param wcp_r14c13=2
.param wcn_r14c13=0
.param wcp_r14c14=1
.param wcn_r14c14=0
.param wcp_r14c15=0
.param wcn_r14c15=4
.param wcp_r15c0=0
.param wcn_r15c0=1
.param wcp_r15c1=1
.param wcn_r15c1=0
.param wcp_r15c2=0
.param wcn_r15c2=1
.param wcp_r15c3=0
.param wcn_r15c3=1
.param wcp_r15c4=1
.param wcn_r15c4=0
.param wcp_r15c5=0
.param wcn_r15c5=1
.param wcp_r15c6=0
.param wcn_r15c6=0
.param wcp_r15c7=0
.param wcn_r15c7=2
.param wcp_r15c8=0
.param wcn_r15c8=0
.param wcp_r15c9=0
.param wcn_r15c9=0
.param wcp_r15c10=1
.param wcn_r15c10=0
.param wcp_r15c11=0
.param wcn_r15c11=0
.param wcp_r15c12=3
.param wcn_r15c12=0
.param wcp_r15c13=1
.param wcn_r15c13=0
.param wcp_r15c14=0
.param wcn_r15c14=1
.param wcp_r15c15=0
.param wcn_r15c15=0
.param wcp_r0c16=1
.param wcn_r0c16=0
.param wcp_r1c16=1
.param wcn_r1c16=0
.param wcp_r2c16=0
.param wcn_r2c16=0
.param wcp_r3c16=0
.param wcn_r3c16=1
.param wcp_r4c16=0
.param wcn_r4c16=0
.param wcp_r5c16=0
.param wcn_r5c16=1
.param wcp_r6c16=0
.param wcn_r6c16=1
.param wcp_r7c16=1
.param wcn_r7c16=0
.param wcp_r8c16=1
.param wcn_r8c16=0
.param wcp_r9c16=0
.param wcn_r9c16=1
.param wcp_r10c16=0
.param wcn_r10c16=0
.param wcp_r11c16=0
.param wcn_r11c16=0
.param wcp_r12c16=0
.param wcn_r12c16=1
.param wcp_r13c16=0
.param wcn_r13c16=0
.param wcp_r14c16=0
.param wcn_r14c16=2
.param wcp_r15c16=0
.param wcn_r15c16=0
