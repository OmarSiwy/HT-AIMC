// tile_seq testbench fixture: the rail side of the integrate handshake plus 17 column
// stand-ins. integ_req rises at t_req, falls t_sync after integ_ack rises and rises again
// t_sync after integ_ack falls while fewer than n_pass handshakes completed. Column j
// raises sdone_j (2 + 0.3 j) ns after sgo (its sign strobe resolving), drops it with sgo.
`include "disciplines.vams"
`include "constants.vams"

module seq_drv(integ_ack, sgo, integ_req, sdone0, sdone1, sdone2, sdone3, sdone4, sdone5,
               sdone6, sdone7, sdone8, sdone9, sdone10, sdone11, sdone12, sdone13, sdone14,
               sdone15, sdone16);
    inout integ_ack, sgo, integ_req, sdone0, sdone1, sdone2, sdone3, sdone4, sdone5, sdone6,
          sdone7, sdone8, sdone9, sdone10, sdone11, sdone12, sdone13, sdone14, sdone15,
          sdone16;
    electrical integ_ack, sgo, integ_req, sdone0, sdone1, sdone2, sdone3, sdone4, sdone5,
               sdone6, sdone7, sdone8, sdone9, sdone10, sdone11, sdone12, sdone13, sdone14,
               sdone15, sdone16;
    parameter integer n_pass = 1 from [1:8];
    parameter real t_req = 20e-9 from (0:inf);
    parameter real t_sync = 40e-9 from (0:inf);
    parameter real vdd = 1.8 from (0:inf);
    integer req, done, sg;

    analog begin
        @(initial_step) begin
            req = 0; done = 0; sg = 0;
        end
        @(timer(t_req)) req = 1;
        @(cross(V(integ_ack) - vdd / 2, +1)) req = 0;
        @(cross(V(integ_ack) - vdd / 2, -1)) begin
            done = done + 1;
            if (done < n_pass) req = 1;
        end
        @(cross(V(sgo) - vdd / 2, +1)) sg = 1;
        @(cross(V(sgo) - vdd / 2, -1)) sg = 0;
        V(integ_req) <+ transition(req * vdd, t_sync, 0.1e-9);
        V(sdone0) <+ transition(sg * vdd, 2.0e-9, 0.1e-9);
        V(sdone1) <+ transition(sg * vdd, 2.3e-9, 0.1e-9);
        V(sdone2) <+ transition(sg * vdd, 2.6e-9, 0.1e-9);
        V(sdone3) <+ transition(sg * vdd, 2.9e-9, 0.1e-9);
        V(sdone4) <+ transition(sg * vdd, 3.2e-9, 0.1e-9);
        V(sdone5) <+ transition(sg * vdd, 3.5e-9, 0.1e-9);
        V(sdone6) <+ transition(sg * vdd, 3.8e-9, 0.1e-9);
        V(sdone7) <+ transition(sg * vdd, 4.1e-9, 0.1e-9);
        V(sdone8) <+ transition(sg * vdd, 4.4e-9, 0.1e-9);
        V(sdone9) <+ transition(sg * vdd, 4.7e-9, 0.1e-9);
        V(sdone10) <+ transition(sg * vdd, 5.0e-9, 0.1e-9);
        V(sdone11) <+ transition(sg * vdd, 5.3e-9, 0.1e-9);
        V(sdone12) <+ transition(sg * vdd, 5.6e-9, 0.1e-9);
        V(sdone13) <+ transition(sg * vdd, 5.9e-9, 0.1e-9);
        V(sdone14) <+ transition(sg * vdd, 6.2e-9, 0.1e-9);
        V(sdone15) <+ transition(sg * vdd, 6.5e-9, 0.1e-9);
        V(sdone16) <+ transition(sg * vdd, 6.8e-9, 0.1e-9);
    end
endmodule
