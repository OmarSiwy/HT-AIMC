.subckt rst_delay in out vdd vss
X0_n d0 in vss vss sky130_fd_pr__nfet_01v8 W=0.42 L=0.15
X0_p d0 in vdd vdd sky130_fd_pr__pfet_01v8 W=0.7 L=0.15
Xload0 d0 vss sky130_fd_pr__cap_mim_m3_1 W=10.32 L=10.32
X1_n d1 d0 vss vss sky130_fd_pr__nfet_01v8 W=0.42 L=0.15
X1_p d1 d0 vdd vdd sky130_fd_pr__pfet_01v8 W=0.7 L=0.15
Xload1 d1 vss sky130_fd_pr__cap_mim_m3_1 W=10.32 L=10.32
X2_n d2 d1 vss vss sky130_fd_pr__nfet_01v8 W=0.42 L=0.15
X2_p d2 d1 vdd vdd sky130_fd_pr__pfet_01v8 W=0.7 L=0.15
Xload2 d2 vss sky130_fd_pr__cap_mim_m3_1 W=10.32 L=10.32
X3_n d3 d2 vss vss sky130_fd_pr__nfet_01v8 W=0.42 L=0.15
X3_p d3 d2 vdd vdd sky130_fd_pr__pfet_01v8 W=0.7 L=0.15
Xload3 d3 vss sky130_fd_pr__cap_mim_m3_1 W=10.32 L=10.32
X4_n d4 d3 vss vss sky130_fd_pr__nfet_01v8 W=0.42 L=0.15
X4_p d4 d3 vdd vdd sky130_fd_pr__pfet_01v8 W=0.7 L=0.15
Xload4 d4 vss sky130_fd_pr__cap_mim_m3_1 W=10.32 L=10.32
X5_n d5 d4 vss vss sky130_fd_pr__nfet_01v8 W=0.42 L=0.15
X5_p d5 d4 vdd vdd sky130_fd_pr__pfet_01v8 W=0.7 L=0.15
Xload5 d5 vss sky130_fd_pr__cap_mim_m3_1 W=10.32 L=10.32
X6_n d6 d5 vss vss sky130_fd_pr__nfet_01v8 W=0.42 L=0.15
X6_p d6 d5 vdd vdd sky130_fd_pr__pfet_01v8 W=0.7 L=0.15
Xload6 d6 vss sky130_fd_pr__cap_mim_m3_1 W=10.32 L=10.32
X7_n d7 d6 vss vss sky130_fd_pr__nfet_01v8 W=0.42 L=0.15
X7_p d7 d6 vdd vdd sky130_fd_pr__pfet_01v8 W=0.7 L=0.15
Xload7 d7 vss sky130_fd_pr__cap_mim_m3_1 W=10.32 L=10.32
X8_n d8 d7 vss vss sky130_fd_pr__nfet_01v8 W=0.42 L=0.15
X8_p d8 d7 vdd vdd sky130_fd_pr__pfet_01v8 W=0.7 L=0.15
Xload8 d8 vss sky130_fd_pr__cap_mim_m3_1 W=10.32 L=10.32
X9_n out d8 vss vss sky130_fd_pr__nfet_01v8 W=0.42 L=0.15
X9_p out d8 vdd vdd sky130_fd_pr__pfet_01v8 W=0.7 L=0.15
Xload9 out vss sky130_fd_pr__cap_mim_m3_1 W=10.32 L=10.32
.ends rst_delay

.subckt settle_delay in out vdd vss
X0_n d0 in vss vss sky130_fd_pr__nfet_01v8 W=0.42 L=0.15
X0_p d0 in vdd vdd sky130_fd_pr__pfet_01v8 W=0.7 L=0.15
Xload0 d0 vss sky130_fd_pr__cap_mim_m3_1 W=10.32 L=10.32
X1_n d1 d0 vss vss sky130_fd_pr__nfet_01v8 W=0.42 L=0.15
X1_p d1 d0 vdd vdd sky130_fd_pr__pfet_01v8 W=0.7 L=0.15
Xload1 d1 vss sky130_fd_pr__cap_mim_m3_1 W=10.32 L=10.32
X2_n d2 d1 vss vss sky130_fd_pr__nfet_01v8 W=0.42 L=0.15
X2_p d2 d1 vdd vdd sky130_fd_pr__pfet_01v8 W=0.7 L=0.15
Xload2 d2 vss sky130_fd_pr__cap_mim_m3_1 W=10.32 L=10.32
X3_n d3 d2 vss vss sky130_fd_pr__nfet_01v8 W=0.42 L=0.15
X3_p d3 d2 vdd vdd sky130_fd_pr__pfet_01v8 W=0.7 L=0.15
Xload3 d3 vss sky130_fd_pr__cap_mim_m3_1 W=10.32 L=10.32
X4_n d4 d3 vss vss sky130_fd_pr__nfet_01v8 W=0.42 L=0.15
X4_p d4 d3 vdd vdd sky130_fd_pr__pfet_01v8 W=0.7 L=0.15
Xload4 d4 vss sky130_fd_pr__cap_mim_m3_1 W=10.32 L=10.32
X5_n d5 d4 vss vss sky130_fd_pr__nfet_01v8 W=0.42 L=0.15
X5_p d5 d4 vdd vdd sky130_fd_pr__pfet_01v8 W=0.7 L=0.15
Xload5 d5 vss sky130_fd_pr__cap_mim_m3_1 W=10.32 L=10.32
X6_n d6 d5 vss vss sky130_fd_pr__nfet_01v8 W=0.42 L=0.15
X6_p d6 d5 vdd vdd sky130_fd_pr__pfet_01v8 W=0.7 L=0.15
Xload6 d6 vss sky130_fd_pr__cap_mim_m3_1 W=10.32 L=10.32
X7_n d7 d6 vss vss sky130_fd_pr__nfet_01v8 W=0.42 L=0.15
X7_p d7 d6 vdd vdd sky130_fd_pr__pfet_01v8 W=0.7 L=0.15
Xload7 d7 vss sky130_fd_pr__cap_mim_m3_1 W=10.32 L=10.32
X8_n d8 d7 vss vss sky130_fd_pr__nfet_01v8 W=0.42 L=0.15
X8_p d8 d7 vdd vdd sky130_fd_pr__pfet_01v8 W=0.7 L=0.15
Xload8 d8 vss sky130_fd_pr__cap_mim_m3_1 W=10.32 L=10.32
X9_n d9 d8 vss vss sky130_fd_pr__nfet_01v8 W=0.42 L=0.15
X9_p d9 d8 vdd vdd sky130_fd_pr__pfet_01v8 W=0.7 L=0.15
Xload9 d9 vss sky130_fd_pr__cap_mim_m3_1 W=10.32 L=10.32
X10_n d10 d9 vss vss sky130_fd_pr__nfet_01v8 W=0.42 L=0.15
X10_p d10 d9 vdd vdd sky130_fd_pr__pfet_01v8 W=0.7 L=0.15
Xload10 d10 vss sky130_fd_pr__cap_mim_m3_1 W=10.32 L=10.32
X11_n d11 d10 vss vss sky130_fd_pr__nfet_01v8 W=0.42 L=0.15
X11_p d11 d10 vdd vdd sky130_fd_pr__pfet_01v8 W=0.7 L=0.15
Xload11 d11 vss sky130_fd_pr__cap_mim_m3_1 W=10.32 L=10.32
X12_n d12 d11 vss vss sky130_fd_pr__nfet_01v8 W=0.42 L=0.15
X12_p d12 d11 vdd vdd sky130_fd_pr__pfet_01v8 W=0.7 L=0.15
Xload12 d12 vss sky130_fd_pr__cap_mim_m3_1 W=10.32 L=10.32
X13_n d13 d12 vss vss sky130_fd_pr__nfet_01v8 W=0.42 L=0.15
X13_p d13 d12 vdd vdd sky130_fd_pr__pfet_01v8 W=0.7 L=0.15
Xload13 d13 vss sky130_fd_pr__cap_mim_m3_1 W=10.32 L=10.32
X14_n d14 d13 vss vss sky130_fd_pr__nfet_01v8 W=0.42 L=0.15
X14_p d14 d13 vdd vdd sky130_fd_pr__pfet_01v8 W=0.7 L=0.15
Xload14 d14 vss sky130_fd_pr__cap_mim_m3_1 W=10.32 L=10.32
X15_n d15 d14 vss vss sky130_fd_pr__nfet_01v8 W=0.42 L=0.15
X15_p d15 d14 vdd vdd sky130_fd_pr__pfet_01v8 W=0.7 L=0.15
Xload15 d15 vss sky130_fd_pr__cap_mim_m3_1 W=10.32 L=10.32
X16_n d16 d15 vss vss sky130_fd_pr__nfet_01v8 W=0.42 L=0.15
X16_p d16 d15 vdd vdd sky130_fd_pr__pfet_01v8 W=0.7 L=0.15
Xload16 d16 vss sky130_fd_pr__cap_mim_m3_1 W=10.32 L=10.32
X17_n d17 d16 vss vss sky130_fd_pr__nfet_01v8 W=0.42 L=0.15
X17_p d17 d16 vdd vdd sky130_fd_pr__pfet_01v8 W=0.7 L=0.15
Xload17 d17 vss sky130_fd_pr__cap_mim_m3_1 W=10.32 L=10.32
X18_n d18 d17 vss vss sky130_fd_pr__nfet_01v8 W=0.42 L=0.15
X18_p d18 d17 vdd vdd sky130_fd_pr__pfet_01v8 W=0.7 L=0.15
Xload18 d18 vss sky130_fd_pr__cap_mim_m3_1 W=10.32 L=10.32
X19_n out d18 vss vss sky130_fd_pr__nfet_01v8 W=0.42 L=0.15
X19_p out d18 vdd vdd sky130_fd_pr__pfet_01v8 W=0.7 L=0.15
Xload19 out vss sky130_fd_pr__cap_mim_m3_1 W=10.32 L=10.32
.ends settle_delay

.subckt tq_chain in tap1 tap2 tap3 tap4 vdd vss
Xtq_tap1_m_n tap1_m in vss vss sky130_fd_pr__nfet_01v8 W=0.84 L=0.15
Xtq_tap1_m_p tap1_m in vdd vdd sky130_fd_pr__pfet_01v8 W=1.4 L=0.15
Xload_tap1_m tap1_m vss sky130_fd_pr__cap_mim_m3_1 W=21.87 L=21.87
Xtq_tap1_n tap1 tap1_m vss vss sky130_fd_pr__nfet_01v8 W=0.84 L=0.15
Xtq_tap1_p tap1 tap1_m vdd vdd sky130_fd_pr__pfet_01v8 W=1.4 L=0.15
Xload_tap1 tap1 vss sky130_fd_pr__cap_mim_m3_1 W=21.87 L=21.87
Xtq_tap2_m_n tap2_m tap1 vss vss sky130_fd_pr__nfet_01v8 W=0.84 L=0.15
Xtq_tap2_m_p tap2_m tap1 vdd vdd sky130_fd_pr__pfet_01v8 W=1.4 L=0.15
Xload_tap2_m tap2_m vss sky130_fd_pr__cap_mim_m3_1 W=21.87 L=21.87
Xtq_tap2_n tap2 tap2_m vss vss sky130_fd_pr__nfet_01v8 W=0.84 L=0.15
Xtq_tap2_p tap2 tap2_m vdd vdd sky130_fd_pr__pfet_01v8 W=1.4 L=0.15
Xload_tap2 tap2 vss sky130_fd_pr__cap_mim_m3_1 W=21.87 L=21.87
Xtq_tap3_m_n tap3_m tap2 vss vss sky130_fd_pr__nfet_01v8 W=0.84 L=0.15
Xtq_tap3_m_p tap3_m tap2 vdd vdd sky130_fd_pr__pfet_01v8 W=1.4 L=0.15
Xload_tap3_m tap3_m vss sky130_fd_pr__cap_mim_m3_1 W=21.87 L=21.87
Xtq_tap3_n tap3 tap3_m vss vss sky130_fd_pr__nfet_01v8 W=0.84 L=0.15
Xtq_tap3_p tap3 tap3_m vdd vdd sky130_fd_pr__pfet_01v8 W=1.4 L=0.15
Xload_tap3 tap3 vss sky130_fd_pr__cap_mim_m3_1 W=21.87 L=21.87
Xtq_tap4_m_n tap4_m tap3 vss vss sky130_fd_pr__nfet_01v8 W=0.84 L=0.15
Xtq_tap4_m_p tap4_m tap3 vdd vdd sky130_fd_pr__pfet_01v8 W=1.4 L=0.15
Xload_tap4_m tap4_m vss sky130_fd_pr__cap_mim_m3_1 W=21.87 L=21.87
Xtq_tap4_n tap4 tap4_m vss vss sky130_fd_pr__nfet_01v8 W=0.84 L=0.15
Xtq_tap4_p tap4 tap4_m vdd vdd sky130_fd_pr__pfet_01v8 W=1.4 L=0.15
Xload_tap4 tap4 vss sky130_fd_pr__cap_mim_m3_1 W=21.87 L=21.87
.ends tq_chain

.subckt muller_c a b out vdd vss
Xp1 out a n1p vdd sky130_fd_pr__pfet_01v8 W=1.4 L=0.15
Xp2 n1p b vdd vdd sky130_fd_pr__pfet_01v8 W=1.4 L=0.15
Xp3 out out_b vdd vdd sky130_fd_pr__pfet_01v8 W=0.42 L=0.6
Xn1 out a n1n vss sky130_fd_pr__nfet_01v8 W=0.84 L=0.15
Xn2 n1n b vss vss sky130_fd_pr__nfet_01v8 W=0.84 L=0.15
Xn3 out out_b vss vss sky130_fd_pr__nfet_01v8 W=0.42 L=0.6
Xfb_n out_b out vss vss sky130_fd_pr__nfet_01v8 W=0.42 L=0.15
Xfb_p out_b out vdd vdd sky130_fd_pr__pfet_01v8 W=0.7 L=0.15
.ends muller_c

.subckt dly_pace in out vdd vss
Xu0_p1 u0 in vdd vdd sky130_fd_pr__pfet_01v8 W=1.11 L=1.2
Xu0_p2 u0 in vdd vdd sky130_fd_pr__pfet_01v8 W=1.11 L=1.2
Xu0_n1 u0 in u0_m vss sky130_fd_pr__nfet_01v8 W=0.84 L=1.2
Xu0_n2 u0_m in vss vss sky130_fd_pr__nfet_01v8 W=0.84 L=1.2
Xd0_n d0 u0 vss vss sky130_fd_pr__nfet_01v8 W=0.42 L=1.2
Xd0_p d0 u0 vdd vdd sky130_fd_pr__pfet_01v8 W=1.11 L=1.2
Xcu0 u0 vss sky130_fd_pr__cap_mim_m3_1 W=7.65 L=7.65
Xcd0 d0 vss sky130_fd_pr__cap_mim_m3_1 W=7.65 L=7.65
Xu1_p1 u1 in vdd vdd sky130_fd_pr__pfet_01v8 W=1.11 L=1.2
Xu1_p2 u1 d0 vdd vdd sky130_fd_pr__pfet_01v8 W=1.11 L=1.2
Xu1_n1 u1 in u1_m vss sky130_fd_pr__nfet_01v8 W=0.84 L=1.2
Xu1_n2 u1_m d0 vss vss sky130_fd_pr__nfet_01v8 W=0.84 L=1.2
Xd1_n d1 u1 vss vss sky130_fd_pr__nfet_01v8 W=0.42 L=1.2
Xd1_p d1 u1 vdd vdd sky130_fd_pr__pfet_01v8 W=1.11 L=1.2
Xcu1 u1 vss sky130_fd_pr__cap_mim_m3_1 W=7.65 L=7.65
Xcd1 d1 vss sky130_fd_pr__cap_mim_m3_1 W=7.65 L=7.65
Xu2_p1 u2 in vdd vdd sky130_fd_pr__pfet_01v8 W=1.11 L=1.2
Xu2_p2 u2 d1 vdd vdd sky130_fd_pr__pfet_01v8 W=1.11 L=1.2
Xu2_n1 u2 in u2_m vss sky130_fd_pr__nfet_01v8 W=0.84 L=1.2
Xu2_n2 u2_m d1 vss vss sky130_fd_pr__nfet_01v8 W=0.84 L=1.2
Xd2_n d2 u2 vss vss sky130_fd_pr__nfet_01v8 W=0.42 L=1.2
Xd2_p d2 u2 vdd vdd sky130_fd_pr__pfet_01v8 W=1.11 L=1.2
Xcu2 u2 vss sky130_fd_pr__cap_mim_m3_1 W=7.65 L=7.65
Xcd2 d2 vss sky130_fd_pr__cap_mim_m3_1 W=7.65 L=7.65
Xu3_p1 u3 in vdd vdd sky130_fd_pr__pfet_01v8 W=1.11 L=1.2
Xu3_p2 u3 d2 vdd vdd sky130_fd_pr__pfet_01v8 W=1.11 L=1.2
Xu3_n1 u3 in u3_m vss sky130_fd_pr__nfet_01v8 W=0.84 L=1.2
Xu3_n2 u3_m d2 vss vss sky130_fd_pr__nfet_01v8 W=0.84 L=1.2
Xout_n out u3 vss vss sky130_fd_pr__nfet_01v8 W=0.42 L=1.2
Xout_p out u3 vdd vdd sky130_fd_pr__pfet_01v8 W=1.11 L=1.2
Xcu3 u3 vss sky130_fd_pr__cap_mim_m3_1 W=7.65 L=7.65
Xcout out vss sky130_fd_pr__cap_mim_m3_1 W=7.65 L=7.65
.ends dly_pace

.subckt dly_bundle in out vdd vss
Xu0_p1 u0 in vdd vdd sky130_fd_pr__pfet_01v8 W=0.7 L=0.15
Xu0_p2 u0 in vdd vdd sky130_fd_pr__pfet_01v8 W=0.7 L=0.15
Xu0_n1 u0 in u0_m vss sky130_fd_pr__nfet_01v8 W=0.84 L=0.15
Xu0_n2 u0_m in vss vss sky130_fd_pr__nfet_01v8 W=0.84 L=0.15
Xd0_n d0 u0 vss vss sky130_fd_pr__nfet_01v8 W=0.42 L=0.15
Xd0_p d0 u0 vdd vdd sky130_fd_pr__pfet_01v8 W=0.7 L=0.15
Xcu0 u0 vss sky130_fd_pr__cap_mim_m3_1 W=3.95 L=3.95
Xcd0 d0 vss sky130_fd_pr__cap_mim_m3_1 W=3.95 L=3.95
Xu1_p1 u1 in vdd vdd sky130_fd_pr__pfet_01v8 W=0.7 L=0.15
Xu1_p2 u1 d0 vdd vdd sky130_fd_pr__pfet_01v8 W=0.7 L=0.15
Xu1_n1 u1 in u1_m vss sky130_fd_pr__nfet_01v8 W=0.84 L=0.15
Xu1_n2 u1_m d0 vss vss sky130_fd_pr__nfet_01v8 W=0.84 L=0.15
Xd1_n d1 u1 vss vss sky130_fd_pr__nfet_01v8 W=0.42 L=0.15
Xd1_p d1 u1 vdd vdd sky130_fd_pr__pfet_01v8 W=0.7 L=0.15
Xcu1 u1 vss sky130_fd_pr__cap_mim_m3_1 W=3.95 L=3.95
Xcd1 d1 vss sky130_fd_pr__cap_mim_m3_1 W=3.95 L=3.95
Xu2_p1 u2 in vdd vdd sky130_fd_pr__pfet_01v8 W=0.7 L=0.15
Xu2_p2 u2 d1 vdd vdd sky130_fd_pr__pfet_01v8 W=0.7 L=0.15
Xu2_n1 u2 in u2_m vss sky130_fd_pr__nfet_01v8 W=0.84 L=0.15
Xu2_n2 u2_m d1 vss vss sky130_fd_pr__nfet_01v8 W=0.84 L=0.15
Xd2_n d2 u2 vss vss sky130_fd_pr__nfet_01v8 W=0.42 L=0.15
Xd2_p d2 u2 vdd vdd sky130_fd_pr__pfet_01v8 W=0.7 L=0.15
Xcu2 u2 vss sky130_fd_pr__cap_mim_m3_1 W=3.95 L=3.95
Xcd2 d2 vss sky130_fd_pr__cap_mim_m3_1 W=3.95 L=3.95
Xu3_p1 u3 in vdd vdd sky130_fd_pr__pfet_01v8 W=0.7 L=0.15
Xu3_p2 u3 d2 vdd vdd sky130_fd_pr__pfet_01v8 W=0.7 L=0.15
Xu3_n1 u3 in u3_m vss sky130_fd_pr__nfet_01v8 W=0.84 L=0.15
Xu3_n2 u3_m d2 vss vss sky130_fd_pr__nfet_01v8 W=0.84 L=0.15
Xout_n out u3 vss vss sky130_fd_pr__nfet_01v8 W=0.42 L=0.15
Xout_p out u3 vdd vdd sky130_fd_pr__pfet_01v8 W=0.7 L=0.15
Xcu3 u3 vss sky130_fd_pr__cap_mim_m3_1 W=3.95 L=3.95
Xcout out vss sky130_fd_pr__cap_mim_m3_1 W=3.95 L=3.95
.ends dly_bundle

.subckt dly_acq in out vdd vss
Xu0_p1 u0 in vdd vdd sky130_fd_pr__pfet_01v8 W=0.85 L=0.3
Xu0_p2 u0 in vdd vdd sky130_fd_pr__pfet_01v8 W=0.85 L=0.3
Xu0_n1 u0 in u0_m vss sky130_fd_pr__nfet_01v8 W=0.84 L=0.3
Xu0_n2 u0_m in vss vss sky130_fd_pr__nfet_01v8 W=0.84 L=0.3
Xd0_n d0 u0 vss vss sky130_fd_pr__nfet_01v8 W=0.42 L=0.3
Xd0_p d0 u0 vdd vdd sky130_fd_pr__pfet_01v8 W=0.85 L=0.3
Xcu0 u0 vss sky130_fd_pr__cap_mim_m3_1 W=8.07 L=8.07
Xcd0 d0 vss sky130_fd_pr__cap_mim_m3_1 W=8.07 L=8.07
Xu1_p1 u1 in vdd vdd sky130_fd_pr__pfet_01v8 W=0.85 L=0.3
Xu1_p2 u1 d0 vdd vdd sky130_fd_pr__pfet_01v8 W=0.85 L=0.3
Xu1_n1 u1 in u1_m vss sky130_fd_pr__nfet_01v8 W=0.84 L=0.3
Xu1_n2 u1_m d0 vss vss sky130_fd_pr__nfet_01v8 W=0.84 L=0.3
Xd1_n d1 u1 vss vss sky130_fd_pr__nfet_01v8 W=0.42 L=0.3
Xd1_p d1 u1 vdd vdd sky130_fd_pr__pfet_01v8 W=0.85 L=0.3
Xcu1 u1 vss sky130_fd_pr__cap_mim_m3_1 W=8.07 L=8.07
Xcd1 d1 vss sky130_fd_pr__cap_mim_m3_1 W=8.07 L=8.07
Xu2_p1 u2 in vdd vdd sky130_fd_pr__pfet_01v8 W=0.85 L=0.3
Xu2_p2 u2 d1 vdd vdd sky130_fd_pr__pfet_01v8 W=0.85 L=0.3
Xu2_n1 u2 in u2_m vss sky130_fd_pr__nfet_01v8 W=0.84 L=0.3
Xu2_n2 u2_m d1 vss vss sky130_fd_pr__nfet_01v8 W=0.84 L=0.3
Xd2_n d2 u2 vss vss sky130_fd_pr__nfet_01v8 W=0.42 L=0.3
Xd2_p d2 u2 vdd vdd sky130_fd_pr__pfet_01v8 W=0.85 L=0.3
Xcu2 u2 vss sky130_fd_pr__cap_mim_m3_1 W=8.07 L=8.07
Xcd2 d2 vss sky130_fd_pr__cap_mim_m3_1 W=8.07 L=8.07
Xu3_p1 u3 in vdd vdd sky130_fd_pr__pfet_01v8 W=0.85 L=0.3
Xu3_p2 u3 d2 vdd vdd sky130_fd_pr__pfet_01v8 W=0.85 L=0.3
Xu3_n1 u3 in u3_m vss sky130_fd_pr__nfet_01v8 W=0.84 L=0.3
Xu3_n2 u3_m d2 vss vss sky130_fd_pr__nfet_01v8 W=0.84 L=0.3
Xout_n out u3 vss vss sky130_fd_pr__nfet_01v8 W=0.42 L=0.3
Xout_p out u3 vdd vdd sky130_fd_pr__pfet_01v8 W=0.85 L=0.3
Xcu3 u3 vss sky130_fd_pr__cap_mim_m3_1 W=8.07 L=8.07
Xcout out vss sky130_fd_pr__cap_mim_m3_1 W=8.07 L=8.07
.ends dly_acq

.subckt dly_acq1 in out vdd vss
Xu0_p1 u0 in vdd vdd sky130_fd_pr__pfet_01v8 W=1.18 L=2.4
Xu0_p2 u0 in vdd vdd sky130_fd_pr__pfet_01v8 W=1.18 L=2.4
Xu0_n1 u0 in u0_m vss sky130_fd_pr__nfet_01v8 W=0.84 L=2.4
Xu0_n2 u0_m in vss vss sky130_fd_pr__nfet_01v8 W=0.84 L=2.4
Xd0_n d0 u0 vss vss sky130_fd_pr__nfet_01v8 W=0.42 L=2.4
Xd0_p d0 u0 vdd vdd sky130_fd_pr__pfet_01v8 W=1.18 L=2.4
Xcu0 u0 vss sky130_fd_pr__cap_mim_m3_1 W=7.81 L=7.81
Xcd0 d0 vss sky130_fd_pr__cap_mim_m3_1 W=7.81 L=7.81
Xu1_p1 u1 in vdd vdd sky130_fd_pr__pfet_01v8 W=1.18 L=2.4
Xu1_p2 u1 d0 vdd vdd sky130_fd_pr__pfet_01v8 W=1.18 L=2.4
Xu1_n1 u1 in u1_m vss sky130_fd_pr__nfet_01v8 W=0.84 L=2.4
Xu1_n2 u1_m d0 vss vss sky130_fd_pr__nfet_01v8 W=0.84 L=2.4
Xd1_n d1 u1 vss vss sky130_fd_pr__nfet_01v8 W=0.42 L=2.4
Xd1_p d1 u1 vdd vdd sky130_fd_pr__pfet_01v8 W=1.18 L=2.4
Xcu1 u1 vss sky130_fd_pr__cap_mim_m3_1 W=7.81 L=7.81
Xcd1 d1 vss sky130_fd_pr__cap_mim_m3_1 W=7.81 L=7.81
Xu2_p1 u2 in vdd vdd sky130_fd_pr__pfet_01v8 W=1.18 L=2.4
Xu2_p2 u2 d1 vdd vdd sky130_fd_pr__pfet_01v8 W=1.18 L=2.4
Xu2_n1 u2 in u2_m vss sky130_fd_pr__nfet_01v8 W=0.84 L=2.4
Xu2_n2 u2_m d1 vss vss sky130_fd_pr__nfet_01v8 W=0.84 L=2.4
Xd2_n d2 u2 vss vss sky130_fd_pr__nfet_01v8 W=0.42 L=2.4
Xd2_p d2 u2 vdd vdd sky130_fd_pr__pfet_01v8 W=1.18 L=2.4
Xcu2 u2 vss sky130_fd_pr__cap_mim_m3_1 W=7.81 L=7.81
Xcd2 d2 vss sky130_fd_pr__cap_mim_m3_1 W=7.81 L=7.81
Xu3_p1 u3 in vdd vdd sky130_fd_pr__pfet_01v8 W=1.18 L=2.4
Xu3_p2 u3 d2 vdd vdd sky130_fd_pr__pfet_01v8 W=1.18 L=2.4
Xu3_n1 u3 in u3_m vss sky130_fd_pr__nfet_01v8 W=0.84 L=2.4
Xu3_n2 u3_m d2 vss vss sky130_fd_pr__nfet_01v8 W=0.84 L=2.4
Xout_n out u3 vss vss sky130_fd_pr__nfet_01v8 W=0.42 L=2.4
Xout_p out u3 vdd vdd sky130_fd_pr__pfet_01v8 W=1.18 L=2.4
Xcu3 u3 vss sky130_fd_pr__cap_mim_m3_1 W=7.81 L=7.81
Xcout out vss sky130_fd_pr__cap_mim_m3_1 W=7.81 L=7.81
.ends dly_acq1

.subckt dly_hold in out vdd vss
Xu0_p1 u0 in vdd vdd sky130_fd_pr__pfet_01v8 W=0.85 L=0.3
Xu0_p2 u0 in vdd vdd sky130_fd_pr__pfet_01v8 W=0.85 L=0.3
Xu0_n1 u0 in u0_m vss sky130_fd_pr__nfet_01v8 W=0.84 L=0.3
Xu0_n2 u0_m in vss vss sky130_fd_pr__nfet_01v8 W=0.84 L=0.3
Xd0_n d0 u0 vss vss sky130_fd_pr__nfet_01v8 W=0.42 L=0.3
Xd0_p d0 u0 vdd vdd sky130_fd_pr__pfet_01v8 W=0.85 L=0.3
Xcu0 u0 vss sky130_fd_pr__cap_mim_m3_1 W=8.36 L=8.36
Xcd0 d0 vss sky130_fd_pr__cap_mim_m3_1 W=8.36 L=8.36
Xu1_p1 u1 in vdd vdd sky130_fd_pr__pfet_01v8 W=0.85 L=0.3
Xu1_p2 u1 d0 vdd vdd sky130_fd_pr__pfet_01v8 W=0.85 L=0.3
Xu1_n1 u1 in u1_m vss sky130_fd_pr__nfet_01v8 W=0.84 L=0.3
Xu1_n2 u1_m d0 vss vss sky130_fd_pr__nfet_01v8 W=0.84 L=0.3
Xd1_n d1 u1 vss vss sky130_fd_pr__nfet_01v8 W=0.42 L=0.3
Xd1_p d1 u1 vdd vdd sky130_fd_pr__pfet_01v8 W=0.85 L=0.3
Xcu1 u1 vss sky130_fd_pr__cap_mim_m3_1 W=8.36 L=8.36
Xcd1 d1 vss sky130_fd_pr__cap_mim_m3_1 W=8.36 L=8.36
Xu2_p1 u2 in vdd vdd sky130_fd_pr__pfet_01v8 W=0.85 L=0.3
Xu2_p2 u2 d1 vdd vdd sky130_fd_pr__pfet_01v8 W=0.85 L=0.3
Xu2_n1 u2 in u2_m vss sky130_fd_pr__nfet_01v8 W=0.84 L=0.3
Xu2_n2 u2_m d1 vss vss sky130_fd_pr__nfet_01v8 W=0.84 L=0.3
Xd2_n d2 u2 vss vss sky130_fd_pr__nfet_01v8 W=0.42 L=0.3
Xd2_p d2 u2 vdd vdd sky130_fd_pr__pfet_01v8 W=0.85 L=0.3
Xcu2 u2 vss sky130_fd_pr__cap_mim_m3_1 W=8.36 L=8.36
Xcd2 d2 vss sky130_fd_pr__cap_mim_m3_1 W=8.36 L=8.36
Xu3_p1 u3 in vdd vdd sky130_fd_pr__pfet_01v8 W=0.85 L=0.3
Xu3_p2 u3 d2 vdd vdd sky130_fd_pr__pfet_01v8 W=0.85 L=0.3
Xu3_n1 u3 in u3_m vss sky130_fd_pr__nfet_01v8 W=0.84 L=0.3
Xu3_n2 u3_m d2 vss vss sky130_fd_pr__nfet_01v8 W=0.84 L=0.3
Xout_n out u3 vss vss sky130_fd_pr__nfet_01v8 W=0.42 L=0.3
Xout_p out u3 vdd vdd sky130_fd_pr__pfet_01v8 W=0.85 L=0.3
Xcu3 u3 vss sky130_fd_pr__cap_mim_m3_1 W=8.36 L=8.36
Xcout out vss sky130_fd_pr__cap_mim_m3_1 W=8.36 L=8.36
.ends dly_hold

.subckt dly_fhi in out vdd vss
Xu0_p1 u0 in vdd vdd sky130_fd_pr__pfet_01v8 W=0.7 L=0.15
Xu0_p2 u0 in vdd vdd sky130_fd_pr__pfet_01v8 W=0.7 L=0.15
Xu0_n1 u0 in u0_m vss sky130_fd_pr__nfet_01v8 W=0.84 L=0.15
Xu0_n2 u0_m in vss vss sky130_fd_pr__nfet_01v8 W=0.84 L=0.15
Xd0_n d0 u0 vss vss sky130_fd_pr__nfet_01v8 W=0.42 L=0.15
Xd0_p d0 u0 vdd vdd sky130_fd_pr__pfet_01v8 W=0.7 L=0.15
Xcu0 u0 vss sky130_fd_pr__cap_mim_m3_1 W=5.65 L=5.65
Xcd0 d0 vss sky130_fd_pr__cap_mim_m3_1 W=5.65 L=5.65
Xu1_p1 u1 in vdd vdd sky130_fd_pr__pfet_01v8 W=0.7 L=0.15
Xu1_p2 u1 d0 vdd vdd sky130_fd_pr__pfet_01v8 W=0.7 L=0.15
Xu1_n1 u1 in u1_m vss sky130_fd_pr__nfet_01v8 W=0.84 L=0.15
Xu1_n2 u1_m d0 vss vss sky130_fd_pr__nfet_01v8 W=0.84 L=0.15
Xd1_n d1 u1 vss vss sky130_fd_pr__nfet_01v8 W=0.42 L=0.15
Xd1_p d1 u1 vdd vdd sky130_fd_pr__pfet_01v8 W=0.7 L=0.15
Xcu1 u1 vss sky130_fd_pr__cap_mim_m3_1 W=5.65 L=5.65
Xcd1 d1 vss sky130_fd_pr__cap_mim_m3_1 W=5.65 L=5.65
Xu2_p1 u2 in vdd vdd sky130_fd_pr__pfet_01v8 W=0.7 L=0.15
Xu2_p2 u2 d1 vdd vdd sky130_fd_pr__pfet_01v8 W=0.7 L=0.15
Xu2_n1 u2 in u2_m vss sky130_fd_pr__nfet_01v8 W=0.84 L=0.15
Xu2_n2 u2_m d1 vss vss sky130_fd_pr__nfet_01v8 W=0.84 L=0.15
Xd2_n d2 u2 vss vss sky130_fd_pr__nfet_01v8 W=0.42 L=0.15
Xd2_p d2 u2 vdd vdd sky130_fd_pr__pfet_01v8 W=0.7 L=0.15
Xcu2 u2 vss sky130_fd_pr__cap_mim_m3_1 W=5.65 L=5.65
Xcd2 d2 vss sky130_fd_pr__cap_mim_m3_1 W=5.65 L=5.65
Xu3_p1 u3 in vdd vdd sky130_fd_pr__pfet_01v8 W=0.7 L=0.15
Xu3_p2 u3 d2 vdd vdd sky130_fd_pr__pfet_01v8 W=0.7 L=0.15
Xu3_n1 u3 in u3_m vss sky130_fd_pr__nfet_01v8 W=0.84 L=0.15
Xu3_n2 u3_m d2 vss vss sky130_fd_pr__nfet_01v8 W=0.84 L=0.15
Xout_n out u3 vss vss sky130_fd_pr__nfet_01v8 W=0.42 L=0.15
Xout_p out u3 vdd vdd sky130_fd_pr__pfet_01v8 W=0.7 L=0.15
Xcu3 u3 vss sky130_fd_pr__cap_mim_m3_1 W=5.65 L=5.65
Xcout out vss sky130_fd_pr__cap_mim_m3_1 W=5.65 L=5.65
.ends dly_fhi

.subckt chop_gen p phi1r phi1er phi2r ck vdd vss
Xn_1_n n_1 p vss vss sky130_fd_pr__nfet_01v8 W=0.42 L=0.15
Xn_1_p n_1 p vdd vdd sky130_fd_pr__pfet_01v8 W=0.7 L=0.15
Xn_2_n n_2 p vss vss sky130_fd_pr__nfet_01v8 W=0.42 L=0.15
Xn_2_p n_2 p vdd vdd sky130_fd_pr__pfet_01v8 W=0.7 L=0.15
Xcm1 n_2 vss sky130_fd_pr__cap_mim_m3_1 W=2.05 L=2.05
Xdl1_n dl1 n_2 vss vss sky130_fd_pr__nfet_01v8 W=0.42 L=0.15
Xdl1_p dl1 n_2 vdd vdd sky130_fd_pr__pfet_01v8 W=0.7 L=0.15
Xcd1 dl1 vss sky130_fd_pr__cap_mim_m3_1 W=2.05 L=2.05
Xn_3_n n_3 dl1 vss vss sky130_fd_pr__nfet_01v8 W=0.42 L=0.15
Xn_3_p n_3 dl1 vdd vdd sky130_fd_pr__pfet_01v8 W=0.7 L=0.15
Xn_4_n n_4 dl1 vss vss sky130_fd_pr__nfet_01v8 W=0.42 L=0.15
Xn_4_p n_4 dl1 vdd vdd sky130_fd_pr__pfet_01v8 W=0.7 L=0.15
Xcm2 n_4 vss sky130_fd_pr__cap_mim_m3_1 W=2.05 L=2.05
Xdl2_n dl2 n_4 vss vss sky130_fd_pr__nfet_01v8 W=0.42 L=0.15
Xdl2_p dl2 n_4 vdd vdd sky130_fd_pr__pfet_01v8 W=0.7 L=0.15
Xcd2 dl2 vss sky130_fd_pr__cap_mim_m3_1 W=2.05 L=2.05
Xn_5_n n_5 dl2 vss vss sky130_fd_pr__nfet_01v8 W=0.42 L=0.15
Xn_5_p n_5 dl2 vdd vdd sky130_fd_pr__pfet_01v8 W=0.7 L=0.15
Xn_6_n n_6 dl2 vss vss sky130_fd_pr__nfet_01v8 W=0.42 L=0.15
Xn_6_p n_6 dl2 vdd vdd sky130_fd_pr__pfet_01v8 W=0.7 L=0.15
Xcm3 n_6 vss sky130_fd_pr__cap_mim_m3_1 W=2.05 L=2.05
Xdl3_n dl3 n_6 vss vss sky130_fd_pr__nfet_01v8 W=0.42 L=0.15
Xdl3_p dl3 n_6 vdd vdd sky130_fd_pr__pfet_01v8 W=0.7 L=0.15
Xcd3 dl3 vss sky130_fd_pr__cap_mim_m3_1 W=2.05 L=2.05
Xn_7_n n_7 dl3 vss vss sky130_fd_pr__nfet_01v8 W=0.42 L=0.15
Xn_7_p n_7 dl3 vdd vdd sky130_fd_pr__pfet_01v8 W=0.7 L=0.15
Xn_8_n n_8 dl3 vss vss sky130_fd_pr__nfet_01v8 W=0.42 L=0.15
Xn_8_p n_8 dl3 vdd vdd sky130_fd_pr__pfet_01v8 W=0.7 L=0.15
Xcm4 n_8 vss sky130_fd_pr__cap_mim_m3_1 W=2.05 L=2.05
Xdl4_n dl4 n_8 vss vss sky130_fd_pr__nfet_01v8 W=0.42 L=0.15
Xdl4_p dl4 n_8 vdd vdd sky130_fd_pr__pfet_01v8 W=0.7 L=0.15
Xcd4 dl4 vss sky130_fd_pr__cap_mim_m3_1 W=2.05 L=2.05
Xn_9_n n_9 dl4 vss vss sky130_fd_pr__nfet_01v8 W=0.42 L=0.15
Xn_9_p n_9 dl4 vdd vdd sky130_fd_pr__pfet_01v8 W=0.7 L=0.15
Xn_10_n n_10 dl4 vss vss sky130_fd_pr__nfet_01v8 W=0.42 L=0.15
Xn_10_p n_10 dl4 vdd vdd sky130_fd_pr__pfet_01v8 W=0.7 L=0.15
Xcm5 n_10 vss sky130_fd_pr__cap_mim_m3_1 W=2.05 L=2.05
Xdl5_n dl5 n_10 vss vss sky130_fd_pr__nfet_01v8 W=0.42 L=0.15
Xdl5_p dl5 n_10 vdd vdd sky130_fd_pr__pfet_01v8 W=0.7 L=0.15
Xcd5 dl5 vss sky130_fd_pr__cap_mim_m3_1 W=2.05 L=2.05
Xn_11_n n_11 dl5 vss vss sky130_fd_pr__nfet_01v8 W=0.42 L=0.15
Xn_11_p n_11 dl5 vdd vdd sky130_fd_pr__pfet_01v8 W=0.7 L=0.15
Xn_12_n n_12 dl5 vss vss sky130_fd_pr__nfet_01v8 W=0.42 L=0.15
Xn_12_p n_12 dl5 vdd vdd sky130_fd_pr__pfet_01v8 W=0.7 L=0.15
Xcm6 n_12 vss sky130_fd_pr__cap_mim_m3_1 W=2.05 L=2.05
Xdl6_n dl6 n_12 vss vss sky130_fd_pr__nfet_01v8 W=0.42 L=0.15
Xdl6_p dl6 n_12 vdd vdd sky130_fd_pr__pfet_01v8 W=0.7 L=0.15
Xcd6 dl6 vss sky130_fd_pr__cap_mim_m3_1 W=2.05 L=2.05
Xn_13_n n_13 dl6 vss vss sky130_fd_pr__nfet_01v8 W=0.42 L=0.15
Xn_13_p n_13 dl6 vdd vdd sky130_fd_pr__pfet_01v8 W=0.7 L=0.15
Xn_14_n n_14 dl6 vss vss sky130_fd_pr__nfet_01v8 W=0.42 L=0.15
Xn_14_p n_14 dl6 vdd vdd sky130_fd_pr__pfet_01v8 W=0.7 L=0.15
Xcm7 n_14 vss sky130_fd_pr__cap_mim_m3_1 W=2.05 L=2.05
Xdl7_n dl7 n_14 vss vss sky130_fd_pr__nfet_01v8 W=0.42 L=0.15
Xdl7_p dl7 n_14 vdd vdd sky130_fd_pr__pfet_01v8 W=0.7 L=0.15
Xcd7 dl7 vss sky130_fd_pr__cap_mim_m3_1 W=2.05 L=2.05
Xn_15_n n_15 dl7 vss vss sky130_fd_pr__nfet_01v8 W=0.42 L=0.15
Xn_15_p n_15 dl7 vdd vdd sky130_fd_pr__pfet_01v8 W=0.7 L=0.15
Xn_16_n n_16 dl7 vss vss sky130_fd_pr__nfet_01v8 W=0.42 L=0.15
Xn_16_p n_16 dl7 vdd vdd sky130_fd_pr__pfet_01v8 W=0.7 L=0.15
Xcm8 n_16 vss sky130_fd_pr__cap_mim_m3_1 W=2.05 L=2.05
Xdl8_n dl8 n_16 vss vss sky130_fd_pr__nfet_01v8 W=0.42 L=0.15
Xdl8_p dl8 n_16 vdd vdd sky130_fd_pr__pfet_01v8 W=0.7 L=0.15
Xcd8 dl8 vss sky130_fd_pr__cap_mim_m3_1 W=2.05 L=2.05
Xn_17_n n_17 dl8 vss vss sky130_fd_pr__nfet_01v8 W=0.42 L=0.15
Xn_17_p n_17 dl8 vdd vdd sky130_fd_pr__pfet_01v8 W=0.7 L=0.15
Xn_18_n n_18 dl8 vss vss sky130_fd_pr__nfet_01v8 W=0.42 L=0.15
Xn_18_p n_18 dl8 vdd vdd sky130_fd_pr__pfet_01v8 W=0.7 L=0.15
Xcm9 n_18 vss sky130_fd_pr__cap_mim_m3_1 W=2.05 L=2.05
Xdl9_n dl9 n_18 vss vss sky130_fd_pr__nfet_01v8 W=0.42 L=0.15
Xdl9_p dl9 n_18 vdd vdd sky130_fd_pr__pfet_01v8 W=0.7 L=0.15
Xcd9 dl9 vss sky130_fd_pr__cap_mim_m3_1 W=2.05 L=2.05
Xn_19_n n_19 dl9 vss vss sky130_fd_pr__nfet_01v8 W=0.42 L=0.15
Xn_19_p n_19 dl9 vdd vdd sky130_fd_pr__pfet_01v8 W=0.7 L=0.15
Xn_20_n n_20 dl9 vss vss sky130_fd_pr__nfet_01v8 W=0.42 L=0.15
Xn_20_p n_20 dl9 vdd vdd sky130_fd_pr__pfet_01v8 W=0.7 L=0.15
Xcm10 n_20 vss sky130_fd_pr__cap_mim_m3_1 W=2.05 L=2.05
Xdl10_n dl10 n_20 vss vss sky130_fd_pr__nfet_01v8 W=0.42 L=0.15
Xdl10_p dl10 n_20 vdd vdd sky130_fd_pr__pfet_01v8 W=0.7 L=0.15
Xcd10 dl10 vss sky130_fd_pr__cap_mim_m3_1 W=2.05 L=2.05
Xn_21_n n_21 dl10 vss vss sky130_fd_pr__nfet_01v8 W=0.42 L=0.15
Xn_21_p n_21 dl10 vdd vdd sky130_fd_pr__pfet_01v8 W=0.7 L=0.15
Xn_22_n n_22 dl10 vss vss sky130_fd_pr__nfet_01v8 W=0.42 L=0.15
Xn_22_p n_22 dl10 vdd vdd sky130_fd_pr__pfet_01v8 W=0.7 L=0.15
Xcm11 n_22 vss sky130_fd_pr__cap_mim_m3_1 W=2.05 L=2.05
Xdl11_n dl11 n_22 vss vss sky130_fd_pr__nfet_01v8 W=0.42 L=0.15
Xdl11_p dl11 n_22 vdd vdd sky130_fd_pr__pfet_01v8 W=0.7 L=0.15
Xcd11 dl11 vss sky130_fd_pr__cap_mim_m3_1 W=2.05 L=2.05
Xn_23_n n_23 dl11 vss vss sky130_fd_pr__nfet_01v8 W=0.42 L=0.15
Xn_23_p n_23 dl11 vdd vdd sky130_fd_pr__pfet_01v8 W=0.7 L=0.15
Xn_24_n n_24 dl11 vss vss sky130_fd_pr__nfet_01v8 W=0.42 L=0.15
Xn_24_p n_24 dl11 vdd vdd sky130_fd_pr__pfet_01v8 W=0.7 L=0.15
Xcm12 n_24 vss sky130_fd_pr__cap_mim_m3_1 W=2.05 L=2.05
Xdl12_n dl12 n_24 vss vss sky130_fd_pr__nfet_01v8 W=0.42 L=0.15
Xdl12_p dl12 n_24 vdd vdd sky130_fd_pr__pfet_01v8 W=0.7 L=0.15
Xcd12 dl12 vss sky130_fd_pr__cap_mim_m3_1 W=2.05 L=2.05
Xn_25_n n_25 dl12 vss vss sky130_fd_pr__nfet_01v8 W=0.42 L=0.15
Xn_25_p n_25 dl12 vdd vdd sky130_fd_pr__pfet_01v8 W=0.7 L=0.15
Xn_26_n n_26 dl12 vss vss sky130_fd_pr__nfet_01v8 W=0.42 L=0.15
Xn_26_p n_26 dl12 vdd vdd sky130_fd_pr__pfet_01v8 W=0.7 L=0.15
Xcm13 n_26 vss sky130_fd_pr__cap_mim_m3_1 W=2.05 L=2.05
Xdl13_n dl13 n_26 vss vss sky130_fd_pr__nfet_01v8 W=0.42 L=0.15
Xdl13_p dl13 n_26 vdd vdd sky130_fd_pr__pfet_01v8 W=0.7 L=0.15
Xcd13 dl13 vss sky130_fd_pr__cap_mim_m3_1 W=2.05 L=2.05
Xn_27_n n_27 dl13 vss vss sky130_fd_pr__nfet_01v8 W=0.42 L=0.15
Xn_27_p n_27 dl13 vdd vdd sky130_fd_pr__pfet_01v8 W=0.7 L=0.15
Xn_28_n n_28 dl13 vss vss sky130_fd_pr__nfet_01v8 W=0.42 L=0.15
Xn_28_p n_28 dl13 vdd vdd sky130_fd_pr__pfet_01v8 W=0.7 L=0.15
Xcm14 n_28 vss sky130_fd_pr__cap_mim_m3_1 W=2.05 L=2.05
Xdl14_n dl14 n_28 vss vss sky130_fd_pr__nfet_01v8 W=0.42 L=0.15
Xdl14_p dl14 n_28 vdd vdd sky130_fd_pr__pfet_01v8 W=0.7 L=0.15
Xcd14 dl14 vss sky130_fd_pr__cap_mim_m3_1 W=2.05 L=2.05
Xn_29_n n_29 dl14 vss vss sky130_fd_pr__nfet_01v8 W=0.42 L=0.15
Xn_29_p n_29 dl14 vdd vdd sky130_fd_pr__pfet_01v8 W=0.7 L=0.15
Xn_30_n n_30 dl14 vss vss sky130_fd_pr__nfet_01v8 W=0.42 L=0.15
Xn_30_p n_30 dl14 vdd vdd sky130_fd_pr__pfet_01v8 W=0.7 L=0.15
Xcm15 n_30 vss sky130_fd_pr__cap_mim_m3_1 W=2.05 L=2.05
Xdl15_n dl15 n_30 vss vss sky130_fd_pr__nfet_01v8 W=0.42 L=0.15
Xdl15_p dl15 n_30 vdd vdd sky130_fd_pr__pfet_01v8 W=0.7 L=0.15
Xcd15 dl15 vss sky130_fd_pr__cap_mim_m3_1 W=2.05 L=2.05
Xn_31_n n_31 dl15 vss vss sky130_fd_pr__nfet_01v8 W=0.42 L=0.15
Xn_31_p n_31 dl15 vdd vdd sky130_fd_pr__pfet_01v8 W=0.7 L=0.15
Xn_32_p1 n_32 n_1 vdd vdd sky130_fd_pr__pfet_01v8 W=0.7 L=0.15
Xn_32_p2 n_32 n_9 vdd vdd sky130_fd_pr__pfet_01v8 W=0.7 L=0.15
Xn_32_n1 n_32 n_1 n_32_x vss sky130_fd_pr__nfet_01v8 W=0.84 L=0.15
Xn_32_n2 n_32_x n_9 vss vss sky130_fd_pr__nfet_01v8 W=0.84 L=0.15
Xn_33_p1 n_33 n_1 vdd vdd sky130_fd_pr__pfet_01v8 W=0.7 L=0.15
Xn_33_p2 n_33 n_32 vdd vdd sky130_fd_pr__pfet_01v8 W=0.7 L=0.15
Xn_33_n1 n_33 n_1 n_33_x vss sky130_fd_pr__nfet_01v8 W=0.84 L=0.15
Xn_33_n2 n_33_x n_32 vss vss sky130_fd_pr__nfet_01v8 W=0.84 L=0.15
Xn_34_p1 n_34 n_9 vdd vdd sky130_fd_pr__pfet_01v8 W=0.7 L=0.15
Xn_34_p2 n_34 n_32 vdd vdd sky130_fd_pr__pfet_01v8 W=0.7 L=0.15
Xn_34_n1 n_34 n_9 n_34_x vss sky130_fd_pr__nfet_01v8 W=0.84 L=0.15
Xn_34_n2 n_34_x n_32 vss vss sky130_fd_pr__nfet_01v8 W=0.84 L=0.15
Xn_35_p1 n_35 n_33 vdd vdd sky130_fd_pr__pfet_01v8 W=0.7 L=0.15
Xn_35_p2 n_35 n_34 vdd vdd sky130_fd_pr__pfet_01v8 W=0.7 L=0.15
Xn_35_n1 n_35 n_33 n_35_x vss sky130_fd_pr__nfet_01v8 W=0.84 L=0.15
Xn_35_n2 n_35_x n_34 vss vss sky130_fd_pr__nfet_01v8 W=0.84 L=0.15
Xn_36_p1 n_36 n_1 vdd vdd sky130_fd_pr__pfet_01v8 W=0.7 L=0.15
Xn_36_p2 n_36 n_25 vdd vdd sky130_fd_pr__pfet_01v8 W=0.7 L=0.15
Xn_36_n1 n_36 n_1 n_36_x vss sky130_fd_pr__nfet_01v8 W=0.84 L=0.15
Xn_36_n2 n_36_x n_25 vss vss sky130_fd_pr__nfet_01v8 W=0.84 L=0.15
Xn_37_p1 n_37 n_1 vdd vdd sky130_fd_pr__pfet_01v8 W=0.7 L=0.15
Xn_37_p2 n_37 n_36 vdd vdd sky130_fd_pr__pfet_01v8 W=0.7 L=0.15
Xn_37_n1 n_37 n_1 n_37_x vss sky130_fd_pr__nfet_01v8 W=0.84 L=0.15
Xn_37_n2 n_37_x n_36 vss vss sky130_fd_pr__nfet_01v8 W=0.84 L=0.15
Xn_38_p1 n_38 n_25 vdd vdd sky130_fd_pr__pfet_01v8 W=0.7 L=0.15
Xn_38_p2 n_38 n_36 vdd vdd sky130_fd_pr__pfet_01v8 W=0.7 L=0.15
Xn_38_n1 n_38 n_25 n_38_x vss sky130_fd_pr__nfet_01v8 W=0.84 L=0.15
Xn_38_n2 n_38_x n_36 vss vss sky130_fd_pr__nfet_01v8 W=0.84 L=0.15
Xn_39_p1 n_39 n_37 vdd vdd sky130_fd_pr__pfet_01v8 W=0.7 L=0.15
Xn_39_p2 n_39 n_38 vdd vdd sky130_fd_pr__pfet_01v8 W=0.7 L=0.15
Xn_39_n1 n_39 n_37 n_39_x vss sky130_fd_pr__nfet_01v8 W=0.84 L=0.15
Xn_39_n2 n_39_x n_38 vss vss sky130_fd_pr__nfet_01v8 W=0.84 L=0.15
Xn_40_p1 n_40 n_1 vdd vdd sky130_fd_pr__pfet_01v8 W=0.7 L=0.15
Xn_40_p2 n_40 n_27 vdd vdd sky130_fd_pr__pfet_01v8 W=0.7 L=0.15
Xn_40_n1 n_40 n_1 n_40_x vss sky130_fd_pr__nfet_01v8 W=0.84 L=0.15
Xn_40_n2 n_40_x n_27 vss vss sky130_fd_pr__nfet_01v8 W=0.84 L=0.15
Xn_41_p1 n_41 n_1 vdd vdd sky130_fd_pr__pfet_01v8 W=0.7 L=0.15
Xn_41_p2 n_41 n_40 vdd vdd sky130_fd_pr__pfet_01v8 W=0.7 L=0.15
Xn_41_n1 n_41 n_1 n_41_x vss sky130_fd_pr__nfet_01v8 W=0.84 L=0.15
Xn_41_n2 n_41_x n_40 vss vss sky130_fd_pr__nfet_01v8 W=0.84 L=0.15
Xn_42_p1 n_42 n_27 vdd vdd sky130_fd_pr__pfet_01v8 W=0.7 L=0.15
Xn_42_p2 n_42 n_40 vdd vdd sky130_fd_pr__pfet_01v8 W=0.7 L=0.15
Xn_42_n1 n_42 n_27 n_42_x vss sky130_fd_pr__nfet_01v8 W=0.84 L=0.15
Xn_42_n2 n_42_x n_40 vss vss sky130_fd_pr__nfet_01v8 W=0.84 L=0.15
Xn_43_p1 n_43 n_41 vdd vdd sky130_fd_pr__pfet_01v8 W=0.7 L=0.15
Xn_43_p2 n_43 n_42 vdd vdd sky130_fd_pr__pfet_01v8 W=0.7 L=0.15
Xn_43_n1 n_43 n_41 n_43_x vss sky130_fd_pr__nfet_01v8 W=0.84 L=0.15
Xn_43_n2 n_43_x n_42 vss vss sky130_fd_pr__nfet_01v8 W=0.84 L=0.15
Xn_44_p1 n_44 n_1 vdd vdd sky130_fd_pr__pfet_01v8 W=0.7 L=0.15
Xn_44_p2 n_44 n_31 vdd vdd sky130_fd_pr__pfet_01v8 W=0.7 L=0.15
Xn_44_n1 n_44 n_1 n_44_x vss sky130_fd_pr__nfet_01v8 W=0.84 L=0.15
Xn_44_n2 n_44_x n_31 vss vss sky130_fd_pr__nfet_01v8 W=0.84 L=0.15
Xn_45_p1 n_45 n_1 vdd vdd sky130_fd_pr__pfet_01v8 W=0.7 L=0.15
Xn_45_p2 n_45 n_44 vdd vdd sky130_fd_pr__pfet_01v8 W=0.7 L=0.15
Xn_45_n1 n_45 n_1 n_45_x vss sky130_fd_pr__nfet_01v8 W=0.84 L=0.15
Xn_45_n2 n_45_x n_44 vss vss sky130_fd_pr__nfet_01v8 W=0.84 L=0.15
Xn_46_p1 n_46 n_31 vdd vdd sky130_fd_pr__pfet_01v8 W=0.7 L=0.15
Xn_46_p2 n_46 n_44 vdd vdd sky130_fd_pr__pfet_01v8 W=0.7 L=0.15
Xn_46_n1 n_46 n_31 n_46_x vss sky130_fd_pr__nfet_01v8 W=0.84 L=0.15
Xn_46_n2 n_46_x n_44 vss vss sky130_fd_pr__nfet_01v8 W=0.84 L=0.15
Xn_47_p1 n_47 n_45 vdd vdd sky130_fd_pr__pfet_01v8 W=0.7 L=0.15
Xn_47_p2 n_47 n_46 vdd vdd sky130_fd_pr__pfet_01v8 W=0.7 L=0.15
Xn_47_n1 n_47 n_45 n_47_x vss sky130_fd_pr__nfet_01v8 W=0.84 L=0.15
Xn_47_n2 n_47_x n_46 vss vss sky130_fd_pr__nfet_01v8 W=0.84 L=0.15
Xn_48_n n_48 n_35 vss vss sky130_fd_pr__nfet_01v8 W=0.42 L=0.15
Xn_48_p n_48 n_35 vdd vdd sky130_fd_pr__pfet_01v8 W=0.7 L=0.15
Xn_49_p1 n_49 n_39 vdd vdd sky130_fd_pr__pfet_01v8 W=0.7 L=0.15
Xn_49_p2 n_49 n_48 vdd vdd sky130_fd_pr__pfet_01v8 W=0.7 L=0.15
Xn_49_n1 n_49 n_39 n_49_x vss sky130_fd_pr__nfet_01v8 W=0.84 L=0.15
Xn_49_n2 n_49_x n_48 vss vss sky130_fd_pr__nfet_01v8 W=0.84 L=0.15
Xphi1r_n phi1r n_49 vss vss sky130_fd_pr__nfet_01v8 W=0.42 L=0.15
Xphi1r_p phi1r n_49 vdd vdd sky130_fd_pr__pfet_01v8 W=0.7 L=0.15
Xn_50_p1 n_50 n_43 vdd vdd sky130_fd_pr__pfet_01v8 W=0.7 L=0.15
Xn_50_p2 n_50 n_48 vdd vdd sky130_fd_pr__pfet_01v8 W=0.7 L=0.15
Xn_50_n1 n_50 n_43 n_50_x vss sky130_fd_pr__nfet_01v8 W=0.84 L=0.15
Xn_50_n2 n_50_x n_48 vss vss sky130_fd_pr__nfet_01v8 W=0.84 L=0.15
Xphi1er_n phi1er n_50 vss vss sky130_fd_pr__nfet_01v8 W=0.42 L=0.15
Xphi1er_p phi1er n_50 vdd vdd sky130_fd_pr__pfet_01v8 W=0.7 L=0.15
Xphi2r_n phi2r n_47 vss vss sky130_fd_pr__nfet_01v8 W=0.42 L=0.15
Xphi2r_p phi2r n_47 vdd vdd sky130_fd_pr__pfet_01v8 W=0.7 L=0.15
Xck_n ck n_48 vss vss sky130_fd_pr__nfet_01v8 W=0.42 L=0.15
Xck_p ck n_48 vdd vdd sky130_fd_pr__pfet_01v8 W=0.7 L=0.15
.ends chop_gen

.subckt conv_seq rst_n sgo phi1 phi2 coarse_en cb_ack cmp_req ota_en pkt_d0 pkt_d1 pkt_d2 c1p c1n c2p c2n sdone col_sign cb_req cb_cross cmp_ack cmp_result busy run fire sign sgd clk_c acq clk_f awake vdd vss
Xxn_28 n_27 n_28 vdd vss dly_pace
Xxn_86 n_85 n_86 vdd vss dly_bundle
Xxn_216 cmp_req n_216 vdd vss dly_acq
Xxn_217 cmp_req n_217 vdd vss dly_acq1
Xxn_225 n_223 n_225 vdd vss dly_hold
Xxn_241 n_240 n_241 vdd vss dly_fhi
Xxn_261 n_260 n_261 vdd vss dly_bundle
Xn_1_p1 n_1 rst_n vdd vdd sky130_fd_pr__pfet_01v8 W=0.7 L=0.15
Xn_1_p2 n_1 sgo vdd vdd sky130_fd_pr__pfet_01v8 W=0.7 L=0.15
Xn_1_n1 n_1 rst_n n_1_x vss sky130_fd_pr__nfet_01v8 W=0.84 L=0.15
Xn_1_n2 n_1_x sgo vss vss sky130_fd_pr__nfet_01v8 W=0.84 L=0.15
Xn_2_n n_2 c1n vss vss sky130_fd_pr__nfet_01v8 W=0.42 L=0.15
Xn_2_p n_2 c1n vdd vdd sky130_fd_pr__pfet_01v8 W=0.7 L=0.15
Xn_3_p1 n_3 c1p n_3_x vdd sky130_fd_pr__pfet_01v8 W=1.4 L=0.15
Xn_3_p2 n_3_x n_2 vdd vdd sky130_fd_pr__pfet_01v8 W=1.4 L=0.15
Xn_3_n1 n_3 c1p vss vss sky130_fd_pr__nfet_01v8 W=0.42 L=0.15
Xn_3_n2 n_3 n_2 vss vss sky130_fd_pr__nfet_01v8 W=0.42 L=0.15
Xn_4_n n_4 c1p vss vss sky130_fd_pr__nfet_01v8 W=0.42 L=0.15
Xn_4_p n_4 c1p vdd vdd sky130_fd_pr__pfet_01v8 W=0.7 L=0.15
Xn_5_p1 n_5 c1n n_5_x vdd sky130_fd_pr__pfet_01v8 W=1.4 L=0.15
Xn_5_p2 n_5_x n_4 vdd vdd sky130_fd_pr__pfet_01v8 W=1.4 L=0.15
Xn_5_n1 n_5 c1n vss vss sky130_fd_pr__nfet_01v8 W=0.42 L=0.15
Xn_5_n2 n_5 n_4 vss vss sky130_fd_pr__nfet_01v8 W=0.42 L=0.15
Xn_6_p1 n_6 n_3 n_6_x vdd sky130_fd_pr__pfet_01v8 W=1.4 L=0.15
Xn_6_p2 n_6_x n_5 vdd vdd sky130_fd_pr__pfet_01v8 W=1.4 L=0.15
Xn_6_n1 n_6 n_3 vss vss sky130_fd_pr__nfet_01v8 W=0.42 L=0.15
Xn_6_n2 n_6 n_5 vss vss sky130_fd_pr__nfet_01v8 W=0.42 L=0.15
Xn_7_n n_7 n_6 vss vss sky130_fd_pr__nfet_01v8 W=0.42 L=0.15
Xn_7_p n_7 n_6 vdd vdd sky130_fd_pr__pfet_01v8 W=0.7 L=0.15
Xn_8_n n_8 sgd vss vss sky130_fd_pr__nfet_01v8 W=0.42 L=0.15
Xn_8_p n_8 sgd vdd vdd sky130_fd_pr__pfet_01v8 W=0.7 L=0.15
Xn_9_p1 n_9 n_3 vdd vdd sky130_fd_pr__pfet_01v8 W=0.7 L=0.15
Xn_9_p2 n_9 n_8 vdd vdd sky130_fd_pr__pfet_01v8 W=0.7 L=0.15
Xn_9_n1 n_9 n_3 n_9_x vss sky130_fd_pr__nfet_01v8 W=0.84 L=0.15
Xn_9_n2 n_9_x n_8 vss vss sky130_fd_pr__nfet_01v8 W=0.84 L=0.15
Xn_10_n n_10 n_9 vss vss sky130_fd_pr__nfet_01v8 W=0.42 L=0.15
Xn_10_p n_10 n_9 vdd vdd sky130_fd_pr__pfet_01v8 W=0.7 L=0.15
Xn_11_p1 n_11 n_5 vdd vdd sky130_fd_pr__pfet_01v8 W=0.7 L=0.15
Xn_11_p2 n_11 n_8 vdd vdd sky130_fd_pr__pfet_01v8 W=0.7 L=0.15
Xn_11_n1 n_11 n_5 n_11_x vss sky130_fd_pr__nfet_01v8 W=0.84 L=0.15
Xn_11_n2 n_11_x n_8 vss vss sky130_fd_pr__nfet_01v8 W=0.84 L=0.15
Xn_12_n n_12 n_11 vss vss sky130_fd_pr__nfet_01v8 W=0.42 L=0.15
Xn_12_p n_12 n_11 vdd vdd sky130_fd_pr__pfet_01v8 W=0.7 L=0.15
Xn_13_p1 n_13 n_12 n_13_x vdd sky130_fd_pr__pfet_01v8 W=1.4 L=0.15
Xn_13_p2 n_13_x n_1 vdd vdd sky130_fd_pr__pfet_01v8 W=1.4 L=0.15
Xn_13_n1 n_13 n_12 vss vss sky130_fd_pr__nfet_01v8 W=0.42 L=0.15
Xn_13_n2 n_13 n_1 vss vss sky130_fd_pr__nfet_01v8 W=0.42 L=0.15
Xn_14_n n_14 n_13 vss vss sky130_fd_pr__nfet_01v8 W=0.42 L=0.15
Xn_14_p n_14 n_13 vdd vdd sky130_fd_pr__pfet_01v8 W=0.7 L=0.15
Xn_15_p1 n_15 n_10 n_15_x vdd sky130_fd_pr__pfet_01v8 W=1.4 L=0.15
Xn_15_p2 n_15_x sign vdd vdd sky130_fd_pr__pfet_01v8 W=1.4 L=0.15
Xn_15_n1 n_15 n_10 vss vss sky130_fd_pr__nfet_01v8 W=0.42 L=0.15
Xn_15_n2 n_15 sign vss vss sky130_fd_pr__nfet_01v8 W=0.42 L=0.15
Xsign_p1 sign n_14 sign_x vdd sky130_fd_pr__pfet_01v8 W=1.4 L=0.15
Xsign_p2 sign_x n_15 vdd vdd sky130_fd_pr__pfet_01v8 W=1.4 L=0.15
Xsign_n1 sign n_14 vss vss sky130_fd_pr__nfet_01v8 W=0.42 L=0.15
Xsign_n2 sign n_15 vss vss sky130_fd_pr__nfet_01v8 W=0.42 L=0.15
Xn_16_p1 n_16 n_7 vdd vdd sky130_fd_pr__pfet_01v8 W=0.7 L=0.15
Xn_16_p2 n_16 n_8 vdd vdd sky130_fd_pr__pfet_01v8 W=0.7 L=0.15
Xn_16_n1 n_16 n_7 n_16_x vss sky130_fd_pr__nfet_01v8 W=0.84 L=0.15
Xn_16_n2 n_16_x n_8 vss vss sky130_fd_pr__nfet_01v8 W=0.84 L=0.15
Xn_17_n n_17 n_16 vss vss sky130_fd_pr__nfet_01v8 W=0.42 L=0.15
Xn_17_p n_17 n_16 vdd vdd sky130_fd_pr__pfet_01v8 W=0.7 L=0.15
Xn_19_p1 n_19 n_17 n_19_x vdd sky130_fd_pr__pfet_01v8 W=1.4 L=0.15
Xn_19_p2 n_19_x n_18 vdd vdd sky130_fd_pr__pfet_01v8 W=1.4 L=0.15
Xn_19_n1 n_19 n_17 vss vss sky130_fd_pr__nfet_01v8 W=0.42 L=0.15
Xn_19_n2 n_19 n_18 vss vss sky130_fd_pr__nfet_01v8 W=0.42 L=0.15
Xn_18_p1 n_18 n_1 n_18_x vdd sky130_fd_pr__pfet_01v8 W=1.4 L=0.15
Xn_18_p2 n_18_x n_19 vdd vdd sky130_fd_pr__pfet_01v8 W=1.4 L=0.15
Xn_18_n1 n_18 n_1 vss vss sky130_fd_pr__nfet_01v8 W=0.42 L=0.15
Xn_18_n2 n_18 n_19 vss vss sky130_fd_pr__nfet_01v8 W=0.42 L=0.15
Xn_20_p1 n_20 n_1 n_20_x vdd sky130_fd_pr__pfet_01v8 W=1.4 L=0.15
Xn_20_p2 n_20_x n_18 vdd vdd sky130_fd_pr__pfet_01v8 W=1.4 L=0.15
Xn_20_n1 n_20 n_1 vss vss sky130_fd_pr__nfet_01v8 W=0.42 L=0.15
Xn_20_n2 n_20 n_18 vss vss sky130_fd_pr__nfet_01v8 W=0.42 L=0.15
Xn_21_p1 n_21 n_7 n_21_x vdd sky130_fd_pr__pfet_01v8 W=1.4 L=0.15
Xn_21_p2 n_21_x clk_c vdd vdd sky130_fd_pr__pfet_01v8 W=1.4 L=0.15
Xn_21_n1 n_21 n_7 vss vss sky130_fd_pr__nfet_01v8 W=0.42 L=0.15
Xn_21_n2 n_21 clk_c vss vss sky130_fd_pr__nfet_01v8 W=0.42 L=0.15
Xn_22_p1 n_22 n_18 vdd vdd sky130_fd_pr__pfet_01v8 W=0.7 L=0.15
Xn_22_p2 n_22 n_21 vdd vdd sky130_fd_pr__pfet_01v8 W=0.7 L=0.15
Xn_22_n1 n_22 n_18 n_22_x vss sky130_fd_pr__nfet_01v8 W=0.84 L=0.15
Xn_22_n2 n_22_x n_21 vss vss sky130_fd_pr__nfet_01v8 W=0.84 L=0.15
Xn_23_n n_23 n_22 vss vss sky130_fd_pr__nfet_01v8 W=0.42 L=0.15
Xn_23_p n_23 n_22 vdd vdd sky130_fd_pr__pfet_01v8 W=0.7 L=0.15
Xn_24_p1 n_24 n_23 n_24_x vdd sky130_fd_pr__pfet_01v8 W=1.4 L=0.15
Xn_24_p2 n_24_x sgd vdd vdd sky130_fd_pr__pfet_01v8 W=1.4 L=0.15
Xn_24_n1 n_24 n_23 vss vss sky130_fd_pr__nfet_01v8 W=0.42 L=0.15
Xn_24_n2 n_24 sgd vss vss sky130_fd_pr__nfet_01v8 W=0.42 L=0.15
Xsgd_p1 sgd n_1 sgd_x vdd sky130_fd_pr__pfet_01v8 W=1.4 L=0.15
Xsgd_p2 sgd_x n_24 vdd vdd sky130_fd_pr__pfet_01v8 W=1.4 L=0.15
Xsgd_n1 sgd n_1 vss vss sky130_fd_pr__nfet_01v8 W=0.42 L=0.15
Xsgd_n2 sgd n_24 vss vss sky130_fd_pr__nfet_01v8 W=0.42 L=0.15
Xsdone_n sdone n_8 vss vss sky130_fd_pr__nfet_01v8 W=0.42 L=0.15
Xsdone_p sdone n_8 vdd vdd sky130_fd_pr__pfet_01v8 W=0.7 L=0.15
Xcol_sign_p1 col_sign sign col_sign_x vdd sky130_fd_pr__pfet_01v8 W=1.4 L=0.15
Xcol_sign_p2 col_sign_x n_8 vdd vdd sky130_fd_pr__pfet_01v8 W=1.4 L=0.15
Xcol_sign_n1 col_sign sign vss vss sky130_fd_pr__nfet_01v8 W=0.42 L=0.15
Xcol_sign_n2 col_sign n_8 vss vss sky130_fd_pr__nfet_01v8 W=0.42 L=0.15
Xn_25_n n_25 c_got vss vss sky130_fd_pr__nfet_01v8 W=0.42 L=0.15
Xn_25_p n_25 c_got vdd vdd sky130_fd_pr__pfet_01v8 W=0.7 L=0.15
Xn_26_p1 n_26 n_25 vdd vdd sky130_fd_pr__pfet_01v8 W=0.7 L=0.15
Xn_26_p2 n_26 sgd vdd vdd sky130_fd_pr__pfet_01v8 W=0.7 L=0.15
Xn_26_n1 n_26 n_25 n_26_x vss sky130_fd_pr__nfet_01v8 W=0.84 L=0.15
Xn_26_n2 n_26_x sgd vss vss sky130_fd_pr__nfet_01v8 W=0.84 L=0.15
Xn_27_n n_27 n_26 vss vss sky130_fd_pr__nfet_01v8 W=0.42 L=0.15
Xn_27_p n_27 n_26 vdd vdd sky130_fd_pr__pfet_01v8 W=0.7 L=0.15
Xn_29_p1 n_29 n_27 vdd vdd sky130_fd_pr__pfet_01v8 W=0.7 L=0.15
Xn_29_p2 n_29 n_28 vdd vdd sky130_fd_pr__pfet_01v8 W=0.7 L=0.15
Xn_29_n1 n_29 n_27 n_29_x vss sky130_fd_pr__nfet_01v8 W=0.84 L=0.15
Xn_29_n2 n_29_x n_28 vss vss sky130_fd_pr__nfet_01v8 W=0.84 L=0.15
Xn_30_n n_30 n_29 vss vss sky130_fd_pr__nfet_01v8 W=0.42 L=0.15
Xn_30_p n_30 n_29 vdd vdd sky130_fd_pr__pfet_01v8 W=0.7 L=0.15
Xn_31_n n_31 cb_ack vss vss sky130_fd_pr__nfet_01v8 W=0.42 L=0.15
Xn_31_p n_31 cb_ack vdd vdd sky130_fd_pr__pfet_01v8 W=0.7 L=0.15
Xn_32_p1 n_32 n_30 vdd vdd sky130_fd_pr__pfet_01v8 W=0.7 L=0.15
Xn_32_p2 n_32 coarse_en vdd vdd sky130_fd_pr__pfet_01v8 W=0.7 L=0.15
Xn_32_n1 n_32 n_30 n_32_x vss sky130_fd_pr__nfet_01v8 W=0.84 L=0.15
Xn_32_n2 n_32_x coarse_en vss vss sky130_fd_pr__nfet_01v8 W=0.84 L=0.15
Xn_33_n n_33 n_32 vss vss sky130_fd_pr__nfet_01v8 W=0.42 L=0.15
Xn_33_p n_33 n_32 vdd vdd sky130_fd_pr__pfet_01v8 W=0.7 L=0.15
Xn_34_p1 n_34 sgd vdd vdd sky130_fd_pr__pfet_01v8 W=0.7 L=0.15
Xn_34_p2 n_34 n_31 vdd vdd sky130_fd_pr__pfet_01v8 W=0.7 L=0.15
Xn_34_n1 n_34 sgd n_34_x vss sky130_fd_pr__nfet_01v8 W=0.84 L=0.15
Xn_34_n2 n_34_x n_31 vss vss sky130_fd_pr__nfet_01v8 W=0.84 L=0.15
Xn_35_n n_35 n_34 vss vss sky130_fd_pr__nfet_01v8 W=0.42 L=0.15
Xn_35_p n_35 n_34 vdd vdd sky130_fd_pr__pfet_01v8 W=0.7 L=0.15
Xn_36_p1 n_36 n_33 vdd vdd sky130_fd_pr__pfet_01v8 W=0.7 L=0.15
Xn_36_p2 n_36 n_35 vdd vdd sky130_fd_pr__pfet_01v8 W=0.7 L=0.15
Xn_36_n1 n_36 n_33 n_36_x vss sky130_fd_pr__nfet_01v8 W=0.84 L=0.15
Xn_36_n2 n_36_x n_35 vss vss sky130_fd_pr__nfet_01v8 W=0.84 L=0.15
Xn_37_n n_37 n_36 vss vss sky130_fd_pr__nfet_01v8 W=0.42 L=0.15
Xn_37_p n_37 n_36 vdd vdd sky130_fd_pr__pfet_01v8 W=0.7 L=0.15
Xn_38_p1 n_38 n_1 n_38_x vdd sky130_fd_pr__pfet_01v8 W=1.4 L=0.15
Xn_38_p2 n_38_x c_got vdd vdd sky130_fd_pr__pfet_01v8 W=1.4 L=0.15
Xn_38_n1 n_38 n_1 vss vss sky130_fd_pr__nfet_01v8 W=0.42 L=0.15
Xn_38_n2 n_38 c_got vss vss sky130_fd_pr__nfet_01v8 W=0.42 L=0.15
Xn_39_n n_39 n_38 vss vss sky130_fd_pr__nfet_01v8 W=0.42 L=0.15
Xn_39_p n_39 n_38 vdd vdd sky130_fd_pr__pfet_01v8 W=0.7 L=0.15
Xn_41_p1 n_41 n_37 n_41_x vdd sky130_fd_pr__pfet_01v8 W=1.4 L=0.15
Xn_41_p2 n_41_x n_40 vdd vdd sky130_fd_pr__pfet_01v8 W=1.4 L=0.15
Xn_41_n1 n_41 n_37 vss vss sky130_fd_pr__nfet_01v8 W=0.42 L=0.15
Xn_41_n2 n_41 n_40 vss vss sky130_fd_pr__nfet_01v8 W=0.42 L=0.15
Xn_40_p1 n_40 n_39 n_40_x vdd sky130_fd_pr__pfet_01v8 W=1.4 L=0.15
Xn_40_p2 n_40_x n_41 vdd vdd sky130_fd_pr__pfet_01v8 W=1.4 L=0.15
Xn_40_n1 n_40 n_39 vss vss sky130_fd_pr__nfet_01v8 W=0.42 L=0.15
Xn_40_n2 n_40 n_41 vss vss sky130_fd_pr__nfet_01v8 W=0.42 L=0.15
Xn_42_n n_42 sign vss vss sky130_fd_pr__nfet_01v8 W=0.42 L=0.15
Xn_42_p n_42 sign vdd vdd sky130_fd_pr__pfet_01v8 W=0.7 L=0.15
Xn_43_p1 n_43 sign vdd vdd sky130_fd_pr__pfet_01v8 W=0.7 L=0.15
Xn_43_p2 n_43 n_3 vdd vdd sky130_fd_pr__pfet_01v8 W=0.7 L=0.15
Xn_43_n1 n_43 sign n_43_x vss sky130_fd_pr__nfet_01v8 W=0.84 L=0.15
Xn_43_n2 n_43_x n_3 vss vss sky130_fd_pr__nfet_01v8 W=0.84 L=0.15
Xn_44_p1 n_44 n_42 vdd vdd sky130_fd_pr__pfet_01v8 W=0.7 L=0.15
Xn_44_p2 n_44 n_5 vdd vdd sky130_fd_pr__pfet_01v8 W=0.7 L=0.15
Xn_44_n1 n_44 n_42 n_44_x vss sky130_fd_pr__nfet_01v8 W=0.84 L=0.15
Xn_44_n2 n_44_x n_5 vss vss sky130_fd_pr__nfet_01v8 W=0.84 L=0.15
Xn_45_p1 n_45 n_43 vdd vdd sky130_fd_pr__pfet_01v8 W=0.7 L=0.15
Xn_45_p2 n_45 n_44 vdd vdd sky130_fd_pr__pfet_01v8 W=0.7 L=0.15
Xn_45_n1 n_45 n_43 n_45_x vss sky130_fd_pr__nfet_01v8 W=0.84 L=0.15
Xn_45_n2 n_45_x n_44 vss vss sky130_fd_pr__nfet_01v8 W=0.84 L=0.15
Xn_46_p1 n_46 sign vdd vdd sky130_fd_pr__pfet_01v8 W=0.7 L=0.15
Xn_46_p2 n_46 n_5 vdd vdd sky130_fd_pr__pfet_01v8 W=0.7 L=0.15
Xn_46_n1 n_46 sign n_46_x vss sky130_fd_pr__nfet_01v8 W=0.84 L=0.15
Xn_46_n2 n_46_x n_5 vss vss sky130_fd_pr__nfet_01v8 W=0.84 L=0.15
Xn_47_p1 n_47 n_42 vdd vdd sky130_fd_pr__pfet_01v8 W=0.7 L=0.15
Xn_47_p2 n_47 n_3 vdd vdd sky130_fd_pr__pfet_01v8 W=0.7 L=0.15
Xn_47_n1 n_47 n_42 n_47_x vss sky130_fd_pr__nfet_01v8 W=0.84 L=0.15
Xn_47_n2 n_47_x n_3 vss vss sky130_fd_pr__nfet_01v8 W=0.84 L=0.15
Xn_48_p1 n_48 n_46 vdd vdd sky130_fd_pr__pfet_01v8 W=0.7 L=0.15
Xn_48_p2 n_48 n_47 vdd vdd sky130_fd_pr__pfet_01v8 W=0.7 L=0.15
Xn_48_n1 n_48 n_46 n_48_x vss sky130_fd_pr__nfet_01v8 W=0.84 L=0.15
Xn_48_n2 n_48_x n_47 vss vss sky130_fd_pr__nfet_01v8 W=0.84 L=0.15
Xn_49_p1 n_49 n_45 vdd vdd sky130_fd_pr__pfet_01v8 W=0.7 L=0.15
Xn_49_p2 n_49 sgd vdd vdd sky130_fd_pr__pfet_01v8 W=0.7 L=0.15
Xn_49_n1 n_49 n_45 n_49_x vss sky130_fd_pr__nfet_01v8 W=0.84 L=0.15
Xn_49_n2 n_49_x sgd vss vss sky130_fd_pr__nfet_01v8 W=0.84 L=0.15
Xn_50_n n_50 n_49 vss vss sky130_fd_pr__nfet_01v8 W=0.42 L=0.15
Xn_50_p n_50 n_49 vdd vdd sky130_fd_pr__pfet_01v8 W=0.7 L=0.15
Xn_51_p1 n_51 n_48 vdd vdd sky130_fd_pr__pfet_01v8 W=0.7 L=0.15
Xn_51_p2 n_51 sgd vdd vdd sky130_fd_pr__pfet_01v8 W=0.7 L=0.15
Xn_51_n1 n_51 n_48 n_51_x vss sky130_fd_pr__nfet_01v8 W=0.84 L=0.15
Xn_51_n2 n_51_x sgd vss vss sky130_fd_pr__nfet_01v8 W=0.84 L=0.15
Xn_52_n n_52 n_51 vss vss sky130_fd_pr__nfet_01v8 W=0.42 L=0.15
Xn_52_p n_52 n_51 vdd vdd sky130_fd_pr__pfet_01v8 W=0.7 L=0.15
Xn_53_p1 n_53 n_52 n_53_x vdd sky130_fd_pr__pfet_01v8 W=1.4 L=0.15
Xn_53_p2 n_53_x n_1 vdd vdd sky130_fd_pr__pfet_01v8 W=1.4 L=0.15
Xn_53_n1 n_53 n_52 vss vss sky130_fd_pr__nfet_01v8 W=0.42 L=0.15
Xn_53_n2 n_53 n_1 vss vss sky130_fd_pr__nfet_01v8 W=0.42 L=0.15
Xn_54_n n_54 n_53 vss vss sky130_fd_pr__nfet_01v8 W=0.42 L=0.15
Xn_54_p n_54 n_53 vdd vdd sky130_fd_pr__pfet_01v8 W=0.7 L=0.15
Xn_55_p1 n_55 n_50 n_55_x vdd sky130_fd_pr__pfet_01v8 W=1.4 L=0.15
Xn_55_p2 n_55_x cb_cross vdd vdd sky130_fd_pr__pfet_01v8 W=1.4 L=0.15
Xn_55_n1 n_55 n_50 vss vss sky130_fd_pr__nfet_01v8 W=0.42 L=0.15
Xn_55_n2 n_55 cb_cross vss vss sky130_fd_pr__nfet_01v8 W=0.42 L=0.15
Xcb_cross_p1 cb_cross n_54 cb_cross_x vdd sky130_fd_pr__pfet_01v8 W=1.4 L=0.15
Xcb_cross_p2 cb_cross_x n_55 vdd vdd sky130_fd_pr__pfet_01v8 W=1.4 L=0.15
Xcb_cross_n1 cb_cross n_54 vss vss sky130_fd_pr__nfet_01v8 W=0.42 L=0.15
Xcb_cross_n2 cb_cross n_55 vss vss sky130_fd_pr__nfet_01v8 W=0.42 L=0.15
Xn_56_p1 n_56 n_7 vdd vdd sky130_fd_pr__pfet_01v8 W=0.7 L=0.15
Xn_56_p2 n_56 n_40 vdd vdd sky130_fd_pr__pfet_01v8 W=0.7 L=0.15
Xn_56_n1 n_56 n_7 n_56_x vss sky130_fd_pr__nfet_01v8 W=0.84 L=0.15
Xn_56_n2 n_56_x n_40 vss vss sky130_fd_pr__nfet_01v8 W=0.84 L=0.15
Xn_57_n n_57 n_56 vss vss sky130_fd_pr__nfet_01v8 W=0.42 L=0.15
Xn_57_p n_57 n_56 vdd vdd sky130_fd_pr__pfet_01v8 W=0.7 L=0.15
Xn_58_p1 n_58 acked vdd vdd sky130_fd_pr__pfet_01v8 W=0.7 L=0.15
Xn_58_p2 n_58 n_31 vdd vdd sky130_fd_pr__pfet_01v8 W=0.7 L=0.15
Xn_58_n1 n_58 acked n_58_x vss sky130_fd_pr__nfet_01v8 W=0.84 L=0.15
Xn_58_n2 n_58_x n_31 vss vss sky130_fd_pr__nfet_01v8 W=0.84 L=0.15
Xn_59_n n_59 n_58 vss vss sky130_fd_pr__nfet_01v8 W=0.42 L=0.15
Xn_59_p n_59 n_58 vdd vdd sky130_fd_pr__pfet_01v8 W=0.7 L=0.15
Xn_60_p1 n_60 n_1 n_60_x vdd sky130_fd_pr__pfet_01v8 W=1.4 L=0.15
Xn_60_p2 n_60_x n_59 vdd vdd sky130_fd_pr__pfet_01v8 W=1.4 L=0.15
Xn_60_n1 n_60 n_1 vss vss sky130_fd_pr__nfet_01v8 W=0.42 L=0.15
Xn_60_n2 n_60 n_59 vss vss sky130_fd_pr__nfet_01v8 W=0.42 L=0.15
Xn_61_n n_61 n_60 vss vss sky130_fd_pr__nfet_01v8 W=0.42 L=0.15
Xn_61_p n_61 n_60 vdd vdd sky130_fd_pr__pfet_01v8 W=0.7 L=0.15
Xn_62_p1 n_62 n_57 n_62_x vdd sky130_fd_pr__pfet_01v8 W=1.4 L=0.15
Xn_62_p2 n_62_x c_got vdd vdd sky130_fd_pr__pfet_01v8 W=1.4 L=0.15
Xn_62_n1 n_62 n_57 vss vss sky130_fd_pr__nfet_01v8 W=0.42 L=0.15
Xn_62_n2 n_62 c_got vss vss sky130_fd_pr__nfet_01v8 W=0.42 L=0.15
Xc_got_p1 c_got n_61 c_got_x vdd sky130_fd_pr__pfet_01v8 W=1.4 L=0.15
Xc_got_p2 c_got_x n_62 vdd vdd sky130_fd_pr__pfet_01v8 W=1.4 L=0.15
Xc_got_n1 c_got n_61 vss vss sky130_fd_pr__nfet_01v8 W=0.42 L=0.15
Xc_got_n2 c_got n_62 vss vss sky130_fd_pr__nfet_01v8 W=0.42 L=0.15
Xn_63_p1 n_63 cb_ack vdd vdd sky130_fd_pr__pfet_01v8 W=0.7 L=0.15
Xn_63_p2 n_63 c_got vdd vdd sky130_fd_pr__pfet_01v8 W=0.7 L=0.15
Xn_63_n1 n_63 cb_ack n_63_x vss sky130_fd_pr__nfet_01v8 W=0.84 L=0.15
Xn_63_n2 n_63_x c_got vss vss sky130_fd_pr__nfet_01v8 W=0.84 L=0.15
Xn_64_n n_64 n_63 vss vss sky130_fd_pr__nfet_01v8 W=0.42 L=0.15
Xn_64_p n_64 n_63 vdd vdd sky130_fd_pr__pfet_01v8 W=0.7 L=0.15
Xn_65_p1 n_65 n_64 n_65_x vdd sky130_fd_pr__pfet_01v8 W=1.4 L=0.15
Xn_65_p2 n_65_x acked vdd vdd sky130_fd_pr__pfet_01v8 W=1.4 L=0.15
Xn_65_n1 n_65 n_64 vss vss sky130_fd_pr__nfet_01v8 W=0.42 L=0.15
Xn_65_n2 n_65 acked vss vss sky130_fd_pr__nfet_01v8 W=0.42 L=0.15
Xacked_p1 acked n_25 acked_x vdd sky130_fd_pr__pfet_01v8 W=1.4 L=0.15
Xacked_p2 acked_x n_65 vdd vdd sky130_fd_pr__pfet_01v8 W=1.4 L=0.15
Xacked_n1 acked n_25 vss vss sky130_fd_pr__nfet_01v8 W=0.42 L=0.15
Xacked_n2 acked n_65 vss vss sky130_fd_pr__nfet_01v8 W=0.42 L=0.15
Xn_66_p1 n_66 n_20 n_66_x vdd sky130_fd_pr__pfet_01v8 W=1.4 L=0.15
Xn_66_p2 n_66_x n_40 vdd vdd sky130_fd_pr__pfet_01v8 W=1.4 L=0.15
Xn_66_n1 n_66 n_20 vss vss sky130_fd_pr__nfet_01v8 W=0.42 L=0.15
Xn_66_n2 n_66 n_40 vss vss sky130_fd_pr__nfet_01v8 W=0.42 L=0.15
Xn_67_n n_67 n_66 vss vss sky130_fd_pr__nfet_01v8 W=0.42 L=0.15
Xn_67_p n_67 n_66 vdd vdd sky130_fd_pr__pfet_01v8 W=0.7 L=0.15
Xn_68_n n_68 phi1 vss vss sky130_fd_pr__nfet_01v8 W=0.42 L=0.15
Xn_68_p n_68 phi1 vdd vdd sky130_fd_pr__pfet_01v8 W=0.7 L=0.15
Xn_69_p1 n_69 n_67 vdd vdd sky130_fd_pr__pfet_01v8 W=0.7 L=0.15
Xn_69_p2 n_69 n_68 vdd vdd sky130_fd_pr__pfet_01v8 W=0.7 L=0.15
Xn_69_n1 n_69 n_67 n_69_x vss sky130_fd_pr__nfet_01v8 W=0.84 L=0.15
Xn_69_n2 n_69_x n_68 vss vss sky130_fd_pr__nfet_01v8 W=0.84 L=0.15
Xn_70_n n_70 n_69 vss vss sky130_fd_pr__nfet_01v8 W=0.42 L=0.15
Xn_70_p n_70 n_69 vdd vdd sky130_fd_pr__pfet_01v8 W=0.7 L=0.15
Xn_71_n n_71 n_67 vss vss sky130_fd_pr__nfet_01v8 W=0.42 L=0.15
Xn_71_p n_71 n_67 vdd vdd sky130_fd_pr__pfet_01v8 W=0.7 L=0.15
Xn_72_p1 n_72 n_71 n_72_x vdd sky130_fd_pr__pfet_01v8 W=1.4 L=0.15
Xn_72_p2 n_72_x n_1 vdd vdd sky130_fd_pr__pfet_01v8 W=1.4 L=0.15
Xn_72_n1 n_72 n_71 vss vss sky130_fd_pr__nfet_01v8 W=0.42 L=0.15
Xn_72_n2 n_72 n_1 vss vss sky130_fd_pr__nfet_01v8 W=0.42 L=0.15
Xn_73_n n_73 n_72 vss vss sky130_fd_pr__nfet_01v8 W=0.42 L=0.15
Xn_73_p n_73 n_72 vdd vdd sky130_fd_pr__pfet_01v8 W=0.7 L=0.15
Xn_75_p1 n_75 n_70 n_75_x vdd sky130_fd_pr__pfet_01v8 W=1.4 L=0.15
Xn_75_p2 n_75_x n_74 vdd vdd sky130_fd_pr__pfet_01v8 W=1.4 L=0.15
Xn_75_n1 n_75 n_70 vss vss sky130_fd_pr__nfet_01v8 W=0.42 L=0.15
Xn_75_n2 n_75 n_74 vss vss sky130_fd_pr__nfet_01v8 W=0.42 L=0.15
Xn_74_p1 n_74 n_73 n_74_x vdd sky130_fd_pr__pfet_01v8 W=1.4 L=0.15
Xn_74_p2 n_74_x n_75 vdd vdd sky130_fd_pr__pfet_01v8 W=1.4 L=0.15
Xn_74_n1 n_74 n_73 vss vss sky130_fd_pr__nfet_01v8 W=0.42 L=0.15
Xn_74_n2 n_74 n_75 vss vss sky130_fd_pr__nfet_01v8 W=0.42 L=0.15
Xn_76_p1 n_76 n_74 vdd vdd sky130_fd_pr__pfet_01v8 W=0.7 L=0.15
Xn_76_p2 n_76 phi1 vdd vdd sky130_fd_pr__pfet_01v8 W=0.7 L=0.15
Xn_76_n1 n_76 n_74 n_76_x vss sky130_fd_pr__nfet_01v8 W=0.84 L=0.15
Xn_76_n2 n_76_x phi1 vss vss sky130_fd_pr__nfet_01v8 W=0.84 L=0.15
Xn_77_n n_77 n_76 vss vss sky130_fd_pr__nfet_01v8 W=0.42 L=0.15
Xn_77_p n_77 n_76 vdd vdd sky130_fd_pr__pfet_01v8 W=0.7 L=0.15
Xn_78_p1 n_78 n_74 n_78_x vdd sky130_fd_pr__pfet_01v8 W=1.4 L=0.15
Xn_78_p2 n_78_x phi1 vdd vdd sky130_fd_pr__pfet_01v8 W=1.4 L=0.15
Xn_78_n1 n_78 n_74 vss vss sky130_fd_pr__nfet_01v8 W=0.42 L=0.15
Xn_78_n2 n_78 phi1 vss vss sky130_fd_pr__nfet_01v8 W=0.42 L=0.15
Xn_79_p1 n_79 n_78 n_79_x vdd sky130_fd_pr__pfet_01v8 W=1.4 L=0.15
Xn_79_p2 n_79_x n_1 vdd vdd sky130_fd_pr__pfet_01v8 W=1.4 L=0.15
Xn_79_n1 n_79 n_78 vss vss sky130_fd_pr__nfet_01v8 W=0.42 L=0.15
Xn_79_n2 n_79 n_1 vss vss sky130_fd_pr__nfet_01v8 W=0.42 L=0.15
Xn_80_n n_80 n_79 vss vss sky130_fd_pr__nfet_01v8 W=0.42 L=0.15
Xn_80_p n_80 n_79 vdd vdd sky130_fd_pr__pfet_01v8 W=0.7 L=0.15
Xn_82_p1 n_82 n_77 n_82_x vdd sky130_fd_pr__pfet_01v8 W=1.4 L=0.15
Xn_82_p2 n_82_x n_81 vdd vdd sky130_fd_pr__pfet_01v8 W=1.4 L=0.15
Xn_82_n1 n_82 n_77 vss vss sky130_fd_pr__nfet_01v8 W=0.42 L=0.15
Xn_82_n2 n_82 n_81 vss vss sky130_fd_pr__nfet_01v8 W=0.42 L=0.15
Xn_81_p1 n_81 n_80 n_81_x vdd sky130_fd_pr__pfet_01v8 W=1.4 L=0.15
Xn_81_p2 n_81_x n_82 vdd vdd sky130_fd_pr__pfet_01v8 W=1.4 L=0.15
Xn_81_n1 n_81 n_80 vss vss sky130_fd_pr__nfet_01v8 W=0.42 L=0.15
Xn_81_n2 n_81 n_82 vss vss sky130_fd_pr__nfet_01v8 W=0.42 L=0.15
Xn_83_n n_83 n_81 vss vss sky130_fd_pr__nfet_01v8 W=0.42 L=0.15
Xn_83_p n_83 n_81 vdd vdd sky130_fd_pr__pfet_01v8 W=0.7 L=0.15
Xclk_c_n clk_c n_83 vss vss sky130_fd_pr__nfet_01v8 W=0.42 L=0.15
Xclk_c_p clk_c n_83 vdd vdd sky130_fd_pr__pfet_01v8 W=0.7 L=0.15
Xn_84_p1 n_84 c_got vdd vdd sky130_fd_pr__pfet_01v8 W=0.7 L=0.15
Xn_84_p2 n_84 n_21 vdd vdd sky130_fd_pr__pfet_01v8 W=0.7 L=0.15
Xn_84_n1 n_84 c_got n_84_x vss sky130_fd_pr__nfet_01v8 W=0.84 L=0.15
Xn_84_n2 n_84_x n_21 vss vss sky130_fd_pr__nfet_01v8 W=0.84 L=0.15
Xn_85_n n_85 n_84 vss vss sky130_fd_pr__nfet_01v8 W=0.42 L=0.15
Xn_85_p n_85 n_84 vdd vdd sky130_fd_pr__pfet_01v8 W=0.7 L=0.15
Xn_87_p1 n_87 n_85 vdd vdd sky130_fd_pr__pfet_01v8 W=0.7 L=0.15
Xn_87_p2 n_87 n_86 vdd vdd sky130_fd_pr__pfet_01v8 W=0.7 L=0.15
Xn_87_n1 n_87 n_85 n_87_x vss sky130_fd_pr__nfet_01v8 W=0.84 L=0.15
Xn_87_n2 n_87_x n_86 vss vss sky130_fd_pr__nfet_01v8 W=0.84 L=0.15
Xn_88_n n_88 n_87 vss vss sky130_fd_pr__nfet_01v8 W=0.42 L=0.15
Xn_88_p n_88 n_87 vdd vdd sky130_fd_pr__pfet_01v8 W=0.7 L=0.15
Xn_89_n n_89 n_88 vss vss sky130_fd_pr__nfet_01v8 W=0.42 L=0.15
Xn_89_p n_89 n_88 vdd vdd sky130_fd_pr__pfet_01v8 W=0.7 L=0.15
Xn_90_n n_90 cb_cross vss vss sky130_fd_pr__nfet_01v8 W=0.42 L=0.15
Xn_90_p n_90 cb_cross vdd vdd sky130_fd_pr__pfet_01v8 W=0.7 L=0.15
Xn_91_p1 n_91 cb_ack vdd vdd sky130_fd_pr__pfet_01v8 W=0.7 L=0.15
Xn_91_p2 n_91 cb_cross vdd vdd sky130_fd_pr__pfet_01v8 W=0.7 L=0.15
Xn_91_n1 n_91 cb_ack n_91_x vss sky130_fd_pr__nfet_01v8 W=0.84 L=0.15
Xn_91_n2 n_91_x cb_cross vss vss sky130_fd_pr__nfet_01v8 W=0.84 L=0.15
Xn_92_n n_92 n_91 vss vss sky130_fd_pr__nfet_01v8 W=0.42 L=0.15
Xn_92_p n_92 n_91 vdd vdd sky130_fd_pr__pfet_01v8 W=0.7 L=0.15
Xn_93_p1 n_93 n_92 vdd vdd sky130_fd_pr__pfet_01v8 W=0.7 L=0.15
Xn_93_p2 n_93 c_got vdd vdd sky130_fd_pr__pfet_01v8 W=0.7 L=0.15
Xn_93_n1 n_93 n_92 n_93_x vss sky130_fd_pr__nfet_01v8 W=0.84 L=0.15
Xn_93_n2 n_93_x c_got vss vss sky130_fd_pr__nfet_01v8 W=0.84 L=0.15
Xn_94_n n_94 n_93 vss vss sky130_fd_pr__nfet_01v8 W=0.42 L=0.15
Xn_94_p n_94 n_93 vdd vdd sky130_fd_pr__pfet_01v8 W=0.7 L=0.15
Xn_95_n n_95 phi2 vss vss sky130_fd_pr__nfet_01v8 W=0.42 L=0.15
Xn_95_p n_95 phi2 vdd vdd sky130_fd_pr__pfet_01v8 W=0.7 L=0.15
Xn_96_n n_96 n_95 vss vss sky130_fd_pr__nfet_01v8 W=0.42 L=0.15
Xn_96_p n_96 n_95 vdd vdd sky130_fd_pr__pfet_01v8 W=0.7 L=0.15
Xn_97_n n_97 n_96 vss vss sky130_fd_pr__nfet_01v8 W=0.42 L=0.15
Xn_97_p n_97 n_96 vdd vdd sky130_fd_pr__pfet_01v8 W=0.7 L=0.15
Xn_98_n n_98 n_97 vss vss sky130_fd_pr__nfet_01v8 W=0.42 L=0.15
Xn_98_p n_98 n_97 vdd vdd sky130_fd_pr__pfet_01v8 W=0.7 L=0.15
Xn_99_n n_99 n_98 vss vss sky130_fd_pr__nfet_01v8 W=0.42 L=0.15
Xn_99_p n_99 n_98 vdd vdd sky130_fd_pr__pfet_01v8 W=0.7 L=0.15
Xn_100_p1 n_100 n_95 n_100_x vdd sky130_fd_pr__pfet_01v8 W=1.4 L=0.15
Xn_100_p2 n_100_x n_99 vdd vdd sky130_fd_pr__pfet_01v8 W=1.4 L=0.15
Xn_100_n1 n_100 n_95 vss vss sky130_fd_pr__nfet_01v8 W=0.42 L=0.15
Xn_100_n2 n_100 n_99 vss vss sky130_fd_pr__nfet_01v8 W=0.42 L=0.15
Xn_101_n n_101 n_100 vss vss sky130_fd_pr__nfet_01v8 W=0.84 L=0.15
Xn_101_p n_101 n_100 vdd vdd sky130_fd_pr__pfet_01v8 W=1.4 L=0.15
Xn_102_p1 n_102 n_95 vdd vdd sky130_fd_pr__pfet_01v8 W=0.7 L=0.15
Xn_102_p2 n_102 n_99 vdd vdd sky130_fd_pr__pfet_01v8 W=0.7 L=0.15
Xn_102_n1 n_102 n_95 n_102_x vss sky130_fd_pr__nfet_01v8 W=0.84 L=0.15
Xn_102_n2 n_102_x n_99 vss vss sky130_fd_pr__nfet_01v8 W=0.84 L=0.15
Xn_103_n n_103 n_102 vss vss sky130_fd_pr__nfet_01v8 W=0.42 L=0.15
Xn_103_p n_103 n_102 vdd vdd sky130_fd_pr__pfet_01v8 W=0.7 L=0.15
Xn_104_n n_104 n_103 vss vss sky130_fd_pr__nfet_01v8 W=0.84 L=0.15
Xn_104_p n_104 n_103 vdd vdd sky130_fd_pr__pfet_01v8 W=1.4 L=0.15
Xn_105_p1 n_105 pkt_d0 n_105_x vdd sky130_fd_pr__pfet_01v8 W=1.4 L=0.15
Xn_105_p2 n_105_x pkt_d1 vdd vdd sky130_fd_pr__pfet_01v8 W=1.4 L=0.15
Xn_105_n1 n_105 pkt_d0 vss vss sky130_fd_pr__nfet_01v8 W=0.42 L=0.15
Xn_105_n2 n_105 pkt_d1 vss vss sky130_fd_pr__nfet_01v8 W=0.42 L=0.15
Xn_106_n n_106 n_105 vss vss sky130_fd_pr__nfet_01v8 W=0.42 L=0.15
Xn_106_p n_106 n_105 vdd vdd sky130_fd_pr__pfet_01v8 W=0.7 L=0.15
Xn_107_p1 n_107 n_106 n_107_x vdd sky130_fd_pr__pfet_01v8 W=1.4 L=0.15
Xn_107_p2 n_107_x pkt_d2 vdd vdd sky130_fd_pr__pfet_01v8 W=1.4 L=0.15
Xn_107_n1 n_107 n_106 vss vss sky130_fd_pr__nfet_01v8 W=0.42 L=0.15
Xn_107_n2 n_107 pkt_d2 vss vss sky130_fd_pr__nfet_01v8 W=0.42 L=0.15
Xn_108_p1 n_108 pkt_d0 n_108_x vdd sky130_fd_pr__pfet_01v8 W=1.4 L=0.15
Xn_108_p2 n_108_x n_107 vdd vdd sky130_fd_pr__pfet_01v8 W=1.4 L=0.15
Xn_108_n1 n_108 pkt_d0 vss vss sky130_fd_pr__nfet_01v8 W=0.42 L=0.15
Xn_108_n2 n_108 n_107 vss vss sky130_fd_pr__nfet_01v8 W=0.42 L=0.15
Xn_109_n n_109 n_108 vss vss sky130_fd_pr__nfet_01v8 W=0.42 L=0.15
Xn_109_p n_109 n_108 vdd vdd sky130_fd_pr__pfet_01v8 W=0.7 L=0.15
Xn_110_n n_110 fn0 vss vss sky130_fd_pr__nfet_01v8 W=0.42 L=0.15
Xn_110_p n_110 fn0 vdd vdd sky130_fd_pr__pfet_01v8 W=0.7 L=0.15
Xn_111_p1 n_111 n_110 vdd vdd sky130_fd_pr__pfet_01v8 W=0.7 L=0.15
Xn_111_p2 n_111 n_109 vdd vdd sky130_fd_pr__pfet_01v8 W=0.7 L=0.15
Xn_111_n1 n_111 n_110 n_111_x vss sky130_fd_pr__nfet_01v8 W=0.84 L=0.15
Xn_111_n2 n_111_x n_109 vss vss sky130_fd_pr__nfet_01v8 W=0.84 L=0.15
Xn_112_n n_112 n_111 vss vss sky130_fd_pr__nfet_01v8 W=0.42 L=0.15
Xn_112_p n_112 n_111 vdd vdd sky130_fd_pr__pfet_01v8 W=0.7 L=0.15
Xn_113_n n_113 fn1 vss vss sky130_fd_pr__nfet_01v8 W=0.42 L=0.15
Xn_113_p n_113 fn1 vdd vdd sky130_fd_pr__pfet_01v8 W=0.7 L=0.15
Xn_114_p1 n_114 n_113 vdd vdd sky130_fd_pr__pfet_01v8 W=0.7 L=0.15
Xn_114_p2 n_114 pkt_d1 vdd vdd sky130_fd_pr__pfet_01v8 W=0.7 L=0.15
Xn_114_n1 n_114 n_113 n_114_x vss sky130_fd_pr__nfet_01v8 W=0.84 L=0.15
Xn_114_n2 n_114_x pkt_d1 vss vss sky130_fd_pr__nfet_01v8 W=0.84 L=0.15
Xn_115_p1 n_115 n_113 n_115_x vdd sky130_fd_pr__pfet_01v8 W=1.4 L=0.15
Xn_115_p2 n_115_x pkt_d1 vdd vdd sky130_fd_pr__pfet_01v8 W=1.4 L=0.15
Xn_115_n1 n_115 n_113 vss vss sky130_fd_pr__nfet_01v8 W=0.42 L=0.15
Xn_115_n2 n_115 pkt_d1 vss vss sky130_fd_pr__nfet_01v8 W=0.42 L=0.15
Xn_116_n n_116 n_115 vss vss sky130_fd_pr__nfet_01v8 W=0.42 L=0.15
Xn_116_p n_116 n_115 vdd vdd sky130_fd_pr__pfet_01v8 W=0.7 L=0.15
Xn_117_p1 n_117 n_112 vdd vdd sky130_fd_pr__pfet_01v8 W=0.7 L=0.15
Xn_117_p2 n_117 n_116 vdd vdd sky130_fd_pr__pfet_01v8 W=0.7 L=0.15
Xn_117_n1 n_117 n_112 n_117_x vss sky130_fd_pr__nfet_01v8 W=0.84 L=0.15
Xn_117_n2 n_117_x n_116 vss vss sky130_fd_pr__nfet_01v8 W=0.84 L=0.15
Xn_118_p1 n_118 n_114 vdd vdd sky130_fd_pr__pfet_01v8 W=0.7 L=0.15
Xn_118_p2 n_118 n_117 vdd vdd sky130_fd_pr__pfet_01v8 W=0.7 L=0.15
Xn_118_n1 n_118 n_114 n_118_x vss sky130_fd_pr__nfet_01v8 W=0.84 L=0.15
Xn_118_n2 n_118_x n_117 vss vss sky130_fd_pr__nfet_01v8 W=0.84 L=0.15
Xn_119_n n_119 fn2 vss vss sky130_fd_pr__nfet_01v8 W=0.42 L=0.15
Xn_119_p n_119 fn2 vdd vdd sky130_fd_pr__pfet_01v8 W=0.7 L=0.15
Xn_120_p1 n_120 n_119 vdd vdd sky130_fd_pr__pfet_01v8 W=0.7 L=0.15
Xn_120_p2 n_120 pkt_d2 vdd vdd sky130_fd_pr__pfet_01v8 W=0.7 L=0.15
Xn_120_n1 n_120 n_119 n_120_x vss sky130_fd_pr__nfet_01v8 W=0.84 L=0.15
Xn_120_n2 n_120_x pkt_d2 vss vss sky130_fd_pr__nfet_01v8 W=0.84 L=0.15
Xn_121_p1 n_121 n_119 n_121_x vdd sky130_fd_pr__pfet_01v8 W=1.4 L=0.15
Xn_121_p2 n_121_x pkt_d2 vdd vdd sky130_fd_pr__pfet_01v8 W=1.4 L=0.15
Xn_121_n1 n_121 n_119 vss vss sky130_fd_pr__nfet_01v8 W=0.42 L=0.15
Xn_121_n2 n_121 pkt_d2 vss vss sky130_fd_pr__nfet_01v8 W=0.42 L=0.15
Xn_122_n n_122 n_121 vss vss sky130_fd_pr__nfet_01v8 W=0.42 L=0.15
Xn_122_p n_122 n_121 vdd vdd sky130_fd_pr__pfet_01v8 W=0.7 L=0.15
Xn_123_p1 n_123 n_118 vdd vdd sky130_fd_pr__pfet_01v8 W=0.7 L=0.15
Xn_123_p2 n_123 n_122 vdd vdd sky130_fd_pr__pfet_01v8 W=0.7 L=0.15
Xn_123_n1 n_123 n_118 n_123_x vss sky130_fd_pr__nfet_01v8 W=0.84 L=0.15
Xn_123_n2 n_123_x n_122 vss vss sky130_fd_pr__nfet_01v8 W=0.84 L=0.15
Xn_124_p1 n_124 n_120 vdd vdd sky130_fd_pr__pfet_01v8 W=0.7 L=0.15
Xn_124_p2 n_124 n_123 vdd vdd sky130_fd_pr__pfet_01v8 W=0.7 L=0.15
Xn_124_n1 n_124 n_120 n_124_x vss sky130_fd_pr__nfet_01v8 W=0.84 L=0.15
Xn_124_n2 n_124_x n_123 vss vss sky130_fd_pr__nfet_01v8 W=0.84 L=0.15
Xn_125_p1 n_125 n_94 vdd vdd sky130_fd_pr__pfet_01v8 W=0.7 L=0.15
Xn_125_p2 n_125 n_124 vdd vdd sky130_fd_pr__pfet_01v8 W=0.7 L=0.15
Xn_125_n1 n_125 n_94 n_125_x vss sky130_fd_pr__nfet_01v8 W=0.84 L=0.15
Xn_125_n2 n_125_x n_124 vss vss sky130_fd_pr__nfet_01v8 W=0.84 L=0.15
Xn_126_n n_126 n_125 vss vss sky130_fd_pr__nfet_01v8 W=0.42 L=0.15
Xn_126_p n_126 n_125 vdd vdd sky130_fd_pr__pfet_01v8 W=0.7 L=0.15
Xn_127_n n_127 n_126 vss vss sky130_fd_pr__nfet_01v8 W=0.42 L=0.15
Xn_127_p n_127 n_126 vdd vdd sky130_fd_pr__pfet_01v8 W=0.7 L=0.15
Xn_128_p1 n_128 n_126 n_128_x vdd sky130_fd_pr__pfet_01v8 W=1.4 L=0.15
Xn_128_p2 n_128_x n_101 vdd vdd sky130_fd_pr__pfet_01v8 W=1.4 L=0.15
Xn_128_n1 n_128 n_126 vss vss sky130_fd_pr__nfet_01v8 W=0.42 L=0.15
Xn_128_n2 n_128 n_101 vss vss sky130_fd_pr__nfet_01v8 W=0.42 L=0.15
Xn_129_p1 n_129 n_128 n_129_x vdd sky130_fd_pr__pfet_01v8 W=1.4 L=0.15
Xn_129_p2 n_129_x n_25 vdd vdd sky130_fd_pr__pfet_01v8 W=1.4 L=0.15
Xn_129_n1 n_129 n_128 vss vss sky130_fd_pr__nfet_01v8 W=0.42 L=0.15
Xn_129_n2 n_129 n_25 vss vss sky130_fd_pr__nfet_01v8 W=0.42 L=0.15
Xn_130_n n_130 n_129 vss vss sky130_fd_pr__nfet_01v8 W=0.42 L=0.15
Xn_130_p n_130 n_129 vdd vdd sky130_fd_pr__pfet_01v8 W=0.7 L=0.15
Xn_133_p1 n_133 n_127 n_133_x vdd sky130_fd_pr__pfet_01v8 W=1.4 L=0.15
Xn_133_p2 n_133_x n_101 vdd vdd sky130_fd_pr__pfet_01v8 W=1.4 L=0.15
Xn_133_n1 n_133 n_127 vss vss sky130_fd_pr__nfet_01v8 W=0.42 L=0.15
Xn_133_n2 n_133 n_101 vss vss sky130_fd_pr__nfet_01v8 W=0.42 L=0.15
Xn_132_p1 n_132 n_133 n_132_x vdd sky130_fd_pr__pfet_01v8 W=1.4 L=0.15
Xn_132_p2 n_132_x n_131 vdd vdd sky130_fd_pr__pfet_01v8 W=1.4 L=0.15
Xn_132_n1 n_132 n_133 vss vss sky130_fd_pr__nfet_01v8 W=0.42 L=0.15
Xn_132_n2 n_132 n_131 vss vss sky130_fd_pr__nfet_01v8 W=0.42 L=0.15
Xn_131_p1 n_131 n_130 n_131_x vdd sky130_fd_pr__pfet_01v8 W=1.4 L=0.15
Xn_131_p2 n_131_x n_132 vdd vdd sky130_fd_pr__pfet_01v8 W=1.4 L=0.15
Xn_131_n1 n_131 n_130 vss vss sky130_fd_pr__nfet_01v8 W=0.42 L=0.15
Xn_131_n2 n_131 n_132 vss vss sky130_fd_pr__nfet_01v8 W=0.42 L=0.15
Xn_134_p1 n_134 n_131 n_134_x vdd sky130_fd_pr__pfet_01v8 W=1.4 L=0.15
Xn_134_p2 n_134_x n_104 vdd vdd sky130_fd_pr__pfet_01v8 W=1.4 L=0.15
Xn_134_n1 n_134 n_131 vss vss sky130_fd_pr__nfet_01v8 W=0.42 L=0.15
Xn_134_n2 n_134 n_104 vss vss sky130_fd_pr__nfet_01v8 W=0.42 L=0.15
Xn_135_p1 n_135 n_134 n_135_x vdd sky130_fd_pr__pfet_01v8 W=1.4 L=0.15
Xn_135_p2 n_135_x n_25 vdd vdd sky130_fd_pr__pfet_01v8 W=1.4 L=0.15
Xn_135_n1 n_135 n_134 vss vss sky130_fd_pr__nfet_01v8 W=0.42 L=0.15
Xn_135_n2 n_135 n_25 vss vss sky130_fd_pr__nfet_01v8 W=0.42 L=0.15
Xn_136_n n_136 n_135 vss vss sky130_fd_pr__nfet_01v8 W=0.42 L=0.15
Xn_136_p n_136 n_135 vdd vdd sky130_fd_pr__pfet_01v8 W=0.7 L=0.15
Xn_138_p1 n_138 n_132 n_138_x vdd sky130_fd_pr__pfet_01v8 W=1.4 L=0.15
Xn_138_p2 n_138_x n_104 vdd vdd sky130_fd_pr__pfet_01v8 W=1.4 L=0.15
Xn_138_n1 n_138 n_132 vss vss sky130_fd_pr__nfet_01v8 W=0.42 L=0.15
Xn_138_n2 n_138 n_104 vss vss sky130_fd_pr__nfet_01v8 W=0.42 L=0.15
Xn_137_p1 n_137 n_138 n_137_x vdd sky130_fd_pr__pfet_01v8 W=1.4 L=0.15
Xn_137_p2 n_137_x fire vdd vdd sky130_fd_pr__pfet_01v8 W=1.4 L=0.15
Xn_137_n1 n_137 n_138 vss vss sky130_fd_pr__nfet_01v8 W=0.42 L=0.15
Xn_137_n2 n_137 fire vss vss sky130_fd_pr__nfet_01v8 W=0.42 L=0.15
Xfire_p1 fire n_136 fire_x vdd sky130_fd_pr__pfet_01v8 W=1.4 L=0.15
Xfire_p2 fire_x n_137 vdd vdd sky130_fd_pr__pfet_01v8 W=1.4 L=0.15
Xfire_n1 fire n_136 vss vss sky130_fd_pr__nfet_01v8 W=0.42 L=0.15
Xfire_n2 fire n_137 vss vss sky130_fd_pr__nfet_01v8 W=0.42 L=0.15
Xn_139_p1 n_139 fn0 vdd vdd sky130_fd_pr__pfet_01v8 W=0.7 L=0.15
Xn_139_p2 n_139 n_126 vdd vdd sky130_fd_pr__pfet_01v8 W=0.7 L=0.15
Xn_139_n1 n_139 fn0 n_139_x vss sky130_fd_pr__nfet_01v8 W=0.84 L=0.15
Xn_139_n2 n_139_x n_126 vss vss sky130_fd_pr__nfet_01v8 W=0.84 L=0.15
Xn_140_p1 n_140 fn0 vdd vdd sky130_fd_pr__pfet_01v8 W=0.7 L=0.15
Xn_140_p2 n_140 n_139 vdd vdd sky130_fd_pr__pfet_01v8 W=0.7 L=0.15
Xn_140_n1 n_140 fn0 n_140_x vss sky130_fd_pr__nfet_01v8 W=0.84 L=0.15
Xn_140_n2 n_140_x n_139 vss vss sky130_fd_pr__nfet_01v8 W=0.84 L=0.15
Xn_141_p1 n_141 n_126 vdd vdd sky130_fd_pr__pfet_01v8 W=0.7 L=0.15
Xn_141_p2 n_141 n_139 vdd vdd sky130_fd_pr__pfet_01v8 W=0.7 L=0.15
Xn_141_n1 n_141 n_126 n_141_x vss sky130_fd_pr__nfet_01v8 W=0.84 L=0.15
Xn_141_n2 n_141_x n_139 vss vss sky130_fd_pr__nfet_01v8 W=0.84 L=0.15
Xn_142_p1 n_142 n_140 vdd vdd sky130_fd_pr__pfet_01v8 W=0.7 L=0.15
Xn_142_p2 n_142 n_141 vdd vdd sky130_fd_pr__pfet_01v8 W=0.7 L=0.15
Xn_142_n1 n_142 n_140 n_142_x vss sky130_fd_pr__nfet_01v8 W=0.84 L=0.15
Xn_142_n2 n_142_x n_141 vss vss sky130_fd_pr__nfet_01v8 W=0.84 L=0.15
Xn_143_n n_143 n_142 vss vss sky130_fd_pr__nfet_01v8 W=0.42 L=0.15
Xn_143_p n_143 n_142 vdd vdd sky130_fd_pr__pfet_01v8 W=0.7 L=0.15
Xn_144_p1 n_144 n_142 n_144_x vdd sky130_fd_pr__pfet_01v8 W=1.4 L=0.15
Xn_144_p2 n_144_x n_101 vdd vdd sky130_fd_pr__pfet_01v8 W=1.4 L=0.15
Xn_144_n1 n_144 n_142 vss vss sky130_fd_pr__nfet_01v8 W=0.42 L=0.15
Xn_144_n2 n_144 n_101 vss vss sky130_fd_pr__nfet_01v8 W=0.42 L=0.15
Xn_145_p1 n_145 n_144 n_145_x vdd sky130_fd_pr__pfet_01v8 W=1.4 L=0.15
Xn_145_p2 n_145_x n_25 vdd vdd sky130_fd_pr__pfet_01v8 W=1.4 L=0.15
Xn_145_n1 n_145 n_144 vss vss sky130_fd_pr__nfet_01v8 W=0.42 L=0.15
Xn_145_n2 n_145 n_25 vss vss sky130_fd_pr__nfet_01v8 W=0.42 L=0.15
Xn_146_n n_146 n_145 vss vss sky130_fd_pr__nfet_01v8 W=0.42 L=0.15
Xn_146_p n_146 n_145 vdd vdd sky130_fd_pr__pfet_01v8 W=0.7 L=0.15
Xn_149_p1 n_149 n_143 n_149_x vdd sky130_fd_pr__pfet_01v8 W=1.4 L=0.15
Xn_149_p2 n_149_x n_101 vdd vdd sky130_fd_pr__pfet_01v8 W=1.4 L=0.15
Xn_149_n1 n_149 n_143 vss vss sky130_fd_pr__nfet_01v8 W=0.42 L=0.15
Xn_149_n2 n_149 n_101 vss vss sky130_fd_pr__nfet_01v8 W=0.42 L=0.15
Xn_148_p1 n_148 n_149 n_148_x vdd sky130_fd_pr__pfet_01v8 W=1.4 L=0.15
Xn_148_p2 n_148_x n_147 vdd vdd sky130_fd_pr__pfet_01v8 W=1.4 L=0.15
Xn_148_n1 n_148 n_149 vss vss sky130_fd_pr__nfet_01v8 W=0.42 L=0.15
Xn_148_n2 n_148 n_147 vss vss sky130_fd_pr__nfet_01v8 W=0.42 L=0.15
Xn_147_p1 n_147 n_146 n_147_x vdd sky130_fd_pr__pfet_01v8 W=1.4 L=0.15
Xn_147_p2 n_147_x n_148 vdd vdd sky130_fd_pr__pfet_01v8 W=1.4 L=0.15
Xn_147_n1 n_147 n_146 vss vss sky130_fd_pr__nfet_01v8 W=0.42 L=0.15
Xn_147_n2 n_147 n_148 vss vss sky130_fd_pr__nfet_01v8 W=0.42 L=0.15
Xn_150_p1 n_150 n_147 n_150_x vdd sky130_fd_pr__pfet_01v8 W=1.4 L=0.15
Xn_150_p2 n_150_x n_104 vdd vdd sky130_fd_pr__pfet_01v8 W=1.4 L=0.15
Xn_150_n1 n_150 n_147 vss vss sky130_fd_pr__nfet_01v8 W=0.42 L=0.15
Xn_150_n2 n_150 n_104 vss vss sky130_fd_pr__nfet_01v8 W=0.42 L=0.15
Xn_151_p1 n_151 n_150 n_151_x vdd sky130_fd_pr__pfet_01v8 W=1.4 L=0.15
Xn_151_p2 n_151_x n_25 vdd vdd sky130_fd_pr__pfet_01v8 W=1.4 L=0.15
Xn_151_n1 n_151 n_150 vss vss sky130_fd_pr__nfet_01v8 W=0.42 L=0.15
Xn_151_n2 n_151 n_25 vss vss sky130_fd_pr__nfet_01v8 W=0.42 L=0.15
Xn_152_n n_152 n_151 vss vss sky130_fd_pr__nfet_01v8 W=0.42 L=0.15
Xn_152_p n_152 n_151 vdd vdd sky130_fd_pr__pfet_01v8 W=0.7 L=0.15
Xn_154_p1 n_154 n_148 n_154_x vdd sky130_fd_pr__pfet_01v8 W=1.4 L=0.15
Xn_154_p2 n_154_x n_104 vdd vdd sky130_fd_pr__pfet_01v8 W=1.4 L=0.15
Xn_154_n1 n_154 n_148 vss vss sky130_fd_pr__nfet_01v8 W=0.42 L=0.15
Xn_154_n2 n_154 n_104 vss vss sky130_fd_pr__nfet_01v8 W=0.42 L=0.15
Xn_153_p1 n_153 n_154 n_153_x vdd sky130_fd_pr__pfet_01v8 W=1.4 L=0.15
Xn_153_p2 n_153_x fn0 vdd vdd sky130_fd_pr__pfet_01v8 W=1.4 L=0.15
Xn_153_n1 n_153 n_154 vss vss sky130_fd_pr__nfet_01v8 W=0.42 L=0.15
Xn_153_n2 n_153 fn0 vss vss sky130_fd_pr__nfet_01v8 W=0.42 L=0.15
Xfn0_p1 fn0 n_152 fn0_x vdd sky130_fd_pr__pfet_01v8 W=1.4 L=0.15
Xfn0_p2 fn0_x n_153 vdd vdd sky130_fd_pr__pfet_01v8 W=1.4 L=0.15
Xfn0_n1 fn0 n_152 vss vss sky130_fd_pr__nfet_01v8 W=0.42 L=0.15
Xfn0_n2 fn0 n_153 vss vss sky130_fd_pr__nfet_01v8 W=0.42 L=0.15
Xn_155_p1 n_155 fn0 vdd vdd sky130_fd_pr__pfet_01v8 W=0.7 L=0.15
Xn_155_p2 n_155 n_126 vdd vdd sky130_fd_pr__pfet_01v8 W=0.7 L=0.15
Xn_155_n1 n_155 fn0 n_155_x vss sky130_fd_pr__nfet_01v8 W=0.84 L=0.15
Xn_155_n2 n_155_x n_126 vss vss sky130_fd_pr__nfet_01v8 W=0.84 L=0.15
Xn_156_n n_156 n_155 vss vss sky130_fd_pr__nfet_01v8 W=0.42 L=0.15
Xn_156_p n_156 n_155 vdd vdd sky130_fd_pr__pfet_01v8 W=0.7 L=0.15
Xn_157_p1 n_157 fn1 vdd vdd sky130_fd_pr__pfet_01v8 W=0.7 L=0.15
Xn_157_p2 n_157 n_156 vdd vdd sky130_fd_pr__pfet_01v8 W=0.7 L=0.15
Xn_157_n1 n_157 fn1 n_157_x vss sky130_fd_pr__nfet_01v8 W=0.84 L=0.15
Xn_157_n2 n_157_x n_156 vss vss sky130_fd_pr__nfet_01v8 W=0.84 L=0.15
Xn_158_p1 n_158 fn1 vdd vdd sky130_fd_pr__pfet_01v8 W=0.7 L=0.15
Xn_158_p2 n_158 n_157 vdd vdd sky130_fd_pr__pfet_01v8 W=0.7 L=0.15
Xn_158_n1 n_158 fn1 n_158_x vss sky130_fd_pr__nfet_01v8 W=0.84 L=0.15
Xn_158_n2 n_158_x n_157 vss vss sky130_fd_pr__nfet_01v8 W=0.84 L=0.15
Xn_159_p1 n_159 n_156 vdd vdd sky130_fd_pr__pfet_01v8 W=0.7 L=0.15
Xn_159_p2 n_159 n_157 vdd vdd sky130_fd_pr__pfet_01v8 W=0.7 L=0.15
Xn_159_n1 n_159 n_156 n_159_x vss sky130_fd_pr__nfet_01v8 W=0.84 L=0.15
Xn_159_n2 n_159_x n_157 vss vss sky130_fd_pr__nfet_01v8 W=0.84 L=0.15
Xn_160_p1 n_160 n_158 vdd vdd sky130_fd_pr__pfet_01v8 W=0.7 L=0.15
Xn_160_p2 n_160 n_159 vdd vdd sky130_fd_pr__pfet_01v8 W=0.7 L=0.15
Xn_160_n1 n_160 n_158 n_160_x vss sky130_fd_pr__nfet_01v8 W=0.84 L=0.15
Xn_160_n2 n_160_x n_159 vss vss sky130_fd_pr__nfet_01v8 W=0.84 L=0.15
Xn_161_n n_161 n_160 vss vss sky130_fd_pr__nfet_01v8 W=0.42 L=0.15
Xn_161_p n_161 n_160 vdd vdd sky130_fd_pr__pfet_01v8 W=0.7 L=0.15
Xn_162_p1 n_162 n_160 n_162_x vdd sky130_fd_pr__pfet_01v8 W=1.4 L=0.15
Xn_162_p2 n_162_x n_101 vdd vdd sky130_fd_pr__pfet_01v8 W=1.4 L=0.15
Xn_162_n1 n_162 n_160 vss vss sky130_fd_pr__nfet_01v8 W=0.42 L=0.15
Xn_162_n2 n_162 n_101 vss vss sky130_fd_pr__nfet_01v8 W=0.42 L=0.15
Xn_163_p1 n_163 n_162 n_163_x vdd sky130_fd_pr__pfet_01v8 W=1.4 L=0.15
Xn_163_p2 n_163_x n_25 vdd vdd sky130_fd_pr__pfet_01v8 W=1.4 L=0.15
Xn_163_n1 n_163 n_162 vss vss sky130_fd_pr__nfet_01v8 W=0.42 L=0.15
Xn_163_n2 n_163 n_25 vss vss sky130_fd_pr__nfet_01v8 W=0.42 L=0.15
Xn_164_n n_164 n_163 vss vss sky130_fd_pr__nfet_01v8 W=0.42 L=0.15
Xn_164_p n_164 n_163 vdd vdd sky130_fd_pr__pfet_01v8 W=0.7 L=0.15
Xn_167_p1 n_167 n_161 n_167_x vdd sky130_fd_pr__pfet_01v8 W=1.4 L=0.15
Xn_167_p2 n_167_x n_101 vdd vdd sky130_fd_pr__pfet_01v8 W=1.4 L=0.15
Xn_167_n1 n_167 n_161 vss vss sky130_fd_pr__nfet_01v8 W=0.42 L=0.15
Xn_167_n2 n_167 n_101 vss vss sky130_fd_pr__nfet_01v8 W=0.42 L=0.15
Xn_166_p1 n_166 n_167 n_166_x vdd sky130_fd_pr__pfet_01v8 W=1.4 L=0.15
Xn_166_p2 n_166_x n_165 vdd vdd sky130_fd_pr__pfet_01v8 W=1.4 L=0.15
Xn_166_n1 n_166 n_167 vss vss sky130_fd_pr__nfet_01v8 W=0.42 L=0.15
Xn_166_n2 n_166 n_165 vss vss sky130_fd_pr__nfet_01v8 W=0.42 L=0.15
Xn_165_p1 n_165 n_164 n_165_x vdd sky130_fd_pr__pfet_01v8 W=1.4 L=0.15
Xn_165_p2 n_165_x n_166 vdd vdd sky130_fd_pr__pfet_01v8 W=1.4 L=0.15
Xn_165_n1 n_165 n_164 vss vss sky130_fd_pr__nfet_01v8 W=0.42 L=0.15
Xn_165_n2 n_165 n_166 vss vss sky130_fd_pr__nfet_01v8 W=0.42 L=0.15
Xn_168_p1 n_168 n_165 n_168_x vdd sky130_fd_pr__pfet_01v8 W=1.4 L=0.15
Xn_168_p2 n_168_x n_104 vdd vdd sky130_fd_pr__pfet_01v8 W=1.4 L=0.15
Xn_168_n1 n_168 n_165 vss vss sky130_fd_pr__nfet_01v8 W=0.42 L=0.15
Xn_168_n2 n_168 n_104 vss vss sky130_fd_pr__nfet_01v8 W=0.42 L=0.15
Xn_169_p1 n_169 n_168 n_169_x vdd sky130_fd_pr__pfet_01v8 W=1.4 L=0.15
Xn_169_p2 n_169_x n_25 vdd vdd sky130_fd_pr__pfet_01v8 W=1.4 L=0.15
Xn_169_n1 n_169 n_168 vss vss sky130_fd_pr__nfet_01v8 W=0.42 L=0.15
Xn_169_n2 n_169 n_25 vss vss sky130_fd_pr__nfet_01v8 W=0.42 L=0.15
Xn_170_n n_170 n_169 vss vss sky130_fd_pr__nfet_01v8 W=0.42 L=0.15
Xn_170_p n_170 n_169 vdd vdd sky130_fd_pr__pfet_01v8 W=0.7 L=0.15
Xn_172_p1 n_172 n_166 n_172_x vdd sky130_fd_pr__pfet_01v8 W=1.4 L=0.15
Xn_172_p2 n_172_x n_104 vdd vdd sky130_fd_pr__pfet_01v8 W=1.4 L=0.15
Xn_172_n1 n_172 n_166 vss vss sky130_fd_pr__nfet_01v8 W=0.42 L=0.15
Xn_172_n2 n_172 n_104 vss vss sky130_fd_pr__nfet_01v8 W=0.42 L=0.15
Xn_171_p1 n_171 n_172 n_171_x vdd sky130_fd_pr__pfet_01v8 W=1.4 L=0.15
Xn_171_p2 n_171_x fn1 vdd vdd sky130_fd_pr__pfet_01v8 W=1.4 L=0.15
Xn_171_n1 n_171 n_172 vss vss sky130_fd_pr__nfet_01v8 W=0.42 L=0.15
Xn_171_n2 n_171 fn1 vss vss sky130_fd_pr__nfet_01v8 W=0.42 L=0.15
Xfn1_p1 fn1 n_170 fn1_x vdd sky130_fd_pr__pfet_01v8 W=1.4 L=0.15
Xfn1_p2 fn1_x n_171 vdd vdd sky130_fd_pr__pfet_01v8 W=1.4 L=0.15
Xfn1_n1 fn1 n_170 vss vss sky130_fd_pr__nfet_01v8 W=0.42 L=0.15
Xfn1_n2 fn1 n_171 vss vss sky130_fd_pr__nfet_01v8 W=0.42 L=0.15
Xn_173_p1 n_173 fn1 vdd vdd sky130_fd_pr__pfet_01v8 W=0.7 L=0.15
Xn_173_p2 n_173 n_156 vdd vdd sky130_fd_pr__pfet_01v8 W=0.7 L=0.15
Xn_173_n1 n_173 fn1 n_173_x vss sky130_fd_pr__nfet_01v8 W=0.84 L=0.15
Xn_173_n2 n_173_x n_156 vss vss sky130_fd_pr__nfet_01v8 W=0.84 L=0.15
Xn_174_n n_174 n_173 vss vss sky130_fd_pr__nfet_01v8 W=0.42 L=0.15
Xn_174_p n_174 n_173 vdd vdd sky130_fd_pr__pfet_01v8 W=0.7 L=0.15
Xn_175_p1 n_175 fn2 vdd vdd sky130_fd_pr__pfet_01v8 W=0.7 L=0.15
Xn_175_p2 n_175 n_174 vdd vdd sky130_fd_pr__pfet_01v8 W=0.7 L=0.15
Xn_175_n1 n_175 fn2 n_175_x vss sky130_fd_pr__nfet_01v8 W=0.84 L=0.15
Xn_175_n2 n_175_x n_174 vss vss sky130_fd_pr__nfet_01v8 W=0.84 L=0.15
Xn_176_p1 n_176 fn2 vdd vdd sky130_fd_pr__pfet_01v8 W=0.7 L=0.15
Xn_176_p2 n_176 n_175 vdd vdd sky130_fd_pr__pfet_01v8 W=0.7 L=0.15
Xn_176_n1 n_176 fn2 n_176_x vss sky130_fd_pr__nfet_01v8 W=0.84 L=0.15
Xn_176_n2 n_176_x n_175 vss vss sky130_fd_pr__nfet_01v8 W=0.84 L=0.15
Xn_177_p1 n_177 n_174 vdd vdd sky130_fd_pr__pfet_01v8 W=0.7 L=0.15
Xn_177_p2 n_177 n_175 vdd vdd sky130_fd_pr__pfet_01v8 W=0.7 L=0.15
Xn_177_n1 n_177 n_174 n_177_x vss sky130_fd_pr__nfet_01v8 W=0.84 L=0.15
Xn_177_n2 n_177_x n_175 vss vss sky130_fd_pr__nfet_01v8 W=0.84 L=0.15
Xn_178_p1 n_178 n_176 vdd vdd sky130_fd_pr__pfet_01v8 W=0.7 L=0.15
Xn_178_p2 n_178 n_177 vdd vdd sky130_fd_pr__pfet_01v8 W=0.7 L=0.15
Xn_178_n1 n_178 n_176 n_178_x vss sky130_fd_pr__nfet_01v8 W=0.84 L=0.15
Xn_178_n2 n_178_x n_177 vss vss sky130_fd_pr__nfet_01v8 W=0.84 L=0.15
Xn_179_n n_179 n_178 vss vss sky130_fd_pr__nfet_01v8 W=0.42 L=0.15
Xn_179_p n_179 n_178 vdd vdd sky130_fd_pr__pfet_01v8 W=0.7 L=0.15
Xn_180_p1 n_180 n_178 n_180_x vdd sky130_fd_pr__pfet_01v8 W=1.4 L=0.15
Xn_180_p2 n_180_x n_101 vdd vdd sky130_fd_pr__pfet_01v8 W=1.4 L=0.15
Xn_180_n1 n_180 n_178 vss vss sky130_fd_pr__nfet_01v8 W=0.42 L=0.15
Xn_180_n2 n_180 n_101 vss vss sky130_fd_pr__nfet_01v8 W=0.42 L=0.15
Xn_181_p1 n_181 n_180 n_181_x vdd sky130_fd_pr__pfet_01v8 W=1.4 L=0.15
Xn_181_p2 n_181_x n_25 vdd vdd sky130_fd_pr__pfet_01v8 W=1.4 L=0.15
Xn_181_n1 n_181 n_180 vss vss sky130_fd_pr__nfet_01v8 W=0.42 L=0.15
Xn_181_n2 n_181 n_25 vss vss sky130_fd_pr__nfet_01v8 W=0.42 L=0.15
Xn_182_n n_182 n_181 vss vss sky130_fd_pr__nfet_01v8 W=0.42 L=0.15
Xn_182_p n_182 n_181 vdd vdd sky130_fd_pr__pfet_01v8 W=0.7 L=0.15
Xn_185_p1 n_185 n_179 n_185_x vdd sky130_fd_pr__pfet_01v8 W=1.4 L=0.15
Xn_185_p2 n_185_x n_101 vdd vdd sky130_fd_pr__pfet_01v8 W=1.4 L=0.15
Xn_185_n1 n_185 n_179 vss vss sky130_fd_pr__nfet_01v8 W=0.42 L=0.15
Xn_185_n2 n_185 n_101 vss vss sky130_fd_pr__nfet_01v8 W=0.42 L=0.15
Xn_184_p1 n_184 n_185 n_184_x vdd sky130_fd_pr__pfet_01v8 W=1.4 L=0.15
Xn_184_p2 n_184_x n_183 vdd vdd sky130_fd_pr__pfet_01v8 W=1.4 L=0.15
Xn_184_n1 n_184 n_185 vss vss sky130_fd_pr__nfet_01v8 W=0.42 L=0.15
Xn_184_n2 n_184 n_183 vss vss sky130_fd_pr__nfet_01v8 W=0.42 L=0.15
Xn_183_p1 n_183 n_182 n_183_x vdd sky130_fd_pr__pfet_01v8 W=1.4 L=0.15
Xn_183_p2 n_183_x n_184 vdd vdd sky130_fd_pr__pfet_01v8 W=1.4 L=0.15
Xn_183_n1 n_183 n_182 vss vss sky130_fd_pr__nfet_01v8 W=0.42 L=0.15
Xn_183_n2 n_183 n_184 vss vss sky130_fd_pr__nfet_01v8 W=0.42 L=0.15
Xn_186_p1 n_186 n_183 n_186_x vdd sky130_fd_pr__pfet_01v8 W=1.4 L=0.15
Xn_186_p2 n_186_x n_104 vdd vdd sky130_fd_pr__pfet_01v8 W=1.4 L=0.15
Xn_186_n1 n_186 n_183 vss vss sky130_fd_pr__nfet_01v8 W=0.42 L=0.15
Xn_186_n2 n_186 n_104 vss vss sky130_fd_pr__nfet_01v8 W=0.42 L=0.15
Xn_187_p1 n_187 n_186 n_187_x vdd sky130_fd_pr__pfet_01v8 W=1.4 L=0.15
Xn_187_p2 n_187_x n_25 vdd vdd sky130_fd_pr__pfet_01v8 W=1.4 L=0.15
Xn_187_n1 n_187 n_186 vss vss sky130_fd_pr__nfet_01v8 W=0.42 L=0.15
Xn_187_n2 n_187 n_25 vss vss sky130_fd_pr__nfet_01v8 W=0.42 L=0.15
Xn_188_n n_188 n_187 vss vss sky130_fd_pr__nfet_01v8 W=0.42 L=0.15
Xn_188_p n_188 n_187 vdd vdd sky130_fd_pr__pfet_01v8 W=0.7 L=0.15
Xn_190_p1 n_190 n_184 n_190_x vdd sky130_fd_pr__pfet_01v8 W=1.4 L=0.15
Xn_190_p2 n_190_x n_104 vdd vdd sky130_fd_pr__pfet_01v8 W=1.4 L=0.15
Xn_190_n1 n_190 n_184 vss vss sky130_fd_pr__nfet_01v8 W=0.42 L=0.15
Xn_190_n2 n_190 n_104 vss vss sky130_fd_pr__nfet_01v8 W=0.42 L=0.15
Xn_189_p1 n_189 n_190 n_189_x vdd sky130_fd_pr__pfet_01v8 W=1.4 L=0.15
Xn_189_p2 n_189_x fn2 vdd vdd sky130_fd_pr__pfet_01v8 W=1.4 L=0.15
Xn_189_n1 n_189 n_190 vss vss sky130_fd_pr__nfet_01v8 W=0.42 L=0.15
Xn_189_n2 n_189 fn2 vss vss sky130_fd_pr__nfet_01v8 W=0.42 L=0.15
Xfn2_p1 fn2 n_188 fn2_x vdd sky130_fd_pr__pfet_01v8 W=1.4 L=0.15
Xfn2_p2 fn2_x n_189 vdd vdd sky130_fd_pr__pfet_01v8 W=1.4 L=0.15
Xfn2_n1 fn2 n_188 vss vss sky130_fd_pr__nfet_01v8 W=0.42 L=0.15
Xfn2_n2 fn2 n_189 vss vss sky130_fd_pr__nfet_01v8 W=0.42 L=0.15
Xn_191_n n_191 n_124 vss vss sky130_fd_pr__nfet_01v8 W=0.42 L=0.15
Xn_191_p n_191 n_124 vdd vdd sky130_fd_pr__pfet_01v8 W=0.7 L=0.15
Xn_192_p1 n_192 n_94 vdd vdd sky130_fd_pr__pfet_01v8 W=0.7 L=0.15
Xn_192_p2 n_192 n_191 vdd vdd sky130_fd_pr__pfet_01v8 W=0.7 L=0.15
Xn_192_n1 n_192 n_94 n_192_x vss sky130_fd_pr__nfet_01v8 W=0.84 L=0.15
Xn_192_n2 n_192_x n_191 vss vss sky130_fd_pr__nfet_01v8 W=0.84 L=0.15
Xn_193_n n_193 n_192 vss vss sky130_fd_pr__nfet_01v8 W=0.42 L=0.15
Xn_193_p n_193 n_192 vdd vdd sky130_fd_pr__pfet_01v8 W=0.7 L=0.15
Xn_194_p1 n_194 cb_ack vdd vdd sky130_fd_pr__pfet_01v8 W=0.7 L=0.15
Xn_194_p2 n_194 n_90 vdd vdd sky130_fd_pr__pfet_01v8 W=0.7 L=0.15
Xn_194_n1 n_194 cb_ack n_194_x vss sky130_fd_pr__nfet_01v8 W=0.84 L=0.15
Xn_194_n2 n_194_x n_90 vss vss sky130_fd_pr__nfet_01v8 W=0.84 L=0.15
Xn_195_n n_195 n_194 vss vss sky130_fd_pr__nfet_01v8 W=0.42 L=0.15
Xn_195_p n_195 n_194 vdd vdd sky130_fd_pr__pfet_01v8 W=0.7 L=0.15
Xn_196_p1 n_196 n_195 n_196_x vdd sky130_fd_pr__pfet_01v8 W=1.4 L=0.15
Xn_196_p2 n_196_x n_193 vdd vdd sky130_fd_pr__pfet_01v8 W=1.4 L=0.15
Xn_196_n1 n_196 n_195 vss vss sky130_fd_pr__nfet_01v8 W=0.42 L=0.15
Xn_196_n2 n_196 n_193 vss vss sky130_fd_pr__nfet_01v8 W=0.42 L=0.15
Xn_197_n n_197 n_196 vss vss sky130_fd_pr__nfet_01v8 W=0.42 L=0.15
Xn_197_p n_197 n_196 vdd vdd sky130_fd_pr__pfet_01v8 W=0.7 L=0.15
Xn_198_p1 n_198 c_got vdd vdd sky130_fd_pr__pfet_01v8 W=0.7 L=0.15
Xn_198_p2 n_198 n_197 vdd vdd sky130_fd_pr__pfet_01v8 W=0.7 L=0.15
Xn_198_n1 n_198 c_got n_198_x vss sky130_fd_pr__nfet_01v8 W=0.84 L=0.15
Xn_198_n2 n_198_x n_197 vss vss sky130_fd_pr__nfet_01v8 W=0.84 L=0.15
Xn_199_n n_199 n_198 vss vss sky130_fd_pr__nfet_01v8 W=0.42 L=0.15
Xn_199_p n_199 n_198 vdd vdd sky130_fd_pr__pfet_01v8 W=0.7 L=0.15
Xn_201_p1 n_201 n_199 n_201_x vdd sky130_fd_pr__pfet_01v8 W=1.4 L=0.15
Xn_201_p2 n_201_x n_200 vdd vdd sky130_fd_pr__pfet_01v8 W=1.4 L=0.15
Xn_201_n1 n_201 n_199 vss vss sky130_fd_pr__nfet_01v8 W=0.42 L=0.15
Xn_201_n2 n_201 n_200 vss vss sky130_fd_pr__nfet_01v8 W=0.42 L=0.15
Xn_200_p1 n_200 n_89 n_200_x vdd sky130_fd_pr__pfet_01v8 W=1.4 L=0.15
Xn_200_p2 n_200_x n_201 vdd vdd sky130_fd_pr__pfet_01v8 W=1.4 L=0.15
Xn_200_n1 n_200 n_89 vss vss sky130_fd_pr__nfet_01v8 W=0.42 L=0.15
Xn_200_n2 n_200 n_201 vss vss sky130_fd_pr__nfet_01v8 W=0.42 L=0.15
Xcb_req_p1 cb_req n_89 cb_req_x vdd sky130_fd_pr__pfet_01v8 W=1.4 L=0.15
Xcb_req_p2 cb_req_x n_200 vdd vdd sky130_fd_pr__pfet_01v8 W=1.4 L=0.15
Xcb_req_n1 cb_req n_89 vss vss sky130_fd_pr__nfet_01v8 W=0.42 L=0.15
Xcb_req_n2 cb_req n_200 vss vss sky130_fd_pr__nfet_01v8 W=0.42 L=0.15
Xn_202_p1 n_202 cb_ack vdd vdd sky130_fd_pr__pfet_01v8 W=0.7 L=0.15
Xn_202_p2 n_202 c_got vdd vdd sky130_fd_pr__pfet_01v8 W=0.7 L=0.15
Xn_202_n1 n_202 cb_ack n_202_x vss sky130_fd_pr__nfet_01v8 W=0.84 L=0.15
Xn_202_n2 n_202_x c_got vss vss sky130_fd_pr__nfet_01v8 W=0.84 L=0.15
Xn_203_n n_203 n_202 vss vss sky130_fd_pr__nfet_01v8 W=0.42 L=0.15
Xn_203_p n_203 n_202 vdd vdd sky130_fd_pr__pfet_01v8 W=0.7 L=0.15
Xn_204_p1 n_204 n_203 vdd vdd sky130_fd_pr__pfet_01v8 W=0.7 L=0.15
Xn_204_p2 n_204 n_90 vdd vdd sky130_fd_pr__pfet_01v8 W=0.7 L=0.15
Xn_204_n1 n_204 n_203 n_204_x vss sky130_fd_pr__nfet_01v8 W=0.84 L=0.15
Xn_204_n2 n_204_x n_90 vss vss sky130_fd_pr__nfet_01v8 W=0.84 L=0.15
Xn_205_n n_205 n_204 vss vss sky130_fd_pr__nfet_01v8 W=0.42 L=0.15
Xn_205_p n_205 n_204 vdd vdd sky130_fd_pr__pfet_01v8 W=0.7 L=0.15
Xn_206_n n_206 coarse_en vss vss sky130_fd_pr__nfet_01v8 W=0.42 L=0.15
Xn_206_p n_206 coarse_en vdd vdd sky130_fd_pr__pfet_01v8 W=0.7 L=0.15
Xn_207_p1 n_207 n_30 vdd vdd sky130_fd_pr__pfet_01v8 W=0.7 L=0.15
Xn_207_p2 n_207 n_206 vdd vdd sky130_fd_pr__pfet_01v8 W=0.7 L=0.15
Xn_207_n1 n_207 n_30 n_207_x vss sky130_fd_pr__nfet_01v8 W=0.84 L=0.15
Xn_207_n2 n_207_x n_206 vss vss sky130_fd_pr__nfet_01v8 W=0.84 L=0.15
Xn_208_n n_208 n_207 vss vss sky130_fd_pr__nfet_01v8 W=0.42 L=0.15
Xn_208_p n_208 n_207 vdd vdd sky130_fd_pr__pfet_01v8 W=0.7 L=0.15
Xn_209_p1 n_209 n_205 n_209_x vdd sky130_fd_pr__pfet_01v8 W=1.4 L=0.15
Xn_209_p2 n_209_x n_208 vdd vdd sky130_fd_pr__pfet_01v8 W=1.4 L=0.15
Xn_209_n1 n_209 n_205 vss vss sky130_fd_pr__nfet_01v8 W=0.42 L=0.15
Xn_209_n2 n_209 n_208 vss vss sky130_fd_pr__nfet_01v8 W=0.42 L=0.15
Xn_210_n n_210 n_209 vss vss sky130_fd_pr__nfet_01v8 W=0.42 L=0.15
Xn_210_p n_210 n_209 vdd vdd sky130_fd_pr__pfet_01v8 W=0.7 L=0.15
Xn_211_p1 n_211 n_1 n_211_x vdd sky130_fd_pr__pfet_01v8 W=1.4 L=0.15
Xn_211_p2 n_211_x n_210 vdd vdd sky130_fd_pr__pfet_01v8 W=1.4 L=0.15
Xn_211_n1 n_211 n_1 vss vss sky130_fd_pr__nfet_01v8 W=0.42 L=0.15
Xn_211_n2 n_211 n_210 vss vss sky130_fd_pr__nfet_01v8 W=0.42 L=0.15
Xn_212_n n_212 n_211 vss vss sky130_fd_pr__nfet_01v8 W=0.42 L=0.15
Xn_212_p n_212 n_211 vdd vdd sky130_fd_pr__pfet_01v8 W=0.7 L=0.15
Xn_213_p1 n_213 n_40 n_213_x vdd sky130_fd_pr__pfet_01v8 W=1.4 L=0.15
Xn_213_p2 n_213_x run vdd vdd sky130_fd_pr__pfet_01v8 W=1.4 L=0.15
Xn_213_n1 n_213 n_40 vss vss sky130_fd_pr__nfet_01v8 W=0.42 L=0.15
Xn_213_n2 n_213 run vss vss sky130_fd_pr__nfet_01v8 W=0.42 L=0.15
Xrun_p1 run n_212 run_x vdd sky130_fd_pr__pfet_01v8 W=1.4 L=0.15
Xrun_p2 run_x n_213 vdd vdd sky130_fd_pr__pfet_01v8 W=1.4 L=0.15
Xrun_n1 run n_212 vss vss sky130_fd_pr__nfet_01v8 W=0.42 L=0.15
Xrun_n2 run n_213 vss vss sky130_fd_pr__nfet_01v8 W=0.42 L=0.15
Xn_215_p1 n_215 cmp_ack n_215_x vdd sky130_fd_pr__pfet_01v8 W=1.4 L=0.15
Xn_215_p2 n_215_x n_214 vdd vdd sky130_fd_pr__pfet_01v8 W=1.4 L=0.15
Xn_215_n1 n_215 cmp_ack vss vss sky130_fd_pr__nfet_01v8 W=0.42 L=0.15
Xn_215_n2 n_215 n_214 vss vss sky130_fd_pr__nfet_01v8 W=0.42 L=0.15
Xn_214_p1 n_214 n_1 n_214_x vdd sky130_fd_pr__pfet_01v8 W=1.4 L=0.15
Xn_214_p2 n_214_x n_215 vdd vdd sky130_fd_pr__pfet_01v8 W=1.4 L=0.15
Xn_214_n1 n_214 n_1 vss vss sky130_fd_pr__nfet_01v8 W=0.42 L=0.15
Xn_214_n2 n_214 n_215 vss vss sky130_fd_pr__nfet_01v8 W=0.42 L=0.15
Xn_218_n n_218 n_214 vss vss sky130_fd_pr__nfet_01v8 W=0.42 L=0.15
Xn_218_p n_218 n_214 vdd vdd sky130_fd_pr__pfet_01v8 W=0.7 L=0.15
Xn_219_p1 n_219 n_214 vdd vdd sky130_fd_pr__pfet_01v8 W=0.7 L=0.15
Xn_219_p2 n_219 n_216 vdd vdd sky130_fd_pr__pfet_01v8 W=0.7 L=0.15
Xn_219_n1 n_219 n_214 n_219_x vss sky130_fd_pr__nfet_01v8 W=0.84 L=0.15
Xn_219_n2 n_219_x n_216 vss vss sky130_fd_pr__nfet_01v8 W=0.84 L=0.15
Xn_220_p1 n_220 n_218 vdd vdd sky130_fd_pr__pfet_01v8 W=0.7 L=0.15
Xn_220_p2 n_220 n_217 vdd vdd sky130_fd_pr__pfet_01v8 W=0.7 L=0.15
Xn_220_n1 n_220 n_218 n_220_x vss sky130_fd_pr__nfet_01v8 W=0.84 L=0.15
Xn_220_n2 n_220_x n_217 vss vss sky130_fd_pr__nfet_01v8 W=0.84 L=0.15
Xn_221_p1 n_221 n_219 vdd vdd sky130_fd_pr__pfet_01v8 W=0.7 L=0.15
Xn_221_p2 n_221 n_220 vdd vdd sky130_fd_pr__pfet_01v8 W=0.7 L=0.15
Xn_221_n1 n_221 n_219 n_221_x vss sky130_fd_pr__nfet_01v8 W=0.84 L=0.15
Xn_221_n2 n_221_x n_220 vss vss sky130_fd_pr__nfet_01v8 W=0.84 L=0.15
Xn_222_p1 n_222 cmp_req vdd vdd sky130_fd_pr__pfet_01v8 W=0.7 L=0.15
Xn_222_p2 n_222 n_221 vdd vdd sky130_fd_pr__pfet_01v8 W=0.7 L=0.15
Xn_222_n1 n_222 cmp_req n_222_x vss sky130_fd_pr__nfet_01v8 W=0.84 L=0.15
Xn_222_n2 n_222_x n_221 vss vss sky130_fd_pr__nfet_01v8 W=0.84 L=0.15
Xn_223_n n_223 n_222 vss vss sky130_fd_pr__nfet_01v8 W=0.42 L=0.15
Xn_223_p n_223 n_222 vdd vdd sky130_fd_pr__pfet_01v8 W=0.7 L=0.15
Xn_224_n n_224 cmp_req vss vss sky130_fd_pr__nfet_01v8 W=0.42 L=0.15
Xn_224_p n_224 cmp_req vdd vdd sky130_fd_pr__pfet_01v8 W=0.7 L=0.15
Xacq_p1 acq n_224 acq_x vdd sky130_fd_pr__pfet_01v8 W=1.4 L=0.15
Xacq_p2 acq_x n_223 vdd vdd sky130_fd_pr__pfet_01v8 W=1.4 L=0.15
Xacq_n1 acq n_224 vss vss sky130_fd_pr__nfet_01v8 W=0.42 L=0.15
Xacq_n2 acq n_223 vss vss sky130_fd_pr__nfet_01v8 W=0.42 L=0.15
Xn_226_p1 n_226 n_223 vdd vdd sky130_fd_pr__pfet_01v8 W=0.7 L=0.15
Xn_226_p2 n_226 n_225 vdd vdd sky130_fd_pr__pfet_01v8 W=0.7 L=0.15
Xn_226_n1 n_226 n_223 n_226_x vss sky130_fd_pr__nfet_01v8 W=0.84 L=0.15
Xn_226_n2 n_226_x n_225 vss vss sky130_fd_pr__nfet_01v8 W=0.84 L=0.15
Xn_227_n n_227 n_226 vss vss sky130_fd_pr__nfet_01v8 W=0.42 L=0.15
Xn_227_p n_227 n_226 vdd vdd sky130_fd_pr__pfet_01v8 W=0.7 L=0.15
Xn_228_n n_228 c2n vss vss sky130_fd_pr__nfet_01v8 W=0.42 L=0.15
Xn_228_p n_228 c2n vdd vdd sky130_fd_pr__pfet_01v8 W=0.7 L=0.15
Xn_229_p1 n_229 c2p n_229_x vdd sky130_fd_pr__pfet_01v8 W=1.4 L=0.15
Xn_229_p2 n_229_x n_228 vdd vdd sky130_fd_pr__pfet_01v8 W=1.4 L=0.15
Xn_229_n1 n_229 c2p vss vss sky130_fd_pr__nfet_01v8 W=0.42 L=0.15
Xn_229_n2 n_229 n_228 vss vss sky130_fd_pr__nfet_01v8 W=0.42 L=0.15
Xn_230_n n_230 c2p vss vss sky130_fd_pr__nfet_01v8 W=0.42 L=0.15
Xn_230_p n_230 c2p vdd vdd sky130_fd_pr__pfet_01v8 W=0.7 L=0.15
Xn_231_p1 n_231 c2n n_231_x vdd sky130_fd_pr__pfet_01v8 W=1.4 L=0.15
Xn_231_p2 n_231_x n_230 vdd vdd sky130_fd_pr__pfet_01v8 W=1.4 L=0.15
Xn_231_n1 n_231 c2n vss vss sky130_fd_pr__nfet_01v8 W=0.42 L=0.15
Xn_231_n2 n_231 n_230 vss vss sky130_fd_pr__nfet_01v8 W=0.42 L=0.15
Xn_232_p1 n_232 n_229 n_232_x vdd sky130_fd_pr__pfet_01v8 W=1.4 L=0.15
Xn_232_p2 n_232_x n_231 vdd vdd sky130_fd_pr__pfet_01v8 W=1.4 L=0.15
Xn_232_n1 n_232 n_229 vss vss sky130_fd_pr__nfet_01v8 W=0.42 L=0.15
Xn_232_n2 n_232 n_231 vss vss sky130_fd_pr__nfet_01v8 W=0.42 L=0.15
Xn_233_n n_233 n_232 vss vss sky130_fd_pr__nfet_01v8 W=0.42 L=0.15
Xn_233_p n_233 n_232 vdd vdd sky130_fd_pr__pfet_01v8 W=0.7 L=0.15
Xn_234_p1 n_234 n_233 vdd vdd sky130_fd_pr__pfet_01v8 W=0.7 L=0.15
Xn_234_p2 n_234 n_227 vdd vdd sky130_fd_pr__pfet_01v8 W=0.7 L=0.15
Xn_234_n1 n_234 n_233 n_234_x vss sky130_fd_pr__nfet_01v8 W=0.84 L=0.15
Xn_234_n2 n_234_x n_227 vss vss sky130_fd_pr__nfet_01v8 W=0.84 L=0.15
Xn_235_n n_235 n_234 vss vss sky130_fd_pr__nfet_01v8 W=0.42 L=0.15
Xn_235_p n_235 n_234 vdd vdd sky130_fd_pr__pfet_01v8 W=0.7 L=0.15
Xn_236_n n_236 cmp_req vss vss sky130_fd_pr__nfet_01v8 W=0.42 L=0.15
Xn_236_p n_236 cmp_req vdd vdd sky130_fd_pr__pfet_01v8 W=0.7 L=0.15
Xn_238_p1 n_238 n_235 n_238_x vdd sky130_fd_pr__pfet_01v8 W=1.4 L=0.15
Xn_238_p2 n_238_x n_237 vdd vdd sky130_fd_pr__pfet_01v8 W=1.4 L=0.15
Xn_238_n1 n_238 n_235 vss vss sky130_fd_pr__nfet_01v8 W=0.42 L=0.15
Xn_238_n2 n_238 n_237 vss vss sky130_fd_pr__nfet_01v8 W=0.42 L=0.15
Xn_237_p1 n_237 n_236 n_237_x vdd sky130_fd_pr__pfet_01v8 W=1.4 L=0.15
Xn_237_p2 n_237_x n_238 vdd vdd sky130_fd_pr__pfet_01v8 W=1.4 L=0.15
Xn_237_n1 n_237 n_236 vss vss sky130_fd_pr__nfet_01v8 W=0.42 L=0.15
Xn_237_n2 n_237 n_238 vss vss sky130_fd_pr__nfet_01v8 W=0.42 L=0.15
Xn_239_n n_239 clk_f vss vss sky130_fd_pr__nfet_01v8 W=0.42 L=0.15
Xn_239_p n_239 clk_f vdd vdd sky130_fd_pr__pfet_01v8 W=0.7 L=0.15
Xn_240_n n_240 n_239 vss vss sky130_fd_pr__nfet_01v8 W=0.42 L=0.15
Xn_240_p n_240 n_239 vdd vdd sky130_fd_pr__pfet_01v8 W=0.7 L=0.15
Xn_242_n n_242 cmp_req vss vss sky130_fd_pr__nfet_01v8 W=0.42 L=0.15
Xn_242_p n_242 cmp_req vdd vdd sky130_fd_pr__pfet_01v8 W=0.7 L=0.15
Xn_244_p1 n_244 n_241 n_244_x vdd sky130_fd_pr__pfet_01v8 W=1.4 L=0.15
Xn_244_p2 n_244_x n_243 vdd vdd sky130_fd_pr__pfet_01v8 W=1.4 L=0.15
Xn_244_n1 n_244 n_241 vss vss sky130_fd_pr__nfet_01v8 W=0.42 L=0.15
Xn_244_n2 n_244 n_243 vss vss sky130_fd_pr__nfet_01v8 W=0.42 L=0.15
Xn_243_p1 n_243 n_242 n_243_x vdd sky130_fd_pr__pfet_01v8 W=1.4 L=0.15
Xn_243_p2 n_243_x n_244 vdd vdd sky130_fd_pr__pfet_01v8 W=1.4 L=0.15
Xn_243_n1 n_243 n_242 vss vss sky130_fd_pr__nfet_01v8 W=0.42 L=0.15
Xn_243_n2 n_243 n_244 vss vss sky130_fd_pr__nfet_01v8 W=0.42 L=0.15
Xn_245_p1 n_245 n_237 vdd vdd sky130_fd_pr__pfet_01v8 W=0.7 L=0.15
Xn_245_p2 n_245 n_243 vdd vdd sky130_fd_pr__pfet_01v8 W=0.7 L=0.15
Xn_245_n1 n_245 n_237 n_245_x vss sky130_fd_pr__nfet_01v8 W=0.84 L=0.15
Xn_245_n2 n_245_x n_243 vss vss sky130_fd_pr__nfet_01v8 W=0.84 L=0.15
Xn_246_p1 n_246 n_227 vdd vdd sky130_fd_pr__pfet_01v8 W=0.7 L=0.15
Xn_246_p2 n_246 n_245 vdd vdd sky130_fd_pr__pfet_01v8 W=0.7 L=0.15
Xn_246_n1 n_246 n_227 n_246_x vss sky130_fd_pr__nfet_01v8 W=0.84 L=0.15
Xn_246_n2 n_246_x n_245 vss vss sky130_fd_pr__nfet_01v8 W=0.84 L=0.15
Xn_247_n n_247 n_246 vss vss sky130_fd_pr__nfet_01v8 W=0.42 L=0.15
Xn_247_p n_247 n_246 vdd vdd sky130_fd_pr__pfet_01v8 W=0.7 L=0.15
Xn_248_n n_248 n_247 vss vss sky130_fd_pr__nfet_01v8 W=0.42 L=0.15
Xn_248_p n_248 n_247 vdd vdd sky130_fd_pr__pfet_01v8 W=0.7 L=0.15
Xclk_f_n clk_f n_248 vss vss sky130_fd_pr__nfet_01v8 W=0.42 L=0.15
Xclk_f_p clk_f n_248 vdd vdd sky130_fd_pr__pfet_01v8 W=0.7 L=0.15
Xclk_f_c clk_f vss sky130_fd_pr__cap_mim_m3_1 W=13.42 L=13.42
Xn_249_p1 n_249 sign vdd vdd sky130_fd_pr__pfet_01v8 W=0.7 L=0.15
Xn_249_p2 n_249 n_231 vdd vdd sky130_fd_pr__pfet_01v8 W=0.7 L=0.15
Xn_249_n1 n_249 sign n_249_x vss sky130_fd_pr__nfet_01v8 W=0.84 L=0.15
Xn_249_n2 n_249_x n_231 vss vss sky130_fd_pr__nfet_01v8 W=0.84 L=0.15
Xn_250_p1 n_250 n_42 vdd vdd sky130_fd_pr__pfet_01v8 W=0.7 L=0.15
Xn_250_p2 n_250 n_229 vdd vdd sky130_fd_pr__pfet_01v8 W=0.7 L=0.15
Xn_250_n1 n_250 n_42 n_250_x vss sky130_fd_pr__nfet_01v8 W=0.84 L=0.15
Xn_250_n2 n_250_x n_229 vss vss sky130_fd_pr__nfet_01v8 W=0.84 L=0.15
Xn_251_p1 n_251 n_249 vdd vdd sky130_fd_pr__pfet_01v8 W=0.7 L=0.15
Xn_251_p2 n_251 n_250 vdd vdd sky130_fd_pr__pfet_01v8 W=0.7 L=0.15
Xn_251_n1 n_251 n_249 n_251_x vss sky130_fd_pr__nfet_01v8 W=0.84 L=0.15
Xn_251_n2 n_251_x n_250 vss vss sky130_fd_pr__nfet_01v8 W=0.84 L=0.15
Xn_252_p1 n_252 sign vdd vdd sky130_fd_pr__pfet_01v8 W=0.7 L=0.15
Xn_252_p2 n_252 n_229 vdd vdd sky130_fd_pr__pfet_01v8 W=0.7 L=0.15
Xn_252_n1 n_252 sign n_252_x vss sky130_fd_pr__nfet_01v8 W=0.84 L=0.15
Xn_252_n2 n_252_x n_229 vss vss sky130_fd_pr__nfet_01v8 W=0.84 L=0.15
Xn_253_p1 n_253 n_42 vdd vdd sky130_fd_pr__pfet_01v8 W=0.7 L=0.15
Xn_253_p2 n_253 n_231 vdd vdd sky130_fd_pr__pfet_01v8 W=0.7 L=0.15
Xn_253_n1 n_253 n_42 n_253_x vss sky130_fd_pr__nfet_01v8 W=0.84 L=0.15
Xn_253_n2 n_253_x n_231 vss vss sky130_fd_pr__nfet_01v8 W=0.84 L=0.15
Xn_254_p1 n_254 n_252 vdd vdd sky130_fd_pr__pfet_01v8 W=0.7 L=0.15
Xn_254_p2 n_254 n_253 vdd vdd sky130_fd_pr__pfet_01v8 W=0.7 L=0.15
Xn_254_n1 n_254 n_252 n_254_x vss sky130_fd_pr__nfet_01v8 W=0.84 L=0.15
Xn_254_n2 n_254_x n_253 vss vss sky130_fd_pr__nfet_01v8 W=0.84 L=0.15
Xn_255_p1 n_255 n_254 n_255_x vdd sky130_fd_pr__pfet_01v8 W=1.4 L=0.15
Xn_255_p2 n_255_x n_1 vdd vdd sky130_fd_pr__pfet_01v8 W=1.4 L=0.15
Xn_255_n1 n_255 n_254 vss vss sky130_fd_pr__nfet_01v8 W=0.42 L=0.15
Xn_255_n2 n_255 n_1 vss vss sky130_fd_pr__nfet_01v8 W=0.42 L=0.15
Xn_256_n n_256 n_255 vss vss sky130_fd_pr__nfet_01v8 W=0.42 L=0.15
Xn_256_p n_256 n_255 vdd vdd sky130_fd_pr__pfet_01v8 W=0.7 L=0.15
Xn_257_p1 n_257 n_251 n_257_x vdd sky130_fd_pr__pfet_01v8 W=1.4 L=0.15
Xn_257_p2 n_257_x cmp_result vdd vdd sky130_fd_pr__pfet_01v8 W=1.4 L=0.15
Xn_257_n1 n_257 n_251 vss vss sky130_fd_pr__nfet_01v8 W=0.42 L=0.15
Xn_257_n2 n_257 cmp_result vss vss sky130_fd_pr__nfet_01v8 W=0.42 L=0.15
Xcmp_result_p1 cmp_result n_256 cmp_result_x vdd sky130_fd_pr__pfet_01v8 W=1.4 L=0.15
Xcmp_result_p2 cmp_result_x n_257 vdd vdd sky130_fd_pr__pfet_01v8 W=1.4 L=0.15
Xcmp_result_n1 cmp_result n_256 vss vss sky130_fd_pr__nfet_01v8 W=0.42 L=0.15
Xcmp_result_n2 cmp_result n_257 vss vss sky130_fd_pr__nfet_01v8 W=0.42 L=0.15
Xn_258_p1 n_258 n_233 n_258_x vdd sky130_fd_pr__pfet_01v8 W=1.4 L=0.15
Xn_258_p2 n_258_x n_247 vdd vdd sky130_fd_pr__pfet_01v8 W=1.4 L=0.15
Xn_258_n1 n_258 n_233 vss vss sky130_fd_pr__nfet_01v8 W=0.42 L=0.15
Xn_258_n2 n_258 n_247 vss vss sky130_fd_pr__nfet_01v8 W=0.42 L=0.15
Xn_259_p1 n_259 n_237 vdd vdd sky130_fd_pr__pfet_01v8 W=0.7 L=0.15
Xn_259_p2 n_259 n_258 vdd vdd sky130_fd_pr__pfet_01v8 W=0.7 L=0.15
Xn_259_n1 n_259 n_237 n_259_x vss sky130_fd_pr__nfet_01v8 W=0.84 L=0.15
Xn_259_n2 n_259_x n_258 vss vss sky130_fd_pr__nfet_01v8 W=0.84 L=0.15
Xn_260_n n_260 n_259 vss vss sky130_fd_pr__nfet_01v8 W=0.42 L=0.15
Xn_260_p n_260 n_259 vdd vdd sky130_fd_pr__pfet_01v8 W=0.7 L=0.15
Xn_262_p1 n_262 n_260 vdd vdd sky130_fd_pr__pfet_01v8 W=0.7 L=0.15
Xn_262_p2 n_262 n_261 vdd vdd sky130_fd_pr__pfet_01v8 W=0.7 L=0.15
Xn_262_n1 n_262 n_260 n_262_x vss sky130_fd_pr__nfet_01v8 W=0.84 L=0.15
Xn_262_n2 n_262_x n_261 vss vss sky130_fd_pr__nfet_01v8 W=0.84 L=0.15
Xn_263_n n_263 n_262 vss vss sky130_fd_pr__nfet_01v8 W=0.42 L=0.15
Xn_263_p n_263 n_262 vdd vdd sky130_fd_pr__pfet_01v8 W=0.7 L=0.15
Xn_264_p1 n_264 n_263 vdd vdd sky130_fd_pr__pfet_01v8 W=0.7 L=0.15
Xn_264_p2 n_264 cmp_req vdd vdd sky130_fd_pr__pfet_01v8 W=0.7 L=0.15
Xn_264_n1 n_264 n_263 n_264_x vss sky130_fd_pr__nfet_01v8 W=0.84 L=0.15
Xn_264_n2 n_264_x cmp_req vss vss sky130_fd_pr__nfet_01v8 W=0.84 L=0.15
Xcmp_ack_n cmp_ack n_264 vss vss sky130_fd_pr__nfet_01v8 W=0.42 L=0.15
Xcmp_ack_p cmp_ack n_264 vdd vdd sky130_fd_pr__pfet_01v8 W=0.7 L=0.15
Xn_265_p1 n_265 ota_en n_265_x vdd sky130_fd_pr__pfet_01v8 W=1.4 L=0.15
Xn_265_p2 n_265_x acq vdd vdd sky130_fd_pr__pfet_01v8 W=1.4 L=0.15
Xn_265_n1 n_265 ota_en vss vss sky130_fd_pr__nfet_01v8 W=0.42 L=0.15
Xn_265_n2 n_265 acq vss vss sky130_fd_pr__nfet_01v8 W=0.42 L=0.15
Xawake_n awake n_265 vss vss sky130_fd_pr__nfet_01v8 W=0.42 L=0.15
Xawake_p awake n_265 vdd vdd sky130_fd_pr__pfet_01v8 W=0.7 L=0.15
Xn_266_p1 n_266 coarse_en n_266_x vdd sky130_fd_pr__pfet_01v8 W=1.4 L=0.15
Xn_266_p2 n_266_x cmp_req vdd vdd sky130_fd_pr__pfet_01v8 W=1.4 L=0.15
Xn_266_n1 n_266 coarse_en vss vss sky130_fd_pr__nfet_01v8 W=0.42 L=0.15
Xn_266_n2 n_266 cmp_req vss vss sky130_fd_pr__nfet_01v8 W=0.42 L=0.15
Xbusy_n busy n_266 vss vss sky130_fd_pr__nfet_01v8 W=0.42 L=0.15
Xbusy_p busy n_266 vdd vdd sky130_fd_pr__pfet_01v8 W=0.7 L=0.15
.ends conv_seq

.subckt tile_seq seq_rst_n integ_req integ_ack win_hi lora_en x_mag0 x_mag1 x_mag2 x_mag3 x_mag4 x_mag5 x_mag6 x_mag7 x_mag8 x_mag9 x_mag10 x_mag11 x_mag12 x_mag13 x_mag14 x_mag15 x_mag16 x_mag17 x_mag18 x_mag19 x_mag20 x_mag21 x_mag22 x_mag23 x_mag24 x_mag25 x_mag26 x_mag27 x_mag28 x_mag29 x_mag30 x_mag31 x_mag32 x_mag33 x_mag34 x_mag35 x_mag36 x_mag37 x_mag38 x_mag39 x_mag40 x_mag41 x_mag42 x_mag43 x_mag44 x_mag45 x_mag46 x_mag47 x_mag48 x_mag49 x_mag50 x_mag51 x_mag52 x_mag53 x_mag54 x_mag55 x_mag56 x_mag57 x_mag58 x_mag59 x_mag60 x_mag61 x_mag62 x_mag63 x_neg0 x_neg1 x_neg2 x_neg3 x_neg4 x_neg5 x_neg6 x_neg7 x_neg8 x_neg9 x_neg10 x_neg11 x_neg12 x_neg13 x_neg14 x_neg15 sdone0 sdone1 sdone2 sdone3 sdone4 sdone5 sdone6 sdone7 sdone8 sdone9 sdone10 sdone11 sdone12 sdone13 sdone14 sdone15 sdone16 busy0 busy1 busy2 busy3 busy4 busy5 busy6 busy7 busy8 busy9 busy10 busy11 busy12 busy13 busy14 busy15 busy16 sgo rst phi1 phi1e phi2 tphi1 tphi1e tphi2 xin_p_r0 xin_n_r0 xin_p_r1 xin_n_r1 xin_p_r2 xin_n_r2 xin_p_r3 xin_n_r3 xin_p_r4 xin_n_r4 xin_p_r5 xin_n_r5 xin_p_r6 xin_n_r6 xin_p_r7 xin_n_r7 xin_p_r8 xin_n_r8 xin_p_r9 xin_n_r9 xin_p_r10 xin_n_r10 xin_p_r11 xin_n_r11 xin_p_r12 xin_n_r12 xin_p_r13 xin_n_r13 xin_p_r14 xin_n_r14 xin_p_r15 xin_n_r15 xrd_en0 xrd_en1 xrd_en2 xrd_en3 xrd_en4 xrd_en5 xrd_en6 xrd_en7 xrd_en8 xrd_en9 xrd_en10 xrd_en11 xrd_en12 xrd_en13 xrd_en14 xrd_en15 ramp_en vdd vss
Xseq n_3 adc_done xbar_rst adc_go latch_out integ_ack vdd vss async_ctrl
Xxcn_18 sdone0 sdone1 n_18 vdd vss muller_c
Xxcn_19 sdone2 sdone3 n_19 vdd vss muller_c
Xxcn_20 sdone4 sdone5 n_20 vdd vss muller_c
Xxcn_21 sdone6 sdone7 n_21 vdd vss muller_c
Xxcn_22 sdone8 sdone9 n_22 vdd vss muller_c
Xxcn_23 sdone10 sdone11 n_23 vdd vss muller_c
Xxcn_24 sdone12 sdone13 n_24 vdd vss muller_c
Xxcn_25 sdone14 sdone15 n_25 vdd vss muller_c
Xxcn_26 n_18 n_19 n_26 vdd vss muller_c
Xxcn_27 n_20 n_21 n_27 vdd vss muller_c
Xxcn_28 n_22 n_23 n_28 vdd vss muller_c
Xxcn_29 n_24 n_25 n_29 vdd vss muller_c
Xxcn_30 n_26 n_27 n_30 vdd vss muller_c
Xxcn_31 n_28 n_29 n_31 vdd vss muller_c
Xxcn_32 n_30 n_31 n_32 vdd vss muller_c
Xxcn_33 n_32 sdone16 n_33 vdd vss muller_c
Xxn_34 n_33 n_34 vdd vss dly_bundle
Xring in tap1 tap2 tap3 tap4 vdd vss tq_chain
Xcchop p c_phi1 c_phi1e c_phi2 c_ck vdd vss chop_gen
Xtchop p_tile t_phi1 t_phi1e t_phi2 t_ck vdd vss chop_gen
Xn_1_n n_1 seq_rst_n vss vss sky130_fd_pr__nfet_01v8 W=0.42 L=0.15
Xn_1_p n_1 seq_rst_n vdd vdd sky130_fd_pr__pfet_01v8 W=0.7 L=0.15
Xn_2_p1 n_2 integ_req vdd vdd sky130_fd_pr__pfet_01v8 W=0.7 L=0.15
Xn_2_p2 n_2 seq_rst_n vdd vdd sky130_fd_pr__pfet_01v8 W=0.7 L=0.15
Xn_2_n1 n_2 integ_req n_2_x vss sky130_fd_pr__nfet_01v8 W=0.84 L=0.15
Xn_2_n2 n_2_x seq_rst_n vss vss sky130_fd_pr__nfet_01v8 W=0.84 L=0.15
Xn_3_n n_3 n_2 vss vss sky130_fd_pr__nfet_01v8 W=0.42 L=0.15
Xn_3_p n_3 n_2 vdd vdd sky130_fd_pr__pfet_01v8 W=0.7 L=0.15
Xn_4_n n_4 n_3 vss vss sky130_fd_pr__nfet_01v8 W=0.42 L=0.15
Xn_4_p n_4 n_3 vdd vdd sky130_fd_pr__pfet_01v8 W=0.7 L=0.15
Xn_6_p1 n_6 xbar_rst n_6_x vdd sky130_fd_pr__pfet_01v8 W=1.4 L=0.15
Xn_6_p2 n_6_x n_5 vdd vdd sky130_fd_pr__pfet_01v8 W=1.4 L=0.15
Xn_6_n1 n_6 xbar_rst vss vss sky130_fd_pr__nfet_01v8 W=0.42 L=0.15
Xn_6_n2 n_6 n_5 vss vss sky130_fd_pr__nfet_01v8 W=0.42 L=0.15
Xn_5_p1 n_5 n_1 n_5_x vdd sky130_fd_pr__pfet_01v8 W=1.4 L=0.15
Xn_5_p2 n_5_x n_6 vdd vdd sky130_fd_pr__pfet_01v8 W=1.4 L=0.15
Xn_5_n1 n_5 n_1 vss vss sky130_fd_pr__nfet_01v8 W=0.42 L=0.15
Xn_5_n2 n_5 n_6 vss vss sky130_fd_pr__nfet_01v8 W=0.42 L=0.15
Xn_7_n n_7 n_5 vss vss sky130_fd_pr__nfet_01v8 W=0.42 L=0.15
Xn_7_p n_7 n_5 vdd vdd sky130_fd_pr__pfet_01v8 W=0.7 L=0.15
Xn_8_p1 n_8 xbar_rst n_8_x vdd sky130_fd_pr__pfet_01v8 W=1.4 L=0.15
Xn_8_p2 n_8_x n_7 vdd vdd sky130_fd_pr__pfet_01v8 W=1.4 L=0.15
Xn_8_n1 n_8 xbar_rst vss vss sky130_fd_pr__nfet_01v8 W=0.42 L=0.15
Xn_8_n2 n_8 n_7 vss vss sky130_fd_pr__nfet_01v8 W=0.42 L=0.15
Xn_9_n n_9 n_8 vss vss sky130_fd_pr__nfet_01v8 W=0.42 L=0.15
Xn_9_p n_9 n_8 vdd vdd sky130_fd_pr__pfet_01v8 W=0.7 L=0.15
Xn_10_n n_10 n_9 vss vss sky130_fd_pr__nfet_01v8 W=1.26 L=0.15
Xn_10_p n_10 n_9 vdd vdd sky130_fd_pr__pfet_01v8 W=2.1 L=0.15
Xrst_n rst n_10 vss vss sky130_fd_pr__nfet_01v8 W=4.2 L=0.15
Xrst_p rst n_10 vdd vdd sky130_fd_pr__pfet_01v8 W=7 L=0.15
Xn_11_p1 n_11 xbar_rst n_11_x vdd sky130_fd_pr__pfet_01v8 W=1.4 L=0.15
Xn_11_p2 n_11_x n_1 vdd vdd sky130_fd_pr__pfet_01v8 W=1.4 L=0.15
Xn_11_n1 n_11 xbar_rst vss vss sky130_fd_pr__nfet_01v8 W=0.42 L=0.15
Xn_11_n2 n_11 n_1 vss vss sky130_fd_pr__nfet_01v8 W=0.42 L=0.15
Xn_12_n n_12 n_11 vss vss sky130_fd_pr__nfet_01v8 W=0.42 L=0.15
Xn_12_p n_12 n_11 vdd vdd sky130_fd_pr__pfet_01v8 W=0.7 L=0.15
Xn_14_p1 n_14 sg n_14_x vdd sky130_fd_pr__pfet_01v8 W=1.4 L=0.15
Xn_14_p2 n_14_x n_13 vdd vdd sky130_fd_pr__pfet_01v8 W=1.4 L=0.15
Xn_14_n1 n_14 sg vss vss sky130_fd_pr__nfet_01v8 W=0.42 L=0.15
Xn_14_n2 n_14 n_13 vss vss sky130_fd_pr__nfet_01v8 W=0.42 L=0.15
Xn_13_p1 n_13 n_12 n_13_x vdd sky130_fd_pr__pfet_01v8 W=1.4 L=0.15
Xn_13_p2 n_13_x n_14 vdd vdd sky130_fd_pr__pfet_01v8 W=1.4 L=0.15
Xn_13_n1 n_13 n_12 vss vss sky130_fd_pr__nfet_01v8 W=0.42 L=0.15
Xn_13_n2 n_13 n_14 vss vss sky130_fd_pr__nfet_01v8 W=0.42 L=0.15
Xn_15_n n_15 n_13 vss vss sky130_fd_pr__nfet_01v8 W=1.26 L=0.15
Xn_15_p n_15 n_13 vdd vdd sky130_fd_pr__pfet_01v8 W=2.1 L=0.15
Xsgo_n sgo n_15 vss vss sky130_fd_pr__nfet_01v8 W=3.36 L=0.15
Xsgo_p sgo n_15 vdd vdd sky130_fd_pr__pfet_01v8 W=5.6 L=0.15
Xn_17_p1 n_17 sg n_17_x vdd sky130_fd_pr__pfet_01v8 W=1.4 L=0.15
Xn_17_p2 n_17_x n_16 vdd vdd sky130_fd_pr__pfet_01v8 W=1.4 L=0.15
Xn_17_n1 n_17 sg vss vss sky130_fd_pr__nfet_01v8 W=0.42 L=0.15
Xn_17_n2 n_17 n_16 vss vss sky130_fd_pr__nfet_01v8 W=0.42 L=0.15
Xn_16_p1 n_16 n_4 n_16_x vdd sky130_fd_pr__pfet_01v8 W=1.4 L=0.15
Xn_16_p2 n_16_x n_17 vdd vdd sky130_fd_pr__pfet_01v8 W=1.4 L=0.15
Xn_16_n1 n_16 n_4 vss vss sky130_fd_pr__nfet_01v8 W=0.42 L=0.15
Xn_16_n2 n_16 n_17 vss vss sky130_fd_pr__nfet_01v8 W=0.42 L=0.15
Xn_35_p1 n_35 n_33 vdd vdd sky130_fd_pr__pfet_01v8 W=0.7 L=0.15
Xn_35_p2 n_35 n_34 vdd vdd sky130_fd_pr__pfet_01v8 W=0.7 L=0.15
Xn_35_n1 n_35 n_33 n_35_x vss sky130_fd_pr__nfet_01v8 W=0.84 L=0.15
Xn_35_n2 n_35_x n_34 vss vss sky130_fd_pr__nfet_01v8 W=0.84 L=0.15
Xn_36_n n_36 n_35 vss vss sky130_fd_pr__nfet_01v8 W=0.42 L=0.15
Xn_36_p n_36 n_35 vdd vdd sky130_fd_pr__pfet_01v8 W=0.7 L=0.15
Xn_37_p1 n_37 n_16 vdd vdd sky130_fd_pr__pfet_01v8 W=0.7 L=0.15
Xn_37_p2 n_37 n_36 vdd vdd sky130_fd_pr__pfet_01v8 W=0.7 L=0.15
Xn_37_n1 n_37 n_16 n_37_x vss sky130_fd_pr__nfet_01v8 W=0.84 L=0.15
Xn_37_n2 n_37_x n_36 vss vss sky130_fd_pr__nfet_01v8 W=0.84 L=0.15
Xadc_done_n adc_done n_37 vss vss sky130_fd_pr__nfet_01v8 W=0.42 L=0.15
Xadc_done_p adc_done n_37 vdd vdd sky130_fd_pr__pfet_01v8 W=0.7 L=0.15
Xn_38_p1 n_38 integ_req n_38_x vdd sky130_fd_pr__pfet_01v8 W=1.4 L=0.15
Xn_38_p2 n_38_x integ_ack vdd vdd sky130_fd_pr__pfet_01v8 W=1.4 L=0.15
Xn_38_n1 n_38 integ_req vss vss sky130_fd_pr__nfet_01v8 W=0.42 L=0.15
Xn_38_n2 n_38 integ_ack vss vss sky130_fd_pr__nfet_01v8 W=0.42 L=0.15
Xn_39_n n_39 n_38 vss vss sky130_fd_pr__nfet_01v8 W=0.42 L=0.15
Xn_39_p n_39 n_38 vdd vdd sky130_fd_pr__pfet_01v8 W=0.7 L=0.15
Xn_40_p1 n_40 busy0 n_40_x vdd sky130_fd_pr__pfet_01v8 W=1.4 L=0.15
Xn_40_p2 n_40_x busy1 vdd vdd sky130_fd_pr__pfet_01v8 W=1.4 L=0.15
Xn_40_n1 n_40 busy0 vss vss sky130_fd_pr__nfet_01v8 W=0.42 L=0.15
Xn_40_n2 n_40 busy1 vss vss sky130_fd_pr__nfet_01v8 W=0.42 L=0.15
Xn_41_n n_41 n_40 vss vss sky130_fd_pr__nfet_01v8 W=0.42 L=0.15
Xn_41_p n_41 n_40 vdd vdd sky130_fd_pr__pfet_01v8 W=0.7 L=0.15
Xn_42_p1 n_42 busy2 n_42_x vdd sky130_fd_pr__pfet_01v8 W=1.4 L=0.15
Xn_42_p2 n_42_x busy3 vdd vdd sky130_fd_pr__pfet_01v8 W=1.4 L=0.15
Xn_42_n1 n_42 busy2 vss vss sky130_fd_pr__nfet_01v8 W=0.42 L=0.15
Xn_42_n2 n_42 busy3 vss vss sky130_fd_pr__nfet_01v8 W=0.42 L=0.15
Xn_43_n n_43 n_42 vss vss sky130_fd_pr__nfet_01v8 W=0.42 L=0.15
Xn_43_p n_43 n_42 vdd vdd sky130_fd_pr__pfet_01v8 W=0.7 L=0.15
Xn_44_p1 n_44 busy4 n_44_x vdd sky130_fd_pr__pfet_01v8 W=1.4 L=0.15
Xn_44_p2 n_44_x busy5 vdd vdd sky130_fd_pr__pfet_01v8 W=1.4 L=0.15
Xn_44_n1 n_44 busy4 vss vss sky130_fd_pr__nfet_01v8 W=0.42 L=0.15
Xn_44_n2 n_44 busy5 vss vss sky130_fd_pr__nfet_01v8 W=0.42 L=0.15
Xn_45_n n_45 n_44 vss vss sky130_fd_pr__nfet_01v8 W=0.42 L=0.15
Xn_45_p n_45 n_44 vdd vdd sky130_fd_pr__pfet_01v8 W=0.7 L=0.15
Xn_46_p1 n_46 busy6 n_46_x vdd sky130_fd_pr__pfet_01v8 W=1.4 L=0.15
Xn_46_p2 n_46_x busy7 vdd vdd sky130_fd_pr__pfet_01v8 W=1.4 L=0.15
Xn_46_n1 n_46 busy6 vss vss sky130_fd_pr__nfet_01v8 W=0.42 L=0.15
Xn_46_n2 n_46 busy7 vss vss sky130_fd_pr__nfet_01v8 W=0.42 L=0.15
Xn_47_n n_47 n_46 vss vss sky130_fd_pr__nfet_01v8 W=0.42 L=0.15
Xn_47_p n_47 n_46 vdd vdd sky130_fd_pr__pfet_01v8 W=0.7 L=0.15
Xn_48_p1 n_48 busy8 n_48_x vdd sky130_fd_pr__pfet_01v8 W=1.4 L=0.15
Xn_48_p2 n_48_x busy9 vdd vdd sky130_fd_pr__pfet_01v8 W=1.4 L=0.15
Xn_48_n1 n_48 busy8 vss vss sky130_fd_pr__nfet_01v8 W=0.42 L=0.15
Xn_48_n2 n_48 busy9 vss vss sky130_fd_pr__nfet_01v8 W=0.42 L=0.15
Xn_49_n n_49 n_48 vss vss sky130_fd_pr__nfet_01v8 W=0.42 L=0.15
Xn_49_p n_49 n_48 vdd vdd sky130_fd_pr__pfet_01v8 W=0.7 L=0.15
Xn_50_p1 n_50 busy10 n_50_x vdd sky130_fd_pr__pfet_01v8 W=1.4 L=0.15
Xn_50_p2 n_50_x busy11 vdd vdd sky130_fd_pr__pfet_01v8 W=1.4 L=0.15
Xn_50_n1 n_50 busy10 vss vss sky130_fd_pr__nfet_01v8 W=0.42 L=0.15
Xn_50_n2 n_50 busy11 vss vss sky130_fd_pr__nfet_01v8 W=0.42 L=0.15
Xn_51_n n_51 n_50 vss vss sky130_fd_pr__nfet_01v8 W=0.42 L=0.15
Xn_51_p n_51 n_50 vdd vdd sky130_fd_pr__pfet_01v8 W=0.7 L=0.15
Xn_52_p1 n_52 busy12 n_52_x vdd sky130_fd_pr__pfet_01v8 W=1.4 L=0.15
Xn_52_p2 n_52_x busy13 vdd vdd sky130_fd_pr__pfet_01v8 W=1.4 L=0.15
Xn_52_n1 n_52 busy12 vss vss sky130_fd_pr__nfet_01v8 W=0.42 L=0.15
Xn_52_n2 n_52 busy13 vss vss sky130_fd_pr__nfet_01v8 W=0.42 L=0.15
Xn_53_n n_53 n_52 vss vss sky130_fd_pr__nfet_01v8 W=0.42 L=0.15
Xn_53_p n_53 n_52 vdd vdd sky130_fd_pr__pfet_01v8 W=0.7 L=0.15
Xn_54_p1 n_54 busy14 n_54_x vdd sky130_fd_pr__pfet_01v8 W=1.4 L=0.15
Xn_54_p2 n_54_x busy15 vdd vdd sky130_fd_pr__pfet_01v8 W=1.4 L=0.15
Xn_54_n1 n_54 busy14 vss vss sky130_fd_pr__nfet_01v8 W=0.42 L=0.15
Xn_54_n2 n_54 busy15 vss vss sky130_fd_pr__nfet_01v8 W=0.42 L=0.15
Xn_55_n n_55 n_54 vss vss sky130_fd_pr__nfet_01v8 W=0.42 L=0.15
Xn_55_p n_55 n_54 vdd vdd sky130_fd_pr__pfet_01v8 W=0.7 L=0.15
Xn_56_p1 n_56 n_39 n_56_x vdd sky130_fd_pr__pfet_01v8 W=1.4 L=0.15
Xn_56_p2 n_56_x n_41 vdd vdd sky130_fd_pr__pfet_01v8 W=1.4 L=0.15
Xn_56_n1 n_56 n_39 vss vss sky130_fd_pr__nfet_01v8 W=0.42 L=0.15
Xn_56_n2 n_56 n_41 vss vss sky130_fd_pr__nfet_01v8 W=0.42 L=0.15
Xn_57_n n_57 n_56 vss vss sky130_fd_pr__nfet_01v8 W=0.42 L=0.15
Xn_57_p n_57 n_56 vdd vdd sky130_fd_pr__pfet_01v8 W=0.7 L=0.15
Xn_58_p1 n_58 n_43 n_58_x vdd sky130_fd_pr__pfet_01v8 W=1.4 L=0.15
Xn_58_p2 n_58_x n_45 vdd vdd sky130_fd_pr__pfet_01v8 W=1.4 L=0.15
Xn_58_n1 n_58 n_43 vss vss sky130_fd_pr__nfet_01v8 W=0.42 L=0.15
Xn_58_n2 n_58 n_45 vss vss sky130_fd_pr__nfet_01v8 W=0.42 L=0.15
Xn_59_n n_59 n_58 vss vss sky130_fd_pr__nfet_01v8 W=0.42 L=0.15
Xn_59_p n_59 n_58 vdd vdd sky130_fd_pr__pfet_01v8 W=0.7 L=0.15
Xn_60_p1 n_60 n_47 n_60_x vdd sky130_fd_pr__pfet_01v8 W=1.4 L=0.15
Xn_60_p2 n_60_x n_49 vdd vdd sky130_fd_pr__pfet_01v8 W=1.4 L=0.15
Xn_60_n1 n_60 n_47 vss vss sky130_fd_pr__nfet_01v8 W=0.42 L=0.15
Xn_60_n2 n_60 n_49 vss vss sky130_fd_pr__nfet_01v8 W=0.42 L=0.15
Xn_61_n n_61 n_60 vss vss sky130_fd_pr__nfet_01v8 W=0.42 L=0.15
Xn_61_p n_61 n_60 vdd vdd sky130_fd_pr__pfet_01v8 W=0.7 L=0.15
Xn_62_p1 n_62 n_51 n_62_x vdd sky130_fd_pr__pfet_01v8 W=1.4 L=0.15
Xn_62_p2 n_62_x n_53 vdd vdd sky130_fd_pr__pfet_01v8 W=1.4 L=0.15
Xn_62_n1 n_62 n_51 vss vss sky130_fd_pr__nfet_01v8 W=0.42 L=0.15
Xn_62_n2 n_62 n_53 vss vss sky130_fd_pr__nfet_01v8 W=0.42 L=0.15
Xn_63_n n_63 n_62 vss vss sky130_fd_pr__nfet_01v8 W=0.42 L=0.15
Xn_63_p n_63 n_62 vdd vdd sky130_fd_pr__pfet_01v8 W=0.7 L=0.15
Xn_64_p1 n_64 n_55 n_64_x vdd sky130_fd_pr__pfet_01v8 W=1.4 L=0.15
Xn_64_p2 n_64_x busy16 vdd vdd sky130_fd_pr__pfet_01v8 W=1.4 L=0.15
Xn_64_n1 n_64 n_55 vss vss sky130_fd_pr__nfet_01v8 W=0.42 L=0.15
Xn_64_n2 n_64 busy16 vss vss sky130_fd_pr__nfet_01v8 W=0.42 L=0.15
Xn_65_n n_65 n_64 vss vss sky130_fd_pr__nfet_01v8 W=0.42 L=0.15
Xn_65_p n_65 n_64 vdd vdd sky130_fd_pr__pfet_01v8 W=0.7 L=0.15
Xn_66_p1 n_66 n_57 n_66_x vdd sky130_fd_pr__pfet_01v8 W=1.4 L=0.15
Xn_66_p2 n_66_x n_59 vdd vdd sky130_fd_pr__pfet_01v8 W=1.4 L=0.15
Xn_66_n1 n_66 n_57 vss vss sky130_fd_pr__nfet_01v8 W=0.42 L=0.15
Xn_66_n2 n_66 n_59 vss vss sky130_fd_pr__nfet_01v8 W=0.42 L=0.15
Xn_67_n n_67 n_66 vss vss sky130_fd_pr__nfet_01v8 W=0.42 L=0.15
Xn_67_p n_67 n_66 vdd vdd sky130_fd_pr__pfet_01v8 W=0.7 L=0.15
Xn_68_p1 n_68 n_61 n_68_x vdd sky130_fd_pr__pfet_01v8 W=1.4 L=0.15
Xn_68_p2 n_68_x n_63 vdd vdd sky130_fd_pr__pfet_01v8 W=1.4 L=0.15
Xn_68_n1 n_68 n_61 vss vss sky130_fd_pr__nfet_01v8 W=0.42 L=0.15
Xn_68_n2 n_68 n_63 vss vss sky130_fd_pr__nfet_01v8 W=0.42 L=0.15
Xn_69_n n_69 n_68 vss vss sky130_fd_pr__nfet_01v8 W=0.42 L=0.15
Xn_69_p n_69 n_68 vdd vdd sky130_fd_pr__pfet_01v8 W=0.7 L=0.15
Xn_70_p1 n_70 n_67 n_70_x vdd sky130_fd_pr__pfet_01v8 W=1.4 L=0.15
Xn_70_p2 n_70_x n_69 vdd vdd sky130_fd_pr__pfet_01v8 W=1.4 L=0.15
Xn_70_n1 n_70 n_67 vss vss sky130_fd_pr__nfet_01v8 W=0.42 L=0.15
Xn_70_n2 n_70 n_69 vss vss sky130_fd_pr__nfet_01v8 W=0.42 L=0.15
Xn_71_n n_71 n_70 vss vss sky130_fd_pr__nfet_01v8 W=0.42 L=0.15
Xn_71_p n_71 n_70 vdd vdd sky130_fd_pr__pfet_01v8 W=0.7 L=0.15
Xn_72_p1 n_72 n_71 n_72_x vdd sky130_fd_pr__pfet_01v8 W=1.4 L=0.15
Xn_72_p2 n_72_x n_65 vdd vdd sky130_fd_pr__pfet_01v8 W=1.4 L=0.15
Xn_72_n1 n_72 n_71 vss vss sky130_fd_pr__nfet_01v8 W=0.42 L=0.15
Xn_72_n2 n_72 n_65 vss vss sky130_fd_pr__nfet_01v8 W=0.42 L=0.15
Xn_73_n n_73 n_72 vss vss sky130_fd_pr__nfet_01v8 W=0.42 L=0.15
Xn_73_p n_73 n_72 vdd vdd sky130_fd_pr__pfet_01v8 W=0.7 L=0.15
Xclose_p1 in n_73 vdd vdd sky130_fd_pr__pfet_01v8 W=2.32 L=0.15
Xclose_p2 in tap4 vdd vdd sky130_fd_pr__pfet_01v8 W=2.32 L=0.15
Xclose_n1 in n_73 close_x vss sky130_fd_pr__nfet_01v8 W=1.68 L=0.15
Xclose_n2 close_x tap4 vss vss sky130_fd_pr__nfet_01v8 W=1.68 L=0.15
Xclose_c in vss sky130_fd_pr__cap_mim_m3_1 W=35.73 L=35.73
Xn_74_n n_74 in vss vss sky130_fd_pr__nfet_01v8 W=0.42 L=0.15
Xn_74_p n_74 in vdd vdd sky130_fd_pr__pfet_01v8 W=0.7 L=0.15
Xn_75_n n_75 tap1 vss vss sky130_fd_pr__nfet_01v8 W=0.42 L=0.15
Xn_75_p n_75 tap1 vdd vdd sky130_fd_pr__pfet_01v8 W=0.7 L=0.15
Xn_76_n n_76 tap2 vss vss sky130_fd_pr__nfet_01v8 W=0.42 L=0.15
Xn_76_p n_76 tap2 vdd vdd sky130_fd_pr__pfet_01v8 W=0.7 L=0.15
Xn_77_n n_77 tap3 vss vss sky130_fd_pr__nfet_01v8 W=0.42 L=0.15
Xn_77_p n_77 tap3 vdd vdd sky130_fd_pr__pfet_01v8 W=0.7 L=0.15
Xn_78_n n_78 tap4 vss vss sky130_fd_pr__nfet_01v8 W=0.42 L=0.15
Xn_78_p n_78 tap4 vdd vdd sky130_fd_pr__pfet_01v8 W=0.7 L=0.15
Xn_79_p1 n_79 n_74 vdd vdd sky130_fd_pr__pfet_01v8 W=0.7 L=0.15
Xn_79_p2 n_79 n_75 vdd vdd sky130_fd_pr__pfet_01v8 W=0.7 L=0.15
Xn_79_n1 n_79 n_74 n_79_x vss sky130_fd_pr__nfet_01v8 W=0.84 L=0.15
Xn_79_n2 n_79_x n_75 vss vss sky130_fd_pr__nfet_01v8 W=0.84 L=0.15
Xn_80_p1 n_80 n_74 vdd vdd sky130_fd_pr__pfet_01v8 W=0.7 L=0.15
Xn_80_p2 n_80 n_79 vdd vdd sky130_fd_pr__pfet_01v8 W=0.7 L=0.15
Xn_80_n1 n_80 n_74 n_80_x vss sky130_fd_pr__nfet_01v8 W=0.84 L=0.15
Xn_80_n2 n_80_x n_79 vss vss sky130_fd_pr__nfet_01v8 W=0.84 L=0.15
Xn_81_p1 n_81 n_75 vdd vdd sky130_fd_pr__pfet_01v8 W=0.7 L=0.15
Xn_81_p2 n_81 n_79 vdd vdd sky130_fd_pr__pfet_01v8 W=0.7 L=0.15
Xn_81_n1 n_81 n_75 n_81_x vss sky130_fd_pr__nfet_01v8 W=0.84 L=0.15
Xn_81_n2 n_81_x n_79 vss vss sky130_fd_pr__nfet_01v8 W=0.84 L=0.15
Xn_82_p1 n_82 n_80 vdd vdd sky130_fd_pr__pfet_01v8 W=0.7 L=0.15
Xn_82_p2 n_82 n_81 vdd vdd sky130_fd_pr__pfet_01v8 W=0.7 L=0.15
Xn_82_n1 n_82 n_80 n_82_x vss sky130_fd_pr__nfet_01v8 W=0.84 L=0.15
Xn_82_n2 n_82_x n_81 vss vss sky130_fd_pr__nfet_01v8 W=0.84 L=0.15
Xn_83_p1 n_83 n_76 vdd vdd sky130_fd_pr__pfet_01v8 W=0.7 L=0.15
Xn_83_p2 n_83 n_77 vdd vdd sky130_fd_pr__pfet_01v8 W=0.7 L=0.15
Xn_83_n1 n_83 n_76 n_83_x vss sky130_fd_pr__nfet_01v8 W=0.84 L=0.15
Xn_83_n2 n_83_x n_77 vss vss sky130_fd_pr__nfet_01v8 W=0.84 L=0.15
Xn_84_p1 n_84 n_76 vdd vdd sky130_fd_pr__pfet_01v8 W=0.7 L=0.15
Xn_84_p2 n_84 n_83 vdd vdd sky130_fd_pr__pfet_01v8 W=0.7 L=0.15
Xn_84_n1 n_84 n_76 n_84_x vss sky130_fd_pr__nfet_01v8 W=0.84 L=0.15
Xn_84_n2 n_84_x n_83 vss vss sky130_fd_pr__nfet_01v8 W=0.84 L=0.15
Xn_85_p1 n_85 n_77 vdd vdd sky130_fd_pr__pfet_01v8 W=0.7 L=0.15
Xn_85_p2 n_85 n_83 vdd vdd sky130_fd_pr__pfet_01v8 W=0.7 L=0.15
Xn_85_n1 n_85 n_77 n_85_x vss sky130_fd_pr__nfet_01v8 W=0.84 L=0.15
Xn_85_n2 n_85_x n_83 vss vss sky130_fd_pr__nfet_01v8 W=0.84 L=0.15
Xn_86_p1 n_86 n_84 vdd vdd sky130_fd_pr__pfet_01v8 W=0.7 L=0.15
Xn_86_p2 n_86 n_85 vdd vdd sky130_fd_pr__pfet_01v8 W=0.7 L=0.15
Xn_86_n1 n_86 n_84 n_86_x vss sky130_fd_pr__nfet_01v8 W=0.84 L=0.15
Xn_86_n2 n_86_x n_85 vss vss sky130_fd_pr__nfet_01v8 W=0.84 L=0.15
Xn_87_p1 n_87 n_82 vdd vdd sky130_fd_pr__pfet_01v8 W=0.7 L=0.15
Xn_87_p2 n_87 n_86 vdd vdd sky130_fd_pr__pfet_01v8 W=0.7 L=0.15
Xn_87_n1 n_87 n_82 n_87_x vss sky130_fd_pr__nfet_01v8 W=0.84 L=0.15
Xn_87_n2 n_87_x n_86 vss vss sky130_fd_pr__nfet_01v8 W=0.84 L=0.15
Xn_88_p1 n_88 n_82 vdd vdd sky130_fd_pr__pfet_01v8 W=0.7 L=0.15
Xn_88_p2 n_88 n_87 vdd vdd sky130_fd_pr__pfet_01v8 W=0.7 L=0.15
Xn_88_n1 n_88 n_82 n_88_x vss sky130_fd_pr__nfet_01v8 W=0.84 L=0.15
Xn_88_n2 n_88_x n_87 vss vss sky130_fd_pr__nfet_01v8 W=0.84 L=0.15
Xn_89_p1 n_89 n_86 vdd vdd sky130_fd_pr__pfet_01v8 W=0.7 L=0.15
Xn_89_p2 n_89 n_87 vdd vdd sky130_fd_pr__pfet_01v8 W=0.7 L=0.15
Xn_89_n1 n_89 n_86 n_89_x vss sky130_fd_pr__nfet_01v8 W=0.84 L=0.15
Xn_89_n2 n_89_x n_87 vss vss sky130_fd_pr__nfet_01v8 W=0.84 L=0.15
Xn_90_p1 n_90 n_88 vdd vdd sky130_fd_pr__pfet_01v8 W=0.7 L=0.15
Xn_90_p2 n_90 n_89 vdd vdd sky130_fd_pr__pfet_01v8 W=0.7 L=0.15
Xn_90_n1 n_90 n_88 n_90_x vss sky130_fd_pr__nfet_01v8 W=0.84 L=0.15
Xn_90_n2 n_90_x n_89 vss vss sky130_fd_pr__nfet_01v8 W=0.84 L=0.15
Xn_91_p1 n_91 n_90 vdd vdd sky130_fd_pr__pfet_01v8 W=0.7 L=0.15
Xn_91_p2 n_91 n_78 vdd vdd sky130_fd_pr__pfet_01v8 W=0.7 L=0.15
Xn_91_n1 n_91 n_90 n_91_x vss sky130_fd_pr__nfet_01v8 W=0.84 L=0.15
Xn_91_n2 n_91_x n_78 vss vss sky130_fd_pr__nfet_01v8 W=0.84 L=0.15
Xn_92_p1 n_92 n_90 vdd vdd sky130_fd_pr__pfet_01v8 W=0.7 L=0.15
Xn_92_p2 n_92 n_91 vdd vdd sky130_fd_pr__pfet_01v8 W=0.7 L=0.15
Xn_92_n1 n_92 n_90 n_92_x vss sky130_fd_pr__nfet_01v8 W=0.84 L=0.15
Xn_92_n2 n_92_x n_91 vss vss sky130_fd_pr__nfet_01v8 W=0.84 L=0.15
Xn_93_p1 n_93 n_78 vdd vdd sky130_fd_pr__pfet_01v8 W=0.7 L=0.15
Xn_93_p2 n_93 n_91 vdd vdd sky130_fd_pr__pfet_01v8 W=0.7 L=0.15
Xn_93_n1 n_93 n_78 n_93_x vss sky130_fd_pr__nfet_01v8 W=0.84 L=0.15
Xn_93_n2 n_93_x n_91 vss vss sky130_fd_pr__nfet_01v8 W=0.84 L=0.15
Xp_p1 p n_92 vdd vdd sky130_fd_pr__pfet_01v8 W=0.7 L=0.15
Xp_p2 p n_93 vdd vdd sky130_fd_pr__pfet_01v8 W=0.7 L=0.15
Xp_n1 p n_92 p_x vss sky130_fd_pr__nfet_01v8 W=0.84 L=0.15
Xp_n2 p_x n_93 vss vss sky130_fd_pr__nfet_01v8 W=0.84 L=0.15
Xn_94_n n_94 c_phi1 vss vss sky130_fd_pr__nfet_01v8 W=1.68 L=0.15
Xn_94_p n_94 c_phi1 vdd vdd sky130_fd_pr__pfet_01v8 W=2.8 L=0.15
Xphi1_n phi1 n_94 vss vss sky130_fd_pr__nfet_01v8 W=5.46 L=0.15
Xphi1_p phi1 n_94 vdd vdd sky130_fd_pr__pfet_01v8 W=9.1 L=0.15
Xn_95_n n_95 c_phi1e vss vss sky130_fd_pr__nfet_01v8 W=0.84 L=0.15
Xn_95_p n_95 c_phi1e vdd vdd sky130_fd_pr__pfet_01v8 W=1.4 L=0.15
Xphi1e_n phi1e n_95 vss vss sky130_fd_pr__nfet_01v8 W=1.68 L=0.15
Xphi1e_p phi1e n_95 vdd vdd sky130_fd_pr__pfet_01v8 W=2.8 L=0.15
Xn_96_p1 n_96 n_73 vdd vdd sky130_fd_pr__pfet_01v8 W=0.7 L=0.15
Xn_96_p2 n_96 c_phi2 vdd vdd sky130_fd_pr__pfet_01v8 W=0.7 L=0.15
Xn_96_n1 n_96 n_73 n_96_x vss sky130_fd_pr__nfet_01v8 W=0.84 L=0.15
Xn_96_n2 n_96_x c_phi2 vss vss sky130_fd_pr__nfet_01v8 W=0.84 L=0.15
Xn_97_n n_97 n_96 vss vss sky130_fd_pr__nfet_01v8 W=0.42 L=0.15
Xn_97_p n_97 n_96 vdd vdd sky130_fd_pr__pfet_01v8 W=0.7 L=0.15
Xn_98_n n_98 n_97 vss vss sky130_fd_pr__nfet_01v8 W=1.26 L=0.15
Xn_98_p n_98 n_97 vdd vdd sky130_fd_pr__pfet_01v8 W=2.1 L=0.15
Xphi2_n phi2 n_98 vss vss sky130_fd_pr__nfet_01v8 W=3.36 L=0.15
Xphi2_p phi2 n_98 vdd vdd sky130_fd_pr__pfet_01v8 W=5.6 L=0.15
Xn_99_n n_99 c_ck vss vss sky130_fd_pr__nfet_01v8 W=0.42 L=0.15
Xn_99_p n_99 c_ck vdd vdd sky130_fd_pr__pfet_01v8 W=0.7 L=0.15
Xn_100_n n_100 n_99 vss vss sky130_fd_pr__nfet_01v8 W=0.42 L=0.15
Xn_100_p n_100 n_99 vdd vdd sky130_fd_pr__pfet_01v8 W=0.7 L=0.15
Xn_101_n n_101 n_100 vss vss sky130_fd_pr__nfet_01v8 W=0.42 L=0.15
Xn_101_p n_101 n_100 vdd vdd sky130_fd_pr__pfet_01v8 W=0.7 L=0.15
Xn_102_n n_102 n_101 vss vss sky130_fd_pr__nfet_01v8 W=0.42 L=0.15
Xn_102_p n_102 n_101 vdd vdd sky130_fd_pr__pfet_01v8 W=0.7 L=0.15
Xn_103_n n_103 n_102 vss vss sky130_fd_pr__nfet_01v8 W=0.42 L=0.15
Xn_103_p n_103 n_102 vdd vdd sky130_fd_pr__pfet_01v8 W=0.7 L=0.15
Xn_104_n n_104 n_103 vss vss sky130_fd_pr__nfet_01v8 W=0.42 L=0.15
Xn_104_p n_104 n_103 vdd vdd sky130_fd_pr__pfet_01v8 W=0.7 L=0.15
Xn_105_p1 n_105 n_100 n_105_x vdd sky130_fd_pr__pfet_01v8 W=1.4 L=0.15
Xn_105_p2 n_105_x n_104 vdd vdd sky130_fd_pr__pfet_01v8 W=1.4 L=0.15
Xn_105_n1 n_105 n_100 vss vss sky130_fd_pr__nfet_01v8 W=0.42 L=0.15
Xn_105_n2 n_105 n_104 vss vss sky130_fd_pr__nfet_01v8 W=0.42 L=0.15
Xn_106_n n_106 n_105 vss vss sky130_fd_pr__nfet_01v8 W=6.72 L=0.15
Xn_106_p n_106 n_105 vdd vdd sky130_fd_pr__pfet_01v8 W=11.2 L=0.15
Xn_107_p1 n_107 n_100 vdd vdd sky130_fd_pr__pfet_01v8 W=0.7 L=0.15
Xn_107_p2 n_107 n_104 vdd vdd sky130_fd_pr__pfet_01v8 W=0.7 L=0.15
Xn_107_n1 n_107 n_100 n_107_x vss sky130_fd_pr__nfet_01v8 W=0.84 L=0.15
Xn_107_n2 n_107_x n_104 vss vss sky130_fd_pr__nfet_01v8 W=0.84 L=0.15
Xn_108_n n_108 n_107 vss vss sky130_fd_pr__nfet_01v8 W=0.42 L=0.15
Xn_108_p n_108 n_107 vdd vdd sky130_fd_pr__pfet_01v8 W=0.7 L=0.15
Xn_109_n n_109 n_108 vss vss sky130_fd_pr__nfet_01v8 W=6.72 L=0.15
Xn_109_p n_109 n_108 vdd vdd sky130_fd_pr__pfet_01v8 W=11.2 L=0.15
Xn_110_n n_110 adc_go vss vss sky130_fd_pr__nfet_01v8 W=0.42 L=0.15
Xn_110_p n_110 adc_go vdd vdd sky130_fd_pr__pfet_01v8 W=0.7 L=0.15
Xn_111_p1 n_111 adc_go n_111_x vdd sky130_fd_pr__pfet_01v8 W=1.4 L=0.15
Xn_111_p2 n_111_x n_106 vdd vdd sky130_fd_pr__pfet_01v8 W=1.4 L=0.15
Xn_111_n1 n_111 adc_go vss vss sky130_fd_pr__nfet_01v8 W=0.42 L=0.15
Xn_111_n2 n_111 n_106 vss vss sky130_fd_pr__nfet_01v8 W=0.42 L=0.15
Xn_112_p1 n_112 n_111 n_112_x vdd sky130_fd_pr__pfet_01v8 W=1.4 L=0.15
Xn_112_p2 n_112_x n_4 vdd vdd sky130_fd_pr__pfet_01v8 W=1.4 L=0.15
Xn_112_n1 n_112 n_111 vss vss sky130_fd_pr__nfet_01v8 W=0.42 L=0.15
Xn_112_n2 n_112 n_4 vss vss sky130_fd_pr__nfet_01v8 W=0.42 L=0.15
Xn_113_n n_113 n_112 vss vss sky130_fd_pr__nfet_01v8 W=0.42 L=0.15
Xn_113_p n_113 n_112 vdd vdd sky130_fd_pr__pfet_01v8 W=0.7 L=0.15
Xn_116_p1 n_116 n_110 n_116_x vdd sky130_fd_pr__pfet_01v8 W=1.4 L=0.15
Xn_116_p2 n_116_x n_106 vdd vdd sky130_fd_pr__pfet_01v8 W=1.4 L=0.15
Xn_116_n1 n_116 n_110 vss vss sky130_fd_pr__nfet_01v8 W=0.42 L=0.15
Xn_116_n2 n_116 n_106 vss vss sky130_fd_pr__nfet_01v8 W=0.42 L=0.15
Xn_115_p1 n_115 n_116 n_115_x vdd sky130_fd_pr__pfet_01v8 W=1.4 L=0.15
Xn_115_p2 n_115_x n_114 vdd vdd sky130_fd_pr__pfet_01v8 W=1.4 L=0.15
Xn_115_n1 n_115 n_116 vss vss sky130_fd_pr__nfet_01v8 W=0.42 L=0.15
Xn_115_n2 n_115 n_114 vss vss sky130_fd_pr__nfet_01v8 W=0.42 L=0.15
Xn_114_p1 n_114 n_113 n_114_x vdd sky130_fd_pr__pfet_01v8 W=1.4 L=0.15
Xn_114_p2 n_114_x n_115 vdd vdd sky130_fd_pr__pfet_01v8 W=1.4 L=0.15
Xn_114_n1 n_114 n_113 vss vss sky130_fd_pr__nfet_01v8 W=0.42 L=0.15
Xn_114_n2 n_114 n_115 vss vss sky130_fd_pr__nfet_01v8 W=0.42 L=0.15
Xn_117_p1 n_117 n_114 n_117_x vdd sky130_fd_pr__pfet_01v8 W=1.4 L=0.15
Xn_117_p2 n_117_x n_109 vdd vdd sky130_fd_pr__pfet_01v8 W=1.4 L=0.15
Xn_117_n1 n_117 n_114 vss vss sky130_fd_pr__nfet_01v8 W=0.42 L=0.15
Xn_117_n2 n_117 n_109 vss vss sky130_fd_pr__nfet_01v8 W=0.42 L=0.15
Xn_118_p1 n_118 n_117 n_118_x vdd sky130_fd_pr__pfet_01v8 W=1.4 L=0.15
Xn_118_p2 n_118_x n_4 vdd vdd sky130_fd_pr__pfet_01v8 W=1.4 L=0.15
Xn_118_n1 n_118 n_117 vss vss sky130_fd_pr__nfet_01v8 W=0.42 L=0.15
Xn_118_n2 n_118 n_4 vss vss sky130_fd_pr__nfet_01v8 W=0.42 L=0.15
Xn_119_n n_119 n_118 vss vss sky130_fd_pr__nfet_01v8 W=0.42 L=0.15
Xn_119_p n_119 n_118 vdd vdd sky130_fd_pr__pfet_01v8 W=0.7 L=0.15
Xn_122_p1 n_122 n_115 n_122_x vdd sky130_fd_pr__pfet_01v8 W=1.4 L=0.15
Xn_122_p2 n_122_x n_109 vdd vdd sky130_fd_pr__pfet_01v8 W=1.4 L=0.15
Xn_122_n1 n_122 n_115 vss vss sky130_fd_pr__nfet_01v8 W=0.42 L=0.15
Xn_122_n2 n_122 n_109 vss vss sky130_fd_pr__nfet_01v8 W=0.42 L=0.15
Xn_121_p1 n_121 n_122 n_121_x vdd sky130_fd_pr__pfet_01v8 W=1.4 L=0.15
Xn_121_p2 n_121_x n_120 vdd vdd sky130_fd_pr__pfet_01v8 W=1.4 L=0.15
Xn_121_n1 n_121 n_122 vss vss sky130_fd_pr__nfet_01v8 W=0.42 L=0.15
Xn_121_n2 n_121 n_120 vss vss sky130_fd_pr__nfet_01v8 W=0.42 L=0.15
Xn_120_p1 n_120 n_119 n_120_x vdd sky130_fd_pr__pfet_01v8 W=1.4 L=0.15
Xn_120_p2 n_120_x n_121 vdd vdd sky130_fd_pr__pfet_01v8 W=1.4 L=0.15
Xn_120_n1 n_120 n_119 vss vss sky130_fd_pr__nfet_01v8 W=0.42 L=0.15
Xn_120_n2 n_120 n_121 vss vss sky130_fd_pr__nfet_01v8 W=0.42 L=0.15
Xn_123_n n_123 n_120 vss vss sky130_fd_pr__nfet_01v8 W=0.42 L=0.15
Xn_123_p n_123 n_120 vdd vdd sky130_fd_pr__pfet_01v8 W=0.7 L=0.15
Xn_124_p1 n_124 n_120 n_124_x vdd sky130_fd_pr__pfet_01v8 W=1.4 L=0.15
Xn_124_p2 n_124_x n_106 vdd vdd sky130_fd_pr__pfet_01v8 W=1.4 L=0.15
Xn_124_n1 n_124 n_120 vss vss sky130_fd_pr__nfet_01v8 W=0.42 L=0.15
Xn_124_n2 n_124 n_106 vss vss sky130_fd_pr__nfet_01v8 W=0.42 L=0.15
Xn_125_p1 n_125 n_124 n_125_x vdd sky130_fd_pr__pfet_01v8 W=1.4 L=0.15
Xn_125_p2 n_125_x n_4 vdd vdd sky130_fd_pr__pfet_01v8 W=1.4 L=0.15
Xn_125_n1 n_125 n_124 vss vss sky130_fd_pr__nfet_01v8 W=0.42 L=0.15
Xn_125_n2 n_125 n_4 vss vss sky130_fd_pr__nfet_01v8 W=0.42 L=0.15
Xn_126_n n_126 n_125 vss vss sky130_fd_pr__nfet_01v8 W=0.42 L=0.15
Xn_126_p n_126 n_125 vdd vdd sky130_fd_pr__pfet_01v8 W=0.7 L=0.15
Xn_129_p1 n_129 n_123 n_129_x vdd sky130_fd_pr__pfet_01v8 W=1.4 L=0.15
Xn_129_p2 n_129_x n_106 vdd vdd sky130_fd_pr__pfet_01v8 W=1.4 L=0.15
Xn_129_n1 n_129 n_123 vss vss sky130_fd_pr__nfet_01v8 W=0.42 L=0.15
Xn_129_n2 n_129 n_106 vss vss sky130_fd_pr__nfet_01v8 W=0.42 L=0.15
Xn_128_p1 n_128 n_129 n_128_x vdd sky130_fd_pr__pfet_01v8 W=1.4 L=0.15
Xn_128_p2 n_128_x n_127 vdd vdd sky130_fd_pr__pfet_01v8 W=1.4 L=0.15
Xn_128_n1 n_128 n_129 vss vss sky130_fd_pr__nfet_01v8 W=0.42 L=0.15
Xn_128_n2 n_128 n_127 vss vss sky130_fd_pr__nfet_01v8 W=0.42 L=0.15
Xn_127_p1 n_127 n_126 n_127_x vdd sky130_fd_pr__pfet_01v8 W=1.4 L=0.15
Xn_127_p2 n_127_x n_128 vdd vdd sky130_fd_pr__pfet_01v8 W=1.4 L=0.15
Xn_127_n1 n_127 n_126 vss vss sky130_fd_pr__nfet_01v8 W=0.42 L=0.15
Xn_127_n2 n_127 n_128 vss vss sky130_fd_pr__nfet_01v8 W=0.42 L=0.15
Xn_130_p1 n_130 n_127 n_130_x vdd sky130_fd_pr__pfet_01v8 W=1.4 L=0.15
Xn_130_p2 n_130_x n_109 vdd vdd sky130_fd_pr__pfet_01v8 W=1.4 L=0.15
Xn_130_n1 n_130 n_127 vss vss sky130_fd_pr__nfet_01v8 W=0.42 L=0.15
Xn_130_n2 n_130 n_109 vss vss sky130_fd_pr__nfet_01v8 W=0.42 L=0.15
Xn_131_p1 n_131 n_130 n_131_x vdd sky130_fd_pr__pfet_01v8 W=1.4 L=0.15
Xn_131_p2 n_131_x n_4 vdd vdd sky130_fd_pr__pfet_01v8 W=1.4 L=0.15
Xn_131_n1 n_131 n_130 vss vss sky130_fd_pr__nfet_01v8 W=0.42 L=0.15
Xn_131_n2 n_131 n_4 vss vss sky130_fd_pr__nfet_01v8 W=0.42 L=0.15
Xn_132_n n_132 n_131 vss vss sky130_fd_pr__nfet_01v8 W=0.42 L=0.15
Xn_132_p n_132 n_131 vdd vdd sky130_fd_pr__pfet_01v8 W=0.7 L=0.15
Xn_134_p1 n_134 n_128 n_134_x vdd sky130_fd_pr__pfet_01v8 W=1.4 L=0.15
Xn_134_p2 n_134_x n_109 vdd vdd sky130_fd_pr__pfet_01v8 W=1.4 L=0.15
Xn_134_n1 n_134 n_128 vss vss sky130_fd_pr__nfet_01v8 W=0.42 L=0.15
Xn_134_n2 n_134 n_109 vss vss sky130_fd_pr__nfet_01v8 W=0.42 L=0.15
Xn_133_p1 n_133 n_134 n_133_x vdd sky130_fd_pr__pfet_01v8 W=1.4 L=0.15
Xn_133_p2 n_133_x s1 vdd vdd sky130_fd_pr__pfet_01v8 W=1.4 L=0.15
Xn_133_n1 n_133 n_134 vss vss sky130_fd_pr__nfet_01v8 W=0.42 L=0.15
Xn_133_n2 n_133 s1 vss vss sky130_fd_pr__nfet_01v8 W=0.42 L=0.15
Xs1_p1 s1 n_132 s1_x vdd sky130_fd_pr__pfet_01v8 W=1.4 L=0.15
Xs1_p2 s1_x n_133 vdd vdd sky130_fd_pr__pfet_01v8 W=1.4 L=0.15
Xs1_n1 s1 n_132 vss vss sky130_fd_pr__nfet_01v8 W=0.42 L=0.15
Xs1_n2 s1 n_133 vss vss sky130_fd_pr__nfet_01v8 W=0.42 L=0.15
Xn_135_n n_135 win_hi vss vss sky130_fd_pr__nfet_01v8 W=0.42 L=0.15
Xn_135_p n_135 win_hi vdd vdd sky130_fd_pr__pfet_01v8 W=0.7 L=0.15
Xn_136_p1 n_136 win_hi vdd vdd sky130_fd_pr__pfet_01v8 W=0.7 L=0.15
Xn_136_p2 n_136 cnt7 vdd vdd sky130_fd_pr__pfet_01v8 W=0.7 L=0.15
Xn_136_n1 n_136 win_hi n_136_x vss sky130_fd_pr__nfet_01v8 W=0.84 L=0.15
Xn_136_n2 n_136_x cnt7 vss vss sky130_fd_pr__nfet_01v8 W=0.84 L=0.15
Xn_137_p1 n_137 n_135 vdd vdd sky130_fd_pr__pfet_01v8 W=0.7 L=0.15
Xn_137_p2 n_137 cnt4 vdd vdd sky130_fd_pr__pfet_01v8 W=0.7 L=0.15
Xn_137_n1 n_137 n_135 n_137_x vss sky130_fd_pr__nfet_01v8 W=0.84 L=0.15
Xn_137_n2 n_137_x cnt4 vss vss sky130_fd_pr__nfet_01v8 W=0.84 L=0.15
Xn_138_p1 n_138 n_136 vdd vdd sky130_fd_pr__pfet_01v8 W=0.7 L=0.15
Xn_138_p2 n_138 n_137 vdd vdd sky130_fd_pr__pfet_01v8 W=0.7 L=0.15
Xn_138_n1 n_138 n_136 n_138_x vss sky130_fd_pr__nfet_01v8 W=0.84 L=0.15
Xn_138_n2 n_138_x n_137 vss vss sky130_fd_pr__nfet_01v8 W=0.84 L=0.15
Xn_139_n n_139 pw vss vss sky130_fd_pr__nfet_01v8 W=0.42 L=0.15
Xn_139_p n_139 pw vdd vdd sky130_fd_pr__pfet_01v8 W=0.7 L=0.15
Xn_140_p1 n_140 n_138 vdd vdd sky130_fd_pr__pfet_01v8 W=0.7 L=0.15
Xn_140_p2 n_140 n_139 vdd vdd sky130_fd_pr__pfet_01v8 W=0.7 L=0.15
Xn_140_n1 n_140 n_138 n_140_x vss sky130_fd_pr__nfet_01v8 W=0.84 L=0.15
Xn_140_n2 n_140_x n_139 vss vss sky130_fd_pr__nfet_01v8 W=0.84 L=0.15
Xn_141_n n_141 sg vss vss sky130_fd_pr__nfet_01v8 W=0.42 L=0.15
Xn_141_p n_141 sg vdd vdd sky130_fd_pr__pfet_01v8 W=0.7 L=0.15
Xn_142_p1 n_142 s1 vdd vdd sky130_fd_pr__pfet_01v8 W=0.7 L=0.15
Xn_142_p2 n_142 n_141 vdd vdd sky130_fd_pr__pfet_01v8 W=0.7 L=0.15
Xn_142_n1 n_142 s1 n_142_x vss sky130_fd_pr__nfet_01v8 W=0.84 L=0.15
Xn_142_n2 n_142_x n_141 vss vss sky130_fd_pr__nfet_01v8 W=0.84 L=0.15
Xn_143_n n_143 n_142 vss vss sky130_fd_pr__nfet_01v8 W=0.42 L=0.15
Xn_143_p n_143 n_142 vdd vdd sky130_fd_pr__pfet_01v8 W=0.7 L=0.15
Xn_144_p1 n_144 cnt0 vdd vdd sky130_fd_pr__pfet_01v8 W=0.7 L=0.15
Xn_144_p2 n_144 n_143 vdd vdd sky130_fd_pr__pfet_01v8 W=0.7 L=0.15
Xn_144_n1 n_144 cnt0 n_144_x vss sky130_fd_pr__nfet_01v8 W=0.84 L=0.15
Xn_144_n2 n_144_x n_143 vss vss sky130_fd_pr__nfet_01v8 W=0.84 L=0.15
Xn_145_p1 n_145 cnt0 vdd vdd sky130_fd_pr__pfet_01v8 W=0.7 L=0.15
Xn_145_p2 n_145 n_144 vdd vdd sky130_fd_pr__pfet_01v8 W=0.7 L=0.15
Xn_145_n1 n_145 cnt0 n_145_x vss sky130_fd_pr__nfet_01v8 W=0.84 L=0.15
Xn_145_n2 n_145_x n_144 vss vss sky130_fd_pr__nfet_01v8 W=0.84 L=0.15
Xn_146_p1 n_146 n_143 vdd vdd sky130_fd_pr__pfet_01v8 W=0.7 L=0.15
Xn_146_p2 n_146 n_144 vdd vdd sky130_fd_pr__pfet_01v8 W=0.7 L=0.15
Xn_146_n1 n_146 n_143 n_146_x vss sky130_fd_pr__nfet_01v8 W=0.84 L=0.15
Xn_146_n2 n_146_x n_144 vss vss sky130_fd_pr__nfet_01v8 W=0.84 L=0.15
Xn_147_p1 n_147 n_145 vdd vdd sky130_fd_pr__pfet_01v8 W=0.7 L=0.15
Xn_147_p2 n_147 n_146 vdd vdd sky130_fd_pr__pfet_01v8 W=0.7 L=0.15
Xn_147_n1 n_147 n_145 n_147_x vss sky130_fd_pr__nfet_01v8 W=0.84 L=0.15
Xn_147_n2 n_147_x n_146 vss vss sky130_fd_pr__nfet_01v8 W=0.84 L=0.15
Xn_148_p1 n_148 n_140 vdd vdd sky130_fd_pr__pfet_01v8 W=0.7 L=0.15
Xn_148_p2 n_148 n_147 vdd vdd sky130_fd_pr__pfet_01v8 W=0.7 L=0.15
Xn_148_n1 n_148 n_140 n_148_x vss sky130_fd_pr__nfet_01v8 W=0.84 L=0.15
Xn_148_n2 n_148_x n_147 vss vss sky130_fd_pr__nfet_01v8 W=0.84 L=0.15
Xn_149_n n_149 n_148 vss vss sky130_fd_pr__nfet_01v8 W=0.42 L=0.15
Xn_149_p n_149 n_148 vdd vdd sky130_fd_pr__pfet_01v8 W=0.7 L=0.15
Xn_150_n n_150 n_149 vss vss sky130_fd_pr__nfet_01v8 W=0.42 L=0.15
Xn_150_p n_150 n_149 vdd vdd sky130_fd_pr__pfet_01v8 W=0.7 L=0.15
Xn_151_p1 n_151 n_149 n_151_x vdd sky130_fd_pr__pfet_01v8 W=1.4 L=0.15
Xn_151_p2 n_151_x n_106 vdd vdd sky130_fd_pr__pfet_01v8 W=1.4 L=0.15
Xn_151_n1 n_151 n_149 vss vss sky130_fd_pr__nfet_01v8 W=0.42 L=0.15
Xn_151_n2 n_151 n_106 vss vss sky130_fd_pr__nfet_01v8 W=0.42 L=0.15
Xn_152_p1 n_152 n_151 n_152_x vdd sky130_fd_pr__pfet_01v8 W=1.4 L=0.15
Xn_152_p2 n_152_x n_4 vdd vdd sky130_fd_pr__pfet_01v8 W=1.4 L=0.15
Xn_152_n1 n_152 n_151 vss vss sky130_fd_pr__nfet_01v8 W=0.42 L=0.15
Xn_152_n2 n_152 n_4 vss vss sky130_fd_pr__nfet_01v8 W=0.42 L=0.15
Xn_153_n n_153 n_152 vss vss sky130_fd_pr__nfet_01v8 W=0.42 L=0.15
Xn_153_p n_153 n_152 vdd vdd sky130_fd_pr__pfet_01v8 W=0.7 L=0.15
Xn_156_p1 n_156 n_150 n_156_x vdd sky130_fd_pr__pfet_01v8 W=1.4 L=0.15
Xn_156_p2 n_156_x n_106 vdd vdd sky130_fd_pr__pfet_01v8 W=1.4 L=0.15
Xn_156_n1 n_156 n_150 vss vss sky130_fd_pr__nfet_01v8 W=0.42 L=0.15
Xn_156_n2 n_156 n_106 vss vss sky130_fd_pr__nfet_01v8 W=0.42 L=0.15
Xn_155_p1 n_155 n_156 n_155_x vdd sky130_fd_pr__pfet_01v8 W=1.4 L=0.15
Xn_155_p2 n_155_x n_154 vdd vdd sky130_fd_pr__pfet_01v8 W=1.4 L=0.15
Xn_155_n1 n_155 n_156 vss vss sky130_fd_pr__nfet_01v8 W=0.42 L=0.15
Xn_155_n2 n_155 n_154 vss vss sky130_fd_pr__nfet_01v8 W=0.42 L=0.15
Xn_154_p1 n_154 n_153 n_154_x vdd sky130_fd_pr__pfet_01v8 W=1.4 L=0.15
Xn_154_p2 n_154_x n_155 vdd vdd sky130_fd_pr__pfet_01v8 W=1.4 L=0.15
Xn_154_n1 n_154 n_153 vss vss sky130_fd_pr__nfet_01v8 W=0.42 L=0.15
Xn_154_n2 n_154 n_155 vss vss sky130_fd_pr__nfet_01v8 W=0.42 L=0.15
Xn_157_p1 n_157 n_154 n_157_x vdd sky130_fd_pr__pfet_01v8 W=1.4 L=0.15
Xn_157_p2 n_157_x n_109 vdd vdd sky130_fd_pr__pfet_01v8 W=1.4 L=0.15
Xn_157_n1 n_157 n_154 vss vss sky130_fd_pr__nfet_01v8 W=0.42 L=0.15
Xn_157_n2 n_157 n_109 vss vss sky130_fd_pr__nfet_01v8 W=0.42 L=0.15
Xn_158_p1 n_158 n_157 n_158_x vdd sky130_fd_pr__pfet_01v8 W=1.4 L=0.15
Xn_158_p2 n_158_x n_4 vdd vdd sky130_fd_pr__pfet_01v8 W=1.4 L=0.15
Xn_158_n1 n_158 n_157 vss vss sky130_fd_pr__nfet_01v8 W=0.42 L=0.15
Xn_158_n2 n_158 n_4 vss vss sky130_fd_pr__nfet_01v8 W=0.42 L=0.15
Xn_159_n n_159 n_158 vss vss sky130_fd_pr__nfet_01v8 W=0.42 L=0.15
Xn_159_p n_159 n_158 vdd vdd sky130_fd_pr__pfet_01v8 W=0.7 L=0.15
Xn_161_p1 n_161 n_155 n_161_x vdd sky130_fd_pr__pfet_01v8 W=1.4 L=0.15
Xn_161_p2 n_161_x n_109 vdd vdd sky130_fd_pr__pfet_01v8 W=1.4 L=0.15
Xn_161_n1 n_161 n_155 vss vss sky130_fd_pr__nfet_01v8 W=0.42 L=0.15
Xn_161_n2 n_161 n_109 vss vss sky130_fd_pr__nfet_01v8 W=0.42 L=0.15
Xn_160_p1 n_160 n_161 n_160_x vdd sky130_fd_pr__pfet_01v8 W=1.4 L=0.15
Xn_160_p2 n_160_x cnt0 vdd vdd sky130_fd_pr__pfet_01v8 W=1.4 L=0.15
Xn_160_n1 n_160 n_161 vss vss sky130_fd_pr__nfet_01v8 W=0.42 L=0.15
Xn_160_n2 n_160 cnt0 vss vss sky130_fd_pr__nfet_01v8 W=0.42 L=0.15
Xcnt0_p1 cnt0 n_159 cnt0_x vdd sky130_fd_pr__pfet_01v8 W=1.4 L=0.15
Xcnt0_p2 cnt0_x n_160 vdd vdd sky130_fd_pr__pfet_01v8 W=1.4 L=0.15
Xcnt0_n1 cnt0 n_159 vss vss sky130_fd_pr__nfet_01v8 W=0.42 L=0.15
Xcnt0_n2 cnt0 n_160 vss vss sky130_fd_pr__nfet_01v8 W=0.42 L=0.15
Xn_162_p1 n_162 cnt0 vdd vdd sky130_fd_pr__pfet_01v8 W=0.7 L=0.15
Xn_162_p2 n_162 n_143 vdd vdd sky130_fd_pr__pfet_01v8 W=0.7 L=0.15
Xn_162_n1 n_162 cnt0 n_162_x vss sky130_fd_pr__nfet_01v8 W=0.84 L=0.15
Xn_162_n2 n_162_x n_143 vss vss sky130_fd_pr__nfet_01v8 W=0.84 L=0.15
Xn_163_n n_163 n_162 vss vss sky130_fd_pr__nfet_01v8 W=0.42 L=0.15
Xn_163_p n_163 n_162 vdd vdd sky130_fd_pr__pfet_01v8 W=0.7 L=0.15
Xn_164_p1 n_164 cnt1 vdd vdd sky130_fd_pr__pfet_01v8 W=0.7 L=0.15
Xn_164_p2 n_164 n_163 vdd vdd sky130_fd_pr__pfet_01v8 W=0.7 L=0.15
Xn_164_n1 n_164 cnt1 n_164_x vss sky130_fd_pr__nfet_01v8 W=0.84 L=0.15
Xn_164_n2 n_164_x n_163 vss vss sky130_fd_pr__nfet_01v8 W=0.84 L=0.15
Xn_165_p1 n_165 cnt1 vdd vdd sky130_fd_pr__pfet_01v8 W=0.7 L=0.15
Xn_165_p2 n_165 n_164 vdd vdd sky130_fd_pr__pfet_01v8 W=0.7 L=0.15
Xn_165_n1 n_165 cnt1 n_165_x vss sky130_fd_pr__nfet_01v8 W=0.84 L=0.15
Xn_165_n2 n_165_x n_164 vss vss sky130_fd_pr__nfet_01v8 W=0.84 L=0.15
Xn_166_p1 n_166 n_163 vdd vdd sky130_fd_pr__pfet_01v8 W=0.7 L=0.15
Xn_166_p2 n_166 n_164 vdd vdd sky130_fd_pr__pfet_01v8 W=0.7 L=0.15
Xn_166_n1 n_166 n_163 n_166_x vss sky130_fd_pr__nfet_01v8 W=0.84 L=0.15
Xn_166_n2 n_166_x n_164 vss vss sky130_fd_pr__nfet_01v8 W=0.84 L=0.15
Xn_167_p1 n_167 n_165 vdd vdd sky130_fd_pr__pfet_01v8 W=0.7 L=0.15
Xn_167_p2 n_167 n_166 vdd vdd sky130_fd_pr__pfet_01v8 W=0.7 L=0.15
Xn_167_n1 n_167 n_165 n_167_x vss sky130_fd_pr__nfet_01v8 W=0.84 L=0.15
Xn_167_n2 n_167_x n_166 vss vss sky130_fd_pr__nfet_01v8 W=0.84 L=0.15
Xn_168_p1 n_168 n_140 vdd vdd sky130_fd_pr__pfet_01v8 W=0.7 L=0.15
Xn_168_p2 n_168 n_167 vdd vdd sky130_fd_pr__pfet_01v8 W=0.7 L=0.15
Xn_168_n1 n_168 n_140 n_168_x vss sky130_fd_pr__nfet_01v8 W=0.84 L=0.15
Xn_168_n2 n_168_x n_167 vss vss sky130_fd_pr__nfet_01v8 W=0.84 L=0.15
Xn_169_n n_169 n_168 vss vss sky130_fd_pr__nfet_01v8 W=0.42 L=0.15
Xn_169_p n_169 n_168 vdd vdd sky130_fd_pr__pfet_01v8 W=0.7 L=0.15
Xn_170_n n_170 n_169 vss vss sky130_fd_pr__nfet_01v8 W=0.42 L=0.15
Xn_170_p n_170 n_169 vdd vdd sky130_fd_pr__pfet_01v8 W=0.7 L=0.15
Xn_171_p1 n_171 n_169 n_171_x vdd sky130_fd_pr__pfet_01v8 W=1.4 L=0.15
Xn_171_p2 n_171_x n_106 vdd vdd sky130_fd_pr__pfet_01v8 W=1.4 L=0.15
Xn_171_n1 n_171 n_169 vss vss sky130_fd_pr__nfet_01v8 W=0.42 L=0.15
Xn_171_n2 n_171 n_106 vss vss sky130_fd_pr__nfet_01v8 W=0.42 L=0.15
Xn_172_p1 n_172 n_171 n_172_x vdd sky130_fd_pr__pfet_01v8 W=1.4 L=0.15
Xn_172_p2 n_172_x n_4 vdd vdd sky130_fd_pr__pfet_01v8 W=1.4 L=0.15
Xn_172_n1 n_172 n_171 vss vss sky130_fd_pr__nfet_01v8 W=0.42 L=0.15
Xn_172_n2 n_172 n_4 vss vss sky130_fd_pr__nfet_01v8 W=0.42 L=0.15
Xn_173_n n_173 n_172 vss vss sky130_fd_pr__nfet_01v8 W=0.42 L=0.15
Xn_173_p n_173 n_172 vdd vdd sky130_fd_pr__pfet_01v8 W=0.7 L=0.15
Xn_176_p1 n_176 n_170 n_176_x vdd sky130_fd_pr__pfet_01v8 W=1.4 L=0.15
Xn_176_p2 n_176_x n_106 vdd vdd sky130_fd_pr__pfet_01v8 W=1.4 L=0.15
Xn_176_n1 n_176 n_170 vss vss sky130_fd_pr__nfet_01v8 W=0.42 L=0.15
Xn_176_n2 n_176 n_106 vss vss sky130_fd_pr__nfet_01v8 W=0.42 L=0.15
Xn_175_p1 n_175 n_176 n_175_x vdd sky130_fd_pr__pfet_01v8 W=1.4 L=0.15
Xn_175_p2 n_175_x n_174 vdd vdd sky130_fd_pr__pfet_01v8 W=1.4 L=0.15
Xn_175_n1 n_175 n_176 vss vss sky130_fd_pr__nfet_01v8 W=0.42 L=0.15
Xn_175_n2 n_175 n_174 vss vss sky130_fd_pr__nfet_01v8 W=0.42 L=0.15
Xn_174_p1 n_174 n_173 n_174_x vdd sky130_fd_pr__pfet_01v8 W=1.4 L=0.15
Xn_174_p2 n_174_x n_175 vdd vdd sky130_fd_pr__pfet_01v8 W=1.4 L=0.15
Xn_174_n1 n_174 n_173 vss vss sky130_fd_pr__nfet_01v8 W=0.42 L=0.15
Xn_174_n2 n_174 n_175 vss vss sky130_fd_pr__nfet_01v8 W=0.42 L=0.15
Xn_177_p1 n_177 n_174 n_177_x vdd sky130_fd_pr__pfet_01v8 W=1.4 L=0.15
Xn_177_p2 n_177_x n_109 vdd vdd sky130_fd_pr__pfet_01v8 W=1.4 L=0.15
Xn_177_n1 n_177 n_174 vss vss sky130_fd_pr__nfet_01v8 W=0.42 L=0.15
Xn_177_n2 n_177 n_109 vss vss sky130_fd_pr__nfet_01v8 W=0.42 L=0.15
Xn_178_p1 n_178 n_177 n_178_x vdd sky130_fd_pr__pfet_01v8 W=1.4 L=0.15
Xn_178_p2 n_178_x n_4 vdd vdd sky130_fd_pr__pfet_01v8 W=1.4 L=0.15
Xn_178_n1 n_178 n_177 vss vss sky130_fd_pr__nfet_01v8 W=0.42 L=0.15
Xn_178_n2 n_178 n_4 vss vss sky130_fd_pr__nfet_01v8 W=0.42 L=0.15
Xn_179_n n_179 n_178 vss vss sky130_fd_pr__nfet_01v8 W=0.42 L=0.15
Xn_179_p n_179 n_178 vdd vdd sky130_fd_pr__pfet_01v8 W=0.7 L=0.15
Xn_181_p1 n_181 n_175 n_181_x vdd sky130_fd_pr__pfet_01v8 W=1.4 L=0.15
Xn_181_p2 n_181_x n_109 vdd vdd sky130_fd_pr__pfet_01v8 W=1.4 L=0.15
Xn_181_n1 n_181 n_175 vss vss sky130_fd_pr__nfet_01v8 W=0.42 L=0.15
Xn_181_n2 n_181 n_109 vss vss sky130_fd_pr__nfet_01v8 W=0.42 L=0.15
Xn_180_p1 n_180 n_181 n_180_x vdd sky130_fd_pr__pfet_01v8 W=1.4 L=0.15
Xn_180_p2 n_180_x cnt1 vdd vdd sky130_fd_pr__pfet_01v8 W=1.4 L=0.15
Xn_180_n1 n_180 n_181 vss vss sky130_fd_pr__nfet_01v8 W=0.42 L=0.15
Xn_180_n2 n_180 cnt1 vss vss sky130_fd_pr__nfet_01v8 W=0.42 L=0.15
Xcnt1_p1 cnt1 n_179 cnt1_x vdd sky130_fd_pr__pfet_01v8 W=1.4 L=0.15
Xcnt1_p2 cnt1_x n_180 vdd vdd sky130_fd_pr__pfet_01v8 W=1.4 L=0.15
Xcnt1_n1 cnt1 n_179 vss vss sky130_fd_pr__nfet_01v8 W=0.42 L=0.15
Xcnt1_n2 cnt1 n_180 vss vss sky130_fd_pr__nfet_01v8 W=0.42 L=0.15
Xn_182_p1 n_182 cnt1 vdd vdd sky130_fd_pr__pfet_01v8 W=0.7 L=0.15
Xn_182_p2 n_182 n_163 vdd vdd sky130_fd_pr__pfet_01v8 W=0.7 L=0.15
Xn_182_n1 n_182 cnt1 n_182_x vss sky130_fd_pr__nfet_01v8 W=0.84 L=0.15
Xn_182_n2 n_182_x n_163 vss vss sky130_fd_pr__nfet_01v8 W=0.84 L=0.15
Xn_183_n n_183 n_182 vss vss sky130_fd_pr__nfet_01v8 W=0.42 L=0.15
Xn_183_p n_183 n_182 vdd vdd sky130_fd_pr__pfet_01v8 W=0.7 L=0.15
Xn_184_p1 n_184 cnt2 vdd vdd sky130_fd_pr__pfet_01v8 W=0.7 L=0.15
Xn_184_p2 n_184 n_183 vdd vdd sky130_fd_pr__pfet_01v8 W=0.7 L=0.15
Xn_184_n1 n_184 cnt2 n_184_x vss sky130_fd_pr__nfet_01v8 W=0.84 L=0.15
Xn_184_n2 n_184_x n_183 vss vss sky130_fd_pr__nfet_01v8 W=0.84 L=0.15
Xn_185_p1 n_185 cnt2 vdd vdd sky130_fd_pr__pfet_01v8 W=0.7 L=0.15
Xn_185_p2 n_185 n_184 vdd vdd sky130_fd_pr__pfet_01v8 W=0.7 L=0.15
Xn_185_n1 n_185 cnt2 n_185_x vss sky130_fd_pr__nfet_01v8 W=0.84 L=0.15
Xn_185_n2 n_185_x n_184 vss vss sky130_fd_pr__nfet_01v8 W=0.84 L=0.15
Xn_186_p1 n_186 n_183 vdd vdd sky130_fd_pr__pfet_01v8 W=0.7 L=0.15
Xn_186_p2 n_186 n_184 vdd vdd sky130_fd_pr__pfet_01v8 W=0.7 L=0.15
Xn_186_n1 n_186 n_183 n_186_x vss sky130_fd_pr__nfet_01v8 W=0.84 L=0.15
Xn_186_n2 n_186_x n_184 vss vss sky130_fd_pr__nfet_01v8 W=0.84 L=0.15
Xn_187_p1 n_187 n_185 vdd vdd sky130_fd_pr__pfet_01v8 W=0.7 L=0.15
Xn_187_p2 n_187 n_186 vdd vdd sky130_fd_pr__pfet_01v8 W=0.7 L=0.15
Xn_187_n1 n_187 n_185 n_187_x vss sky130_fd_pr__nfet_01v8 W=0.84 L=0.15
Xn_187_n2 n_187_x n_186 vss vss sky130_fd_pr__nfet_01v8 W=0.84 L=0.15
Xn_188_p1 n_188 n_140 vdd vdd sky130_fd_pr__pfet_01v8 W=0.7 L=0.15
Xn_188_p2 n_188 n_187 vdd vdd sky130_fd_pr__pfet_01v8 W=0.7 L=0.15
Xn_188_n1 n_188 n_140 n_188_x vss sky130_fd_pr__nfet_01v8 W=0.84 L=0.15
Xn_188_n2 n_188_x n_187 vss vss sky130_fd_pr__nfet_01v8 W=0.84 L=0.15
Xn_189_n n_189 n_188 vss vss sky130_fd_pr__nfet_01v8 W=0.42 L=0.15
Xn_189_p n_189 n_188 vdd vdd sky130_fd_pr__pfet_01v8 W=0.7 L=0.15
Xn_190_n n_190 n_189 vss vss sky130_fd_pr__nfet_01v8 W=0.42 L=0.15
Xn_190_p n_190 n_189 vdd vdd sky130_fd_pr__pfet_01v8 W=0.7 L=0.15
Xn_191_p1 n_191 n_189 n_191_x vdd sky130_fd_pr__pfet_01v8 W=1.4 L=0.15
Xn_191_p2 n_191_x n_106 vdd vdd sky130_fd_pr__pfet_01v8 W=1.4 L=0.15
Xn_191_n1 n_191 n_189 vss vss sky130_fd_pr__nfet_01v8 W=0.42 L=0.15
Xn_191_n2 n_191 n_106 vss vss sky130_fd_pr__nfet_01v8 W=0.42 L=0.15
Xn_192_p1 n_192 n_191 n_192_x vdd sky130_fd_pr__pfet_01v8 W=1.4 L=0.15
Xn_192_p2 n_192_x n_4 vdd vdd sky130_fd_pr__pfet_01v8 W=1.4 L=0.15
Xn_192_n1 n_192 n_191 vss vss sky130_fd_pr__nfet_01v8 W=0.42 L=0.15
Xn_192_n2 n_192 n_4 vss vss sky130_fd_pr__nfet_01v8 W=0.42 L=0.15
Xn_193_n n_193 n_192 vss vss sky130_fd_pr__nfet_01v8 W=0.42 L=0.15
Xn_193_p n_193 n_192 vdd vdd sky130_fd_pr__pfet_01v8 W=0.7 L=0.15
Xn_196_p1 n_196 n_190 n_196_x vdd sky130_fd_pr__pfet_01v8 W=1.4 L=0.15
Xn_196_p2 n_196_x n_106 vdd vdd sky130_fd_pr__pfet_01v8 W=1.4 L=0.15
Xn_196_n1 n_196 n_190 vss vss sky130_fd_pr__nfet_01v8 W=0.42 L=0.15
Xn_196_n2 n_196 n_106 vss vss sky130_fd_pr__nfet_01v8 W=0.42 L=0.15
Xn_195_p1 n_195 n_196 n_195_x vdd sky130_fd_pr__pfet_01v8 W=1.4 L=0.15
Xn_195_p2 n_195_x n_194 vdd vdd sky130_fd_pr__pfet_01v8 W=1.4 L=0.15
Xn_195_n1 n_195 n_196 vss vss sky130_fd_pr__nfet_01v8 W=0.42 L=0.15
Xn_195_n2 n_195 n_194 vss vss sky130_fd_pr__nfet_01v8 W=0.42 L=0.15
Xn_194_p1 n_194 n_193 n_194_x vdd sky130_fd_pr__pfet_01v8 W=1.4 L=0.15
Xn_194_p2 n_194_x n_195 vdd vdd sky130_fd_pr__pfet_01v8 W=1.4 L=0.15
Xn_194_n1 n_194 n_193 vss vss sky130_fd_pr__nfet_01v8 W=0.42 L=0.15
Xn_194_n2 n_194 n_195 vss vss sky130_fd_pr__nfet_01v8 W=0.42 L=0.15
Xn_197_p1 n_197 n_194 n_197_x vdd sky130_fd_pr__pfet_01v8 W=1.4 L=0.15
Xn_197_p2 n_197_x n_109 vdd vdd sky130_fd_pr__pfet_01v8 W=1.4 L=0.15
Xn_197_n1 n_197 n_194 vss vss sky130_fd_pr__nfet_01v8 W=0.42 L=0.15
Xn_197_n2 n_197 n_109 vss vss sky130_fd_pr__nfet_01v8 W=0.42 L=0.15
Xn_198_p1 n_198 n_197 n_198_x vdd sky130_fd_pr__pfet_01v8 W=1.4 L=0.15
Xn_198_p2 n_198_x n_4 vdd vdd sky130_fd_pr__pfet_01v8 W=1.4 L=0.15
Xn_198_n1 n_198 n_197 vss vss sky130_fd_pr__nfet_01v8 W=0.42 L=0.15
Xn_198_n2 n_198 n_4 vss vss sky130_fd_pr__nfet_01v8 W=0.42 L=0.15
Xn_199_n n_199 n_198 vss vss sky130_fd_pr__nfet_01v8 W=0.42 L=0.15
Xn_199_p n_199 n_198 vdd vdd sky130_fd_pr__pfet_01v8 W=0.7 L=0.15
Xn_201_p1 n_201 n_195 n_201_x vdd sky130_fd_pr__pfet_01v8 W=1.4 L=0.15
Xn_201_p2 n_201_x n_109 vdd vdd sky130_fd_pr__pfet_01v8 W=1.4 L=0.15
Xn_201_n1 n_201 n_195 vss vss sky130_fd_pr__nfet_01v8 W=0.42 L=0.15
Xn_201_n2 n_201 n_109 vss vss sky130_fd_pr__nfet_01v8 W=0.42 L=0.15
Xn_200_p1 n_200 n_201 n_200_x vdd sky130_fd_pr__pfet_01v8 W=1.4 L=0.15
Xn_200_p2 n_200_x cnt2 vdd vdd sky130_fd_pr__pfet_01v8 W=1.4 L=0.15
Xn_200_n1 n_200 n_201 vss vss sky130_fd_pr__nfet_01v8 W=0.42 L=0.15
Xn_200_n2 n_200 cnt2 vss vss sky130_fd_pr__nfet_01v8 W=0.42 L=0.15
Xcnt2_p1 cnt2 n_199 cnt2_x vdd sky130_fd_pr__pfet_01v8 W=1.4 L=0.15
Xcnt2_p2 cnt2_x n_200 vdd vdd sky130_fd_pr__pfet_01v8 W=1.4 L=0.15
Xcnt2_n1 cnt2 n_199 vss vss sky130_fd_pr__nfet_01v8 W=0.42 L=0.15
Xcnt2_n2 cnt2 n_200 vss vss sky130_fd_pr__nfet_01v8 W=0.42 L=0.15
Xn_202_p1 n_202 cnt2 vdd vdd sky130_fd_pr__pfet_01v8 W=0.7 L=0.15
Xn_202_p2 n_202 n_183 vdd vdd sky130_fd_pr__pfet_01v8 W=0.7 L=0.15
Xn_202_n1 n_202 cnt2 n_202_x vss sky130_fd_pr__nfet_01v8 W=0.84 L=0.15
Xn_202_n2 n_202_x n_183 vss vss sky130_fd_pr__nfet_01v8 W=0.84 L=0.15
Xn_203_n n_203 n_202 vss vss sky130_fd_pr__nfet_01v8 W=0.42 L=0.15
Xn_203_p n_203 n_202 vdd vdd sky130_fd_pr__pfet_01v8 W=0.7 L=0.15
Xn_204_p1 n_204 cnt3 vdd vdd sky130_fd_pr__pfet_01v8 W=0.7 L=0.15
Xn_204_p2 n_204 n_203 vdd vdd sky130_fd_pr__pfet_01v8 W=0.7 L=0.15
Xn_204_n1 n_204 cnt3 n_204_x vss sky130_fd_pr__nfet_01v8 W=0.84 L=0.15
Xn_204_n2 n_204_x n_203 vss vss sky130_fd_pr__nfet_01v8 W=0.84 L=0.15
Xn_205_p1 n_205 cnt3 vdd vdd sky130_fd_pr__pfet_01v8 W=0.7 L=0.15
Xn_205_p2 n_205 n_204 vdd vdd sky130_fd_pr__pfet_01v8 W=0.7 L=0.15
Xn_205_n1 n_205 cnt3 n_205_x vss sky130_fd_pr__nfet_01v8 W=0.84 L=0.15
Xn_205_n2 n_205_x n_204 vss vss sky130_fd_pr__nfet_01v8 W=0.84 L=0.15
Xn_206_p1 n_206 n_203 vdd vdd sky130_fd_pr__pfet_01v8 W=0.7 L=0.15
Xn_206_p2 n_206 n_204 vdd vdd sky130_fd_pr__pfet_01v8 W=0.7 L=0.15
Xn_206_n1 n_206 n_203 n_206_x vss sky130_fd_pr__nfet_01v8 W=0.84 L=0.15
Xn_206_n2 n_206_x n_204 vss vss sky130_fd_pr__nfet_01v8 W=0.84 L=0.15
Xn_207_p1 n_207 n_205 vdd vdd sky130_fd_pr__pfet_01v8 W=0.7 L=0.15
Xn_207_p2 n_207 n_206 vdd vdd sky130_fd_pr__pfet_01v8 W=0.7 L=0.15
Xn_207_n1 n_207 n_205 n_207_x vss sky130_fd_pr__nfet_01v8 W=0.84 L=0.15
Xn_207_n2 n_207_x n_206 vss vss sky130_fd_pr__nfet_01v8 W=0.84 L=0.15
Xn_208_p1 n_208 n_140 vdd vdd sky130_fd_pr__pfet_01v8 W=0.7 L=0.15
Xn_208_p2 n_208 n_207 vdd vdd sky130_fd_pr__pfet_01v8 W=0.7 L=0.15
Xn_208_n1 n_208 n_140 n_208_x vss sky130_fd_pr__nfet_01v8 W=0.84 L=0.15
Xn_208_n2 n_208_x n_207 vss vss sky130_fd_pr__nfet_01v8 W=0.84 L=0.15
Xn_209_n n_209 n_208 vss vss sky130_fd_pr__nfet_01v8 W=0.42 L=0.15
Xn_209_p n_209 n_208 vdd vdd sky130_fd_pr__pfet_01v8 W=0.7 L=0.15
Xn_210_n n_210 n_209 vss vss sky130_fd_pr__nfet_01v8 W=0.42 L=0.15
Xn_210_p n_210 n_209 vdd vdd sky130_fd_pr__pfet_01v8 W=0.7 L=0.15
Xn_211_p1 n_211 n_209 n_211_x vdd sky130_fd_pr__pfet_01v8 W=1.4 L=0.15
Xn_211_p2 n_211_x n_106 vdd vdd sky130_fd_pr__pfet_01v8 W=1.4 L=0.15
Xn_211_n1 n_211 n_209 vss vss sky130_fd_pr__nfet_01v8 W=0.42 L=0.15
Xn_211_n2 n_211 n_106 vss vss sky130_fd_pr__nfet_01v8 W=0.42 L=0.15
Xn_212_p1 n_212 n_211 n_212_x vdd sky130_fd_pr__pfet_01v8 W=1.4 L=0.15
Xn_212_p2 n_212_x n_4 vdd vdd sky130_fd_pr__pfet_01v8 W=1.4 L=0.15
Xn_212_n1 n_212 n_211 vss vss sky130_fd_pr__nfet_01v8 W=0.42 L=0.15
Xn_212_n2 n_212 n_4 vss vss sky130_fd_pr__nfet_01v8 W=0.42 L=0.15
Xn_213_n n_213 n_212 vss vss sky130_fd_pr__nfet_01v8 W=0.42 L=0.15
Xn_213_p n_213 n_212 vdd vdd sky130_fd_pr__pfet_01v8 W=0.7 L=0.15
Xn_216_p1 n_216 n_210 n_216_x vdd sky130_fd_pr__pfet_01v8 W=1.4 L=0.15
Xn_216_p2 n_216_x n_106 vdd vdd sky130_fd_pr__pfet_01v8 W=1.4 L=0.15
Xn_216_n1 n_216 n_210 vss vss sky130_fd_pr__nfet_01v8 W=0.42 L=0.15
Xn_216_n2 n_216 n_106 vss vss sky130_fd_pr__nfet_01v8 W=0.42 L=0.15
Xn_215_p1 n_215 n_216 n_215_x vdd sky130_fd_pr__pfet_01v8 W=1.4 L=0.15
Xn_215_p2 n_215_x n_214 vdd vdd sky130_fd_pr__pfet_01v8 W=1.4 L=0.15
Xn_215_n1 n_215 n_216 vss vss sky130_fd_pr__nfet_01v8 W=0.42 L=0.15
Xn_215_n2 n_215 n_214 vss vss sky130_fd_pr__nfet_01v8 W=0.42 L=0.15
Xn_214_p1 n_214 n_213 n_214_x vdd sky130_fd_pr__pfet_01v8 W=1.4 L=0.15
Xn_214_p2 n_214_x n_215 vdd vdd sky130_fd_pr__pfet_01v8 W=1.4 L=0.15
Xn_214_n1 n_214 n_213 vss vss sky130_fd_pr__nfet_01v8 W=0.42 L=0.15
Xn_214_n2 n_214 n_215 vss vss sky130_fd_pr__nfet_01v8 W=0.42 L=0.15
Xn_217_p1 n_217 n_214 n_217_x vdd sky130_fd_pr__pfet_01v8 W=1.4 L=0.15
Xn_217_p2 n_217_x n_109 vdd vdd sky130_fd_pr__pfet_01v8 W=1.4 L=0.15
Xn_217_n1 n_217 n_214 vss vss sky130_fd_pr__nfet_01v8 W=0.42 L=0.15
Xn_217_n2 n_217 n_109 vss vss sky130_fd_pr__nfet_01v8 W=0.42 L=0.15
Xn_218_p1 n_218 n_217 n_218_x vdd sky130_fd_pr__pfet_01v8 W=1.4 L=0.15
Xn_218_p2 n_218_x n_4 vdd vdd sky130_fd_pr__pfet_01v8 W=1.4 L=0.15
Xn_218_n1 n_218 n_217 vss vss sky130_fd_pr__nfet_01v8 W=0.42 L=0.15
Xn_218_n2 n_218 n_4 vss vss sky130_fd_pr__nfet_01v8 W=0.42 L=0.15
Xn_219_n n_219 n_218 vss vss sky130_fd_pr__nfet_01v8 W=0.42 L=0.15
Xn_219_p n_219 n_218 vdd vdd sky130_fd_pr__pfet_01v8 W=0.7 L=0.15
Xn_221_p1 n_221 n_215 n_221_x vdd sky130_fd_pr__pfet_01v8 W=1.4 L=0.15
Xn_221_p2 n_221_x n_109 vdd vdd sky130_fd_pr__pfet_01v8 W=1.4 L=0.15
Xn_221_n1 n_221 n_215 vss vss sky130_fd_pr__nfet_01v8 W=0.42 L=0.15
Xn_221_n2 n_221 n_109 vss vss sky130_fd_pr__nfet_01v8 W=0.42 L=0.15
Xn_220_p1 n_220 n_221 n_220_x vdd sky130_fd_pr__pfet_01v8 W=1.4 L=0.15
Xn_220_p2 n_220_x cnt3 vdd vdd sky130_fd_pr__pfet_01v8 W=1.4 L=0.15
Xn_220_n1 n_220 n_221 vss vss sky130_fd_pr__nfet_01v8 W=0.42 L=0.15
Xn_220_n2 n_220 cnt3 vss vss sky130_fd_pr__nfet_01v8 W=0.42 L=0.15
Xcnt3_p1 cnt3 n_219 cnt3_x vdd sky130_fd_pr__pfet_01v8 W=1.4 L=0.15
Xcnt3_p2 cnt3_x n_220 vdd vdd sky130_fd_pr__pfet_01v8 W=1.4 L=0.15
Xcnt3_n1 cnt3 n_219 vss vss sky130_fd_pr__nfet_01v8 W=0.42 L=0.15
Xcnt3_n2 cnt3 n_220 vss vss sky130_fd_pr__nfet_01v8 W=0.42 L=0.15
Xn_222_p1 n_222 cnt3 vdd vdd sky130_fd_pr__pfet_01v8 W=0.7 L=0.15
Xn_222_p2 n_222 n_203 vdd vdd sky130_fd_pr__pfet_01v8 W=0.7 L=0.15
Xn_222_n1 n_222 cnt3 n_222_x vss sky130_fd_pr__nfet_01v8 W=0.84 L=0.15
Xn_222_n2 n_222_x n_203 vss vss sky130_fd_pr__nfet_01v8 W=0.84 L=0.15
Xn_223_n n_223 n_222 vss vss sky130_fd_pr__nfet_01v8 W=0.42 L=0.15
Xn_223_p n_223 n_222 vdd vdd sky130_fd_pr__pfet_01v8 W=0.7 L=0.15
Xn_224_p1 n_224 cnt4 vdd vdd sky130_fd_pr__pfet_01v8 W=0.7 L=0.15
Xn_224_p2 n_224 n_223 vdd vdd sky130_fd_pr__pfet_01v8 W=0.7 L=0.15
Xn_224_n1 n_224 cnt4 n_224_x vss sky130_fd_pr__nfet_01v8 W=0.84 L=0.15
Xn_224_n2 n_224_x n_223 vss vss sky130_fd_pr__nfet_01v8 W=0.84 L=0.15
Xn_225_p1 n_225 cnt4 vdd vdd sky130_fd_pr__pfet_01v8 W=0.7 L=0.15
Xn_225_p2 n_225 n_224 vdd vdd sky130_fd_pr__pfet_01v8 W=0.7 L=0.15
Xn_225_n1 n_225 cnt4 n_225_x vss sky130_fd_pr__nfet_01v8 W=0.84 L=0.15
Xn_225_n2 n_225_x n_224 vss vss sky130_fd_pr__nfet_01v8 W=0.84 L=0.15
Xn_226_p1 n_226 n_223 vdd vdd sky130_fd_pr__pfet_01v8 W=0.7 L=0.15
Xn_226_p2 n_226 n_224 vdd vdd sky130_fd_pr__pfet_01v8 W=0.7 L=0.15
Xn_226_n1 n_226 n_223 n_226_x vss sky130_fd_pr__nfet_01v8 W=0.84 L=0.15
Xn_226_n2 n_226_x n_224 vss vss sky130_fd_pr__nfet_01v8 W=0.84 L=0.15
Xn_227_p1 n_227 n_225 vdd vdd sky130_fd_pr__pfet_01v8 W=0.7 L=0.15
Xn_227_p2 n_227 n_226 vdd vdd sky130_fd_pr__pfet_01v8 W=0.7 L=0.15
Xn_227_n1 n_227 n_225 n_227_x vss sky130_fd_pr__nfet_01v8 W=0.84 L=0.15
Xn_227_n2 n_227_x n_226 vss vss sky130_fd_pr__nfet_01v8 W=0.84 L=0.15
Xn_228_p1 n_228 n_140 vdd vdd sky130_fd_pr__pfet_01v8 W=0.7 L=0.15
Xn_228_p2 n_228 n_227 vdd vdd sky130_fd_pr__pfet_01v8 W=0.7 L=0.15
Xn_228_n1 n_228 n_140 n_228_x vss sky130_fd_pr__nfet_01v8 W=0.84 L=0.15
Xn_228_n2 n_228_x n_227 vss vss sky130_fd_pr__nfet_01v8 W=0.84 L=0.15
Xn_229_n n_229 n_228 vss vss sky130_fd_pr__nfet_01v8 W=0.42 L=0.15
Xn_229_p n_229 n_228 vdd vdd sky130_fd_pr__pfet_01v8 W=0.7 L=0.15
Xn_230_n n_230 n_229 vss vss sky130_fd_pr__nfet_01v8 W=0.42 L=0.15
Xn_230_p n_230 n_229 vdd vdd sky130_fd_pr__pfet_01v8 W=0.7 L=0.15
Xn_231_p1 n_231 n_229 n_231_x vdd sky130_fd_pr__pfet_01v8 W=1.4 L=0.15
Xn_231_p2 n_231_x n_106 vdd vdd sky130_fd_pr__pfet_01v8 W=1.4 L=0.15
Xn_231_n1 n_231 n_229 vss vss sky130_fd_pr__nfet_01v8 W=0.42 L=0.15
Xn_231_n2 n_231 n_106 vss vss sky130_fd_pr__nfet_01v8 W=0.42 L=0.15
Xn_232_p1 n_232 n_231 n_232_x vdd sky130_fd_pr__pfet_01v8 W=1.4 L=0.15
Xn_232_p2 n_232_x n_4 vdd vdd sky130_fd_pr__pfet_01v8 W=1.4 L=0.15
Xn_232_n1 n_232 n_231 vss vss sky130_fd_pr__nfet_01v8 W=0.42 L=0.15
Xn_232_n2 n_232 n_4 vss vss sky130_fd_pr__nfet_01v8 W=0.42 L=0.15
Xn_233_n n_233 n_232 vss vss sky130_fd_pr__nfet_01v8 W=0.42 L=0.15
Xn_233_p n_233 n_232 vdd vdd sky130_fd_pr__pfet_01v8 W=0.7 L=0.15
Xn_236_p1 n_236 n_230 n_236_x vdd sky130_fd_pr__pfet_01v8 W=1.4 L=0.15
Xn_236_p2 n_236_x n_106 vdd vdd sky130_fd_pr__pfet_01v8 W=1.4 L=0.15
Xn_236_n1 n_236 n_230 vss vss sky130_fd_pr__nfet_01v8 W=0.42 L=0.15
Xn_236_n2 n_236 n_106 vss vss sky130_fd_pr__nfet_01v8 W=0.42 L=0.15
Xn_235_p1 n_235 n_236 n_235_x vdd sky130_fd_pr__pfet_01v8 W=1.4 L=0.15
Xn_235_p2 n_235_x n_234 vdd vdd sky130_fd_pr__pfet_01v8 W=1.4 L=0.15
Xn_235_n1 n_235 n_236 vss vss sky130_fd_pr__nfet_01v8 W=0.42 L=0.15
Xn_235_n2 n_235 n_234 vss vss sky130_fd_pr__nfet_01v8 W=0.42 L=0.15
Xn_234_p1 n_234 n_233 n_234_x vdd sky130_fd_pr__pfet_01v8 W=1.4 L=0.15
Xn_234_p2 n_234_x n_235 vdd vdd sky130_fd_pr__pfet_01v8 W=1.4 L=0.15
Xn_234_n1 n_234 n_233 vss vss sky130_fd_pr__nfet_01v8 W=0.42 L=0.15
Xn_234_n2 n_234 n_235 vss vss sky130_fd_pr__nfet_01v8 W=0.42 L=0.15
Xn_237_p1 n_237 n_234 n_237_x vdd sky130_fd_pr__pfet_01v8 W=1.4 L=0.15
Xn_237_p2 n_237_x n_109 vdd vdd sky130_fd_pr__pfet_01v8 W=1.4 L=0.15
Xn_237_n1 n_237 n_234 vss vss sky130_fd_pr__nfet_01v8 W=0.42 L=0.15
Xn_237_n2 n_237 n_109 vss vss sky130_fd_pr__nfet_01v8 W=0.42 L=0.15
Xn_238_p1 n_238 n_237 n_238_x vdd sky130_fd_pr__pfet_01v8 W=1.4 L=0.15
Xn_238_p2 n_238_x n_4 vdd vdd sky130_fd_pr__pfet_01v8 W=1.4 L=0.15
Xn_238_n1 n_238 n_237 vss vss sky130_fd_pr__nfet_01v8 W=0.42 L=0.15
Xn_238_n2 n_238 n_4 vss vss sky130_fd_pr__nfet_01v8 W=0.42 L=0.15
Xn_239_n n_239 n_238 vss vss sky130_fd_pr__nfet_01v8 W=0.42 L=0.15
Xn_239_p n_239 n_238 vdd vdd sky130_fd_pr__pfet_01v8 W=0.7 L=0.15
Xn_241_p1 n_241 n_235 n_241_x vdd sky130_fd_pr__pfet_01v8 W=1.4 L=0.15
Xn_241_p2 n_241_x n_109 vdd vdd sky130_fd_pr__pfet_01v8 W=1.4 L=0.15
Xn_241_n1 n_241 n_235 vss vss sky130_fd_pr__nfet_01v8 W=0.42 L=0.15
Xn_241_n2 n_241 n_109 vss vss sky130_fd_pr__nfet_01v8 W=0.42 L=0.15
Xn_240_p1 n_240 n_241 n_240_x vdd sky130_fd_pr__pfet_01v8 W=1.4 L=0.15
Xn_240_p2 n_240_x cnt4 vdd vdd sky130_fd_pr__pfet_01v8 W=1.4 L=0.15
Xn_240_n1 n_240 n_241 vss vss sky130_fd_pr__nfet_01v8 W=0.42 L=0.15
Xn_240_n2 n_240 cnt4 vss vss sky130_fd_pr__nfet_01v8 W=0.42 L=0.15
Xcnt4_p1 cnt4 n_239 cnt4_x vdd sky130_fd_pr__pfet_01v8 W=1.4 L=0.15
Xcnt4_p2 cnt4_x n_240 vdd vdd sky130_fd_pr__pfet_01v8 W=1.4 L=0.15
Xcnt4_n1 cnt4 n_239 vss vss sky130_fd_pr__nfet_01v8 W=0.42 L=0.15
Xcnt4_n2 cnt4 n_240 vss vss sky130_fd_pr__nfet_01v8 W=0.42 L=0.15
Xn_242_p1 n_242 cnt4 vdd vdd sky130_fd_pr__pfet_01v8 W=0.7 L=0.15
Xn_242_p2 n_242 n_223 vdd vdd sky130_fd_pr__pfet_01v8 W=0.7 L=0.15
Xn_242_n1 n_242 cnt4 n_242_x vss sky130_fd_pr__nfet_01v8 W=0.84 L=0.15
Xn_242_n2 n_242_x n_223 vss vss sky130_fd_pr__nfet_01v8 W=0.84 L=0.15
Xn_243_n n_243 n_242 vss vss sky130_fd_pr__nfet_01v8 W=0.42 L=0.15
Xn_243_p n_243 n_242 vdd vdd sky130_fd_pr__pfet_01v8 W=0.7 L=0.15
Xn_244_p1 n_244 cnt5 vdd vdd sky130_fd_pr__pfet_01v8 W=0.7 L=0.15
Xn_244_p2 n_244 n_243 vdd vdd sky130_fd_pr__pfet_01v8 W=0.7 L=0.15
Xn_244_n1 n_244 cnt5 n_244_x vss sky130_fd_pr__nfet_01v8 W=0.84 L=0.15
Xn_244_n2 n_244_x n_243 vss vss sky130_fd_pr__nfet_01v8 W=0.84 L=0.15
Xn_245_p1 n_245 cnt5 vdd vdd sky130_fd_pr__pfet_01v8 W=0.7 L=0.15
Xn_245_p2 n_245 n_244 vdd vdd sky130_fd_pr__pfet_01v8 W=0.7 L=0.15
Xn_245_n1 n_245 cnt5 n_245_x vss sky130_fd_pr__nfet_01v8 W=0.84 L=0.15
Xn_245_n2 n_245_x n_244 vss vss sky130_fd_pr__nfet_01v8 W=0.84 L=0.15
Xn_246_p1 n_246 n_243 vdd vdd sky130_fd_pr__pfet_01v8 W=0.7 L=0.15
Xn_246_p2 n_246 n_244 vdd vdd sky130_fd_pr__pfet_01v8 W=0.7 L=0.15
Xn_246_n1 n_246 n_243 n_246_x vss sky130_fd_pr__nfet_01v8 W=0.84 L=0.15
Xn_246_n2 n_246_x n_244 vss vss sky130_fd_pr__nfet_01v8 W=0.84 L=0.15
Xn_247_p1 n_247 n_245 vdd vdd sky130_fd_pr__pfet_01v8 W=0.7 L=0.15
Xn_247_p2 n_247 n_246 vdd vdd sky130_fd_pr__pfet_01v8 W=0.7 L=0.15
Xn_247_n1 n_247 n_245 n_247_x vss sky130_fd_pr__nfet_01v8 W=0.84 L=0.15
Xn_247_n2 n_247_x n_246 vss vss sky130_fd_pr__nfet_01v8 W=0.84 L=0.15
Xn_248_p1 n_248 n_140 vdd vdd sky130_fd_pr__pfet_01v8 W=0.7 L=0.15
Xn_248_p2 n_248 n_247 vdd vdd sky130_fd_pr__pfet_01v8 W=0.7 L=0.15
Xn_248_n1 n_248 n_140 n_248_x vss sky130_fd_pr__nfet_01v8 W=0.84 L=0.15
Xn_248_n2 n_248_x n_247 vss vss sky130_fd_pr__nfet_01v8 W=0.84 L=0.15
Xn_249_n n_249 n_248 vss vss sky130_fd_pr__nfet_01v8 W=0.42 L=0.15
Xn_249_p n_249 n_248 vdd vdd sky130_fd_pr__pfet_01v8 W=0.7 L=0.15
Xn_250_n n_250 n_249 vss vss sky130_fd_pr__nfet_01v8 W=0.42 L=0.15
Xn_250_p n_250 n_249 vdd vdd sky130_fd_pr__pfet_01v8 W=0.7 L=0.15
Xn_251_p1 n_251 n_249 n_251_x vdd sky130_fd_pr__pfet_01v8 W=1.4 L=0.15
Xn_251_p2 n_251_x n_106 vdd vdd sky130_fd_pr__pfet_01v8 W=1.4 L=0.15
Xn_251_n1 n_251 n_249 vss vss sky130_fd_pr__nfet_01v8 W=0.42 L=0.15
Xn_251_n2 n_251 n_106 vss vss sky130_fd_pr__nfet_01v8 W=0.42 L=0.15
Xn_252_p1 n_252 n_251 n_252_x vdd sky130_fd_pr__pfet_01v8 W=1.4 L=0.15
Xn_252_p2 n_252_x n_4 vdd vdd sky130_fd_pr__pfet_01v8 W=1.4 L=0.15
Xn_252_n1 n_252 n_251 vss vss sky130_fd_pr__nfet_01v8 W=0.42 L=0.15
Xn_252_n2 n_252 n_4 vss vss sky130_fd_pr__nfet_01v8 W=0.42 L=0.15
Xn_253_n n_253 n_252 vss vss sky130_fd_pr__nfet_01v8 W=0.42 L=0.15
Xn_253_p n_253 n_252 vdd vdd sky130_fd_pr__pfet_01v8 W=0.7 L=0.15
Xn_256_p1 n_256 n_250 n_256_x vdd sky130_fd_pr__pfet_01v8 W=1.4 L=0.15
Xn_256_p2 n_256_x n_106 vdd vdd sky130_fd_pr__pfet_01v8 W=1.4 L=0.15
Xn_256_n1 n_256 n_250 vss vss sky130_fd_pr__nfet_01v8 W=0.42 L=0.15
Xn_256_n2 n_256 n_106 vss vss sky130_fd_pr__nfet_01v8 W=0.42 L=0.15
Xn_255_p1 n_255 n_256 n_255_x vdd sky130_fd_pr__pfet_01v8 W=1.4 L=0.15
Xn_255_p2 n_255_x n_254 vdd vdd sky130_fd_pr__pfet_01v8 W=1.4 L=0.15
Xn_255_n1 n_255 n_256 vss vss sky130_fd_pr__nfet_01v8 W=0.42 L=0.15
Xn_255_n2 n_255 n_254 vss vss sky130_fd_pr__nfet_01v8 W=0.42 L=0.15
Xn_254_p1 n_254 n_253 n_254_x vdd sky130_fd_pr__pfet_01v8 W=1.4 L=0.15
Xn_254_p2 n_254_x n_255 vdd vdd sky130_fd_pr__pfet_01v8 W=1.4 L=0.15
Xn_254_n1 n_254 n_253 vss vss sky130_fd_pr__nfet_01v8 W=0.42 L=0.15
Xn_254_n2 n_254 n_255 vss vss sky130_fd_pr__nfet_01v8 W=0.42 L=0.15
Xn_257_p1 n_257 n_254 n_257_x vdd sky130_fd_pr__pfet_01v8 W=1.4 L=0.15
Xn_257_p2 n_257_x n_109 vdd vdd sky130_fd_pr__pfet_01v8 W=1.4 L=0.15
Xn_257_n1 n_257 n_254 vss vss sky130_fd_pr__nfet_01v8 W=0.42 L=0.15
Xn_257_n2 n_257 n_109 vss vss sky130_fd_pr__nfet_01v8 W=0.42 L=0.15
Xn_258_p1 n_258 n_257 n_258_x vdd sky130_fd_pr__pfet_01v8 W=1.4 L=0.15
Xn_258_p2 n_258_x n_4 vdd vdd sky130_fd_pr__pfet_01v8 W=1.4 L=0.15
Xn_258_n1 n_258 n_257 vss vss sky130_fd_pr__nfet_01v8 W=0.42 L=0.15
Xn_258_n2 n_258 n_4 vss vss sky130_fd_pr__nfet_01v8 W=0.42 L=0.15
Xn_259_n n_259 n_258 vss vss sky130_fd_pr__nfet_01v8 W=0.42 L=0.15
Xn_259_p n_259 n_258 vdd vdd sky130_fd_pr__pfet_01v8 W=0.7 L=0.15
Xn_261_p1 n_261 n_255 n_261_x vdd sky130_fd_pr__pfet_01v8 W=1.4 L=0.15
Xn_261_p2 n_261_x n_109 vdd vdd sky130_fd_pr__pfet_01v8 W=1.4 L=0.15
Xn_261_n1 n_261 n_255 vss vss sky130_fd_pr__nfet_01v8 W=0.42 L=0.15
Xn_261_n2 n_261 n_109 vss vss sky130_fd_pr__nfet_01v8 W=0.42 L=0.15
Xn_260_p1 n_260 n_261 n_260_x vdd sky130_fd_pr__pfet_01v8 W=1.4 L=0.15
Xn_260_p2 n_260_x cnt5 vdd vdd sky130_fd_pr__pfet_01v8 W=1.4 L=0.15
Xn_260_n1 n_260 n_261 vss vss sky130_fd_pr__nfet_01v8 W=0.42 L=0.15
Xn_260_n2 n_260 cnt5 vss vss sky130_fd_pr__nfet_01v8 W=0.42 L=0.15
Xcnt5_p1 cnt5 n_259 cnt5_x vdd sky130_fd_pr__pfet_01v8 W=1.4 L=0.15
Xcnt5_p2 cnt5_x n_260 vdd vdd sky130_fd_pr__pfet_01v8 W=1.4 L=0.15
Xcnt5_n1 cnt5 n_259 vss vss sky130_fd_pr__nfet_01v8 W=0.42 L=0.15
Xcnt5_n2 cnt5 n_260 vss vss sky130_fd_pr__nfet_01v8 W=0.42 L=0.15
Xn_262_p1 n_262 cnt5 vdd vdd sky130_fd_pr__pfet_01v8 W=0.7 L=0.15
Xn_262_p2 n_262 n_243 vdd vdd sky130_fd_pr__pfet_01v8 W=0.7 L=0.15
Xn_262_n1 n_262 cnt5 n_262_x vss sky130_fd_pr__nfet_01v8 W=0.84 L=0.15
Xn_262_n2 n_262_x n_243 vss vss sky130_fd_pr__nfet_01v8 W=0.84 L=0.15
Xn_263_n n_263 n_262 vss vss sky130_fd_pr__nfet_01v8 W=0.42 L=0.15
Xn_263_p n_263 n_262 vdd vdd sky130_fd_pr__pfet_01v8 W=0.7 L=0.15
Xn_264_p1 n_264 cnt6 vdd vdd sky130_fd_pr__pfet_01v8 W=0.7 L=0.15
Xn_264_p2 n_264 n_263 vdd vdd sky130_fd_pr__pfet_01v8 W=0.7 L=0.15
Xn_264_n1 n_264 cnt6 n_264_x vss sky130_fd_pr__nfet_01v8 W=0.84 L=0.15
Xn_264_n2 n_264_x n_263 vss vss sky130_fd_pr__nfet_01v8 W=0.84 L=0.15
Xn_265_p1 n_265 cnt6 vdd vdd sky130_fd_pr__pfet_01v8 W=0.7 L=0.15
Xn_265_p2 n_265 n_264 vdd vdd sky130_fd_pr__pfet_01v8 W=0.7 L=0.15
Xn_265_n1 n_265 cnt6 n_265_x vss sky130_fd_pr__nfet_01v8 W=0.84 L=0.15
Xn_265_n2 n_265_x n_264 vss vss sky130_fd_pr__nfet_01v8 W=0.84 L=0.15
Xn_266_p1 n_266 n_263 vdd vdd sky130_fd_pr__pfet_01v8 W=0.7 L=0.15
Xn_266_p2 n_266 n_264 vdd vdd sky130_fd_pr__pfet_01v8 W=0.7 L=0.15
Xn_266_n1 n_266 n_263 n_266_x vss sky130_fd_pr__nfet_01v8 W=0.84 L=0.15
Xn_266_n2 n_266_x n_264 vss vss sky130_fd_pr__nfet_01v8 W=0.84 L=0.15
Xn_267_p1 n_267 n_265 vdd vdd sky130_fd_pr__pfet_01v8 W=0.7 L=0.15
Xn_267_p2 n_267 n_266 vdd vdd sky130_fd_pr__pfet_01v8 W=0.7 L=0.15
Xn_267_n1 n_267 n_265 n_267_x vss sky130_fd_pr__nfet_01v8 W=0.84 L=0.15
Xn_267_n2 n_267_x n_266 vss vss sky130_fd_pr__nfet_01v8 W=0.84 L=0.15
Xn_268_p1 n_268 n_140 vdd vdd sky130_fd_pr__pfet_01v8 W=0.7 L=0.15
Xn_268_p2 n_268 n_267 vdd vdd sky130_fd_pr__pfet_01v8 W=0.7 L=0.15
Xn_268_n1 n_268 n_140 n_268_x vss sky130_fd_pr__nfet_01v8 W=0.84 L=0.15
Xn_268_n2 n_268_x n_267 vss vss sky130_fd_pr__nfet_01v8 W=0.84 L=0.15
Xn_269_n n_269 n_268 vss vss sky130_fd_pr__nfet_01v8 W=0.42 L=0.15
Xn_269_p n_269 n_268 vdd vdd sky130_fd_pr__pfet_01v8 W=0.7 L=0.15
Xn_270_n n_270 n_269 vss vss sky130_fd_pr__nfet_01v8 W=0.42 L=0.15
Xn_270_p n_270 n_269 vdd vdd sky130_fd_pr__pfet_01v8 W=0.7 L=0.15
Xn_271_p1 n_271 n_269 n_271_x vdd sky130_fd_pr__pfet_01v8 W=1.4 L=0.15
Xn_271_p2 n_271_x n_106 vdd vdd sky130_fd_pr__pfet_01v8 W=1.4 L=0.15
Xn_271_n1 n_271 n_269 vss vss sky130_fd_pr__nfet_01v8 W=0.42 L=0.15
Xn_271_n2 n_271 n_106 vss vss sky130_fd_pr__nfet_01v8 W=0.42 L=0.15
Xn_272_p1 n_272 n_271 n_272_x vdd sky130_fd_pr__pfet_01v8 W=1.4 L=0.15
Xn_272_p2 n_272_x n_4 vdd vdd sky130_fd_pr__pfet_01v8 W=1.4 L=0.15
Xn_272_n1 n_272 n_271 vss vss sky130_fd_pr__nfet_01v8 W=0.42 L=0.15
Xn_272_n2 n_272 n_4 vss vss sky130_fd_pr__nfet_01v8 W=0.42 L=0.15
Xn_273_n n_273 n_272 vss vss sky130_fd_pr__nfet_01v8 W=0.42 L=0.15
Xn_273_p n_273 n_272 vdd vdd sky130_fd_pr__pfet_01v8 W=0.7 L=0.15
Xn_276_p1 n_276 n_270 n_276_x vdd sky130_fd_pr__pfet_01v8 W=1.4 L=0.15
Xn_276_p2 n_276_x n_106 vdd vdd sky130_fd_pr__pfet_01v8 W=1.4 L=0.15
Xn_276_n1 n_276 n_270 vss vss sky130_fd_pr__nfet_01v8 W=0.42 L=0.15
Xn_276_n2 n_276 n_106 vss vss sky130_fd_pr__nfet_01v8 W=0.42 L=0.15
Xn_275_p1 n_275 n_276 n_275_x vdd sky130_fd_pr__pfet_01v8 W=1.4 L=0.15
Xn_275_p2 n_275_x n_274 vdd vdd sky130_fd_pr__pfet_01v8 W=1.4 L=0.15
Xn_275_n1 n_275 n_276 vss vss sky130_fd_pr__nfet_01v8 W=0.42 L=0.15
Xn_275_n2 n_275 n_274 vss vss sky130_fd_pr__nfet_01v8 W=0.42 L=0.15
Xn_274_p1 n_274 n_273 n_274_x vdd sky130_fd_pr__pfet_01v8 W=1.4 L=0.15
Xn_274_p2 n_274_x n_275 vdd vdd sky130_fd_pr__pfet_01v8 W=1.4 L=0.15
Xn_274_n1 n_274 n_273 vss vss sky130_fd_pr__nfet_01v8 W=0.42 L=0.15
Xn_274_n2 n_274 n_275 vss vss sky130_fd_pr__nfet_01v8 W=0.42 L=0.15
Xn_277_p1 n_277 n_274 n_277_x vdd sky130_fd_pr__pfet_01v8 W=1.4 L=0.15
Xn_277_p2 n_277_x n_109 vdd vdd sky130_fd_pr__pfet_01v8 W=1.4 L=0.15
Xn_277_n1 n_277 n_274 vss vss sky130_fd_pr__nfet_01v8 W=0.42 L=0.15
Xn_277_n2 n_277 n_109 vss vss sky130_fd_pr__nfet_01v8 W=0.42 L=0.15
Xn_278_p1 n_278 n_277 n_278_x vdd sky130_fd_pr__pfet_01v8 W=1.4 L=0.15
Xn_278_p2 n_278_x n_4 vdd vdd sky130_fd_pr__pfet_01v8 W=1.4 L=0.15
Xn_278_n1 n_278 n_277 vss vss sky130_fd_pr__nfet_01v8 W=0.42 L=0.15
Xn_278_n2 n_278 n_4 vss vss sky130_fd_pr__nfet_01v8 W=0.42 L=0.15
Xn_279_n n_279 n_278 vss vss sky130_fd_pr__nfet_01v8 W=0.42 L=0.15
Xn_279_p n_279 n_278 vdd vdd sky130_fd_pr__pfet_01v8 W=0.7 L=0.15
Xn_281_p1 n_281 n_275 n_281_x vdd sky130_fd_pr__pfet_01v8 W=1.4 L=0.15
Xn_281_p2 n_281_x n_109 vdd vdd sky130_fd_pr__pfet_01v8 W=1.4 L=0.15
Xn_281_n1 n_281 n_275 vss vss sky130_fd_pr__nfet_01v8 W=0.42 L=0.15
Xn_281_n2 n_281 n_109 vss vss sky130_fd_pr__nfet_01v8 W=0.42 L=0.15
Xn_280_p1 n_280 n_281 n_280_x vdd sky130_fd_pr__pfet_01v8 W=1.4 L=0.15
Xn_280_p2 n_280_x cnt6 vdd vdd sky130_fd_pr__pfet_01v8 W=1.4 L=0.15
Xn_280_n1 n_280 n_281 vss vss sky130_fd_pr__nfet_01v8 W=0.42 L=0.15
Xn_280_n2 n_280 cnt6 vss vss sky130_fd_pr__nfet_01v8 W=0.42 L=0.15
Xcnt6_p1 cnt6 n_279 cnt6_x vdd sky130_fd_pr__pfet_01v8 W=1.4 L=0.15
Xcnt6_p2 cnt6_x n_280 vdd vdd sky130_fd_pr__pfet_01v8 W=1.4 L=0.15
Xcnt6_n1 cnt6 n_279 vss vss sky130_fd_pr__nfet_01v8 W=0.42 L=0.15
Xcnt6_n2 cnt6 n_280 vss vss sky130_fd_pr__nfet_01v8 W=0.42 L=0.15
Xn_282_p1 n_282 cnt6 vdd vdd sky130_fd_pr__pfet_01v8 W=0.7 L=0.15
Xn_282_p2 n_282 n_263 vdd vdd sky130_fd_pr__pfet_01v8 W=0.7 L=0.15
Xn_282_n1 n_282 cnt6 n_282_x vss sky130_fd_pr__nfet_01v8 W=0.84 L=0.15
Xn_282_n2 n_282_x n_263 vss vss sky130_fd_pr__nfet_01v8 W=0.84 L=0.15
Xn_283_n n_283 n_282 vss vss sky130_fd_pr__nfet_01v8 W=0.42 L=0.15
Xn_283_p n_283 n_282 vdd vdd sky130_fd_pr__pfet_01v8 W=0.7 L=0.15
Xn_284_p1 n_284 cnt7 vdd vdd sky130_fd_pr__pfet_01v8 W=0.7 L=0.15
Xn_284_p2 n_284 n_283 vdd vdd sky130_fd_pr__pfet_01v8 W=0.7 L=0.15
Xn_284_n1 n_284 cnt7 n_284_x vss sky130_fd_pr__nfet_01v8 W=0.84 L=0.15
Xn_284_n2 n_284_x n_283 vss vss sky130_fd_pr__nfet_01v8 W=0.84 L=0.15
Xn_285_p1 n_285 cnt7 vdd vdd sky130_fd_pr__pfet_01v8 W=0.7 L=0.15
Xn_285_p2 n_285 n_284 vdd vdd sky130_fd_pr__pfet_01v8 W=0.7 L=0.15
Xn_285_n1 n_285 cnt7 n_285_x vss sky130_fd_pr__nfet_01v8 W=0.84 L=0.15
Xn_285_n2 n_285_x n_284 vss vss sky130_fd_pr__nfet_01v8 W=0.84 L=0.15
Xn_286_p1 n_286 n_283 vdd vdd sky130_fd_pr__pfet_01v8 W=0.7 L=0.15
Xn_286_p2 n_286 n_284 vdd vdd sky130_fd_pr__pfet_01v8 W=0.7 L=0.15
Xn_286_n1 n_286 n_283 n_286_x vss sky130_fd_pr__nfet_01v8 W=0.84 L=0.15
Xn_286_n2 n_286_x n_284 vss vss sky130_fd_pr__nfet_01v8 W=0.84 L=0.15
Xn_287_p1 n_287 n_285 vdd vdd sky130_fd_pr__pfet_01v8 W=0.7 L=0.15
Xn_287_p2 n_287 n_286 vdd vdd sky130_fd_pr__pfet_01v8 W=0.7 L=0.15
Xn_287_n1 n_287 n_285 n_287_x vss sky130_fd_pr__nfet_01v8 W=0.84 L=0.15
Xn_287_n2 n_287_x n_286 vss vss sky130_fd_pr__nfet_01v8 W=0.84 L=0.15
Xn_288_p1 n_288 n_140 vdd vdd sky130_fd_pr__pfet_01v8 W=0.7 L=0.15
Xn_288_p2 n_288 n_287 vdd vdd sky130_fd_pr__pfet_01v8 W=0.7 L=0.15
Xn_288_n1 n_288 n_140 n_288_x vss sky130_fd_pr__nfet_01v8 W=0.84 L=0.15
Xn_288_n2 n_288_x n_287 vss vss sky130_fd_pr__nfet_01v8 W=0.84 L=0.15
Xn_289_n n_289 n_288 vss vss sky130_fd_pr__nfet_01v8 W=0.42 L=0.15
Xn_289_p n_289 n_288 vdd vdd sky130_fd_pr__pfet_01v8 W=0.7 L=0.15
Xn_290_n n_290 n_289 vss vss sky130_fd_pr__nfet_01v8 W=0.42 L=0.15
Xn_290_p n_290 n_289 vdd vdd sky130_fd_pr__pfet_01v8 W=0.7 L=0.15
Xn_291_p1 n_291 n_289 n_291_x vdd sky130_fd_pr__pfet_01v8 W=1.4 L=0.15
Xn_291_p2 n_291_x n_106 vdd vdd sky130_fd_pr__pfet_01v8 W=1.4 L=0.15
Xn_291_n1 n_291 n_289 vss vss sky130_fd_pr__nfet_01v8 W=0.42 L=0.15
Xn_291_n2 n_291 n_106 vss vss sky130_fd_pr__nfet_01v8 W=0.42 L=0.15
Xn_292_p1 n_292 n_291 n_292_x vdd sky130_fd_pr__pfet_01v8 W=1.4 L=0.15
Xn_292_p2 n_292_x n_4 vdd vdd sky130_fd_pr__pfet_01v8 W=1.4 L=0.15
Xn_292_n1 n_292 n_291 vss vss sky130_fd_pr__nfet_01v8 W=0.42 L=0.15
Xn_292_n2 n_292 n_4 vss vss sky130_fd_pr__nfet_01v8 W=0.42 L=0.15
Xn_293_n n_293 n_292 vss vss sky130_fd_pr__nfet_01v8 W=0.42 L=0.15
Xn_293_p n_293 n_292 vdd vdd sky130_fd_pr__pfet_01v8 W=0.7 L=0.15
Xn_296_p1 n_296 n_290 n_296_x vdd sky130_fd_pr__pfet_01v8 W=1.4 L=0.15
Xn_296_p2 n_296_x n_106 vdd vdd sky130_fd_pr__pfet_01v8 W=1.4 L=0.15
Xn_296_n1 n_296 n_290 vss vss sky130_fd_pr__nfet_01v8 W=0.42 L=0.15
Xn_296_n2 n_296 n_106 vss vss sky130_fd_pr__nfet_01v8 W=0.42 L=0.15
Xn_295_p1 n_295 n_296 n_295_x vdd sky130_fd_pr__pfet_01v8 W=1.4 L=0.15
Xn_295_p2 n_295_x n_294 vdd vdd sky130_fd_pr__pfet_01v8 W=1.4 L=0.15
Xn_295_n1 n_295 n_296 vss vss sky130_fd_pr__nfet_01v8 W=0.42 L=0.15
Xn_295_n2 n_295 n_294 vss vss sky130_fd_pr__nfet_01v8 W=0.42 L=0.15
Xn_294_p1 n_294 n_293 n_294_x vdd sky130_fd_pr__pfet_01v8 W=1.4 L=0.15
Xn_294_p2 n_294_x n_295 vdd vdd sky130_fd_pr__pfet_01v8 W=1.4 L=0.15
Xn_294_n1 n_294 n_293 vss vss sky130_fd_pr__nfet_01v8 W=0.42 L=0.15
Xn_294_n2 n_294 n_295 vss vss sky130_fd_pr__nfet_01v8 W=0.42 L=0.15
Xn_297_p1 n_297 n_294 n_297_x vdd sky130_fd_pr__pfet_01v8 W=1.4 L=0.15
Xn_297_p2 n_297_x n_109 vdd vdd sky130_fd_pr__pfet_01v8 W=1.4 L=0.15
Xn_297_n1 n_297 n_294 vss vss sky130_fd_pr__nfet_01v8 W=0.42 L=0.15
Xn_297_n2 n_297 n_109 vss vss sky130_fd_pr__nfet_01v8 W=0.42 L=0.15
Xn_298_p1 n_298 n_297 n_298_x vdd sky130_fd_pr__pfet_01v8 W=1.4 L=0.15
Xn_298_p2 n_298_x n_4 vdd vdd sky130_fd_pr__pfet_01v8 W=1.4 L=0.15
Xn_298_n1 n_298 n_297 vss vss sky130_fd_pr__nfet_01v8 W=0.42 L=0.15
Xn_298_n2 n_298 n_4 vss vss sky130_fd_pr__nfet_01v8 W=0.42 L=0.15
Xn_299_n n_299 n_298 vss vss sky130_fd_pr__nfet_01v8 W=0.42 L=0.15
Xn_299_p n_299 n_298 vdd vdd sky130_fd_pr__pfet_01v8 W=0.7 L=0.15
Xn_301_p1 n_301 n_295 n_301_x vdd sky130_fd_pr__pfet_01v8 W=1.4 L=0.15
Xn_301_p2 n_301_x n_109 vdd vdd sky130_fd_pr__pfet_01v8 W=1.4 L=0.15
Xn_301_n1 n_301 n_295 vss vss sky130_fd_pr__nfet_01v8 W=0.42 L=0.15
Xn_301_n2 n_301 n_109 vss vss sky130_fd_pr__nfet_01v8 W=0.42 L=0.15
Xn_300_p1 n_300 n_301 n_300_x vdd sky130_fd_pr__pfet_01v8 W=1.4 L=0.15
Xn_300_p2 n_300_x cnt7 vdd vdd sky130_fd_pr__pfet_01v8 W=1.4 L=0.15
Xn_300_n1 n_300 n_301 vss vss sky130_fd_pr__nfet_01v8 W=0.42 L=0.15
Xn_300_n2 n_300 cnt7 vss vss sky130_fd_pr__nfet_01v8 W=0.42 L=0.15
Xcnt7_p1 cnt7 n_299 cnt7_x vdd sky130_fd_pr__pfet_01v8 W=1.4 L=0.15
Xcnt7_p2 cnt7_x n_300 vdd vdd sky130_fd_pr__pfet_01v8 W=1.4 L=0.15
Xcnt7_n1 cnt7 n_299 vss vss sky130_fd_pr__nfet_01v8 W=0.42 L=0.15
Xcnt7_n2 cnt7 n_300 vss vss sky130_fd_pr__nfet_01v8 W=0.42 L=0.15
Xn_302_n n_302 n_138 vss vss sky130_fd_pr__nfet_01v8 W=0.42 L=0.15
Xn_302_p n_302 n_138 vdd vdd sky130_fd_pr__pfet_01v8 W=0.7 L=0.15
Xn_303_p1 n_303 s1 vdd vdd sky130_fd_pr__pfet_01v8 W=0.7 L=0.15
Xn_303_p2 n_303 n_302 vdd vdd sky130_fd_pr__pfet_01v8 W=0.7 L=0.15
Xn_303_n1 n_303 s1 n_303_x vss sky130_fd_pr__nfet_01v8 W=0.84 L=0.15
Xn_303_n2 n_303_x n_302 vss vss sky130_fd_pr__nfet_01v8 W=0.84 L=0.15
Xn_304_n n_304 n_303 vss vss sky130_fd_pr__nfet_01v8 W=0.42 L=0.15
Xn_304_p n_304 n_303 vdd vdd sky130_fd_pr__pfet_01v8 W=0.7 L=0.15
Xn_305_n n_305 pw vss vss sky130_fd_pr__nfet_01v8 W=0.42 L=0.15
Xn_305_p n_305 pw vdd vdd sky130_fd_pr__pfet_01v8 W=0.7 L=0.15
Xn_306_p1 n_306 n_304 vdd vdd sky130_fd_pr__pfet_01v8 W=0.7 L=0.15
Xn_306_p2 n_306 n_305 vdd vdd sky130_fd_pr__pfet_01v8 W=0.7 L=0.15
Xn_306_n1 n_306 n_304 n_306_x vss sky130_fd_pr__nfet_01v8 W=0.84 L=0.15
Xn_306_n2 n_306_x n_305 vss vss sky130_fd_pr__nfet_01v8 W=0.84 L=0.15
Xn_307_n n_307 n_306 vss vss sky130_fd_pr__nfet_01v8 W=0.42 L=0.15
Xn_307_p n_307 n_306 vdd vdd sky130_fd_pr__pfet_01v8 W=0.7 L=0.15
Xn_308_n n_308 n_307 vss vss sky130_fd_pr__nfet_01v8 W=0.42 L=0.15
Xn_308_p n_308 n_307 vdd vdd sky130_fd_pr__pfet_01v8 W=0.7 L=0.15
Xn_309_p1 n_309 n_307 n_309_x vdd sky130_fd_pr__pfet_01v8 W=1.4 L=0.15
Xn_309_p2 n_309_x n_106 vdd vdd sky130_fd_pr__pfet_01v8 W=1.4 L=0.15
Xn_309_n1 n_309 n_307 vss vss sky130_fd_pr__nfet_01v8 W=0.42 L=0.15
Xn_309_n2 n_309 n_106 vss vss sky130_fd_pr__nfet_01v8 W=0.42 L=0.15
Xn_310_p1 n_310 n_309 n_310_x vdd sky130_fd_pr__pfet_01v8 W=1.4 L=0.15
Xn_310_p2 n_310_x n_4 vdd vdd sky130_fd_pr__pfet_01v8 W=1.4 L=0.15
Xn_310_n1 n_310 n_309 vss vss sky130_fd_pr__nfet_01v8 W=0.42 L=0.15
Xn_310_n2 n_310 n_4 vss vss sky130_fd_pr__nfet_01v8 W=0.42 L=0.15
Xn_311_n n_311 n_310 vss vss sky130_fd_pr__nfet_01v8 W=0.42 L=0.15
Xn_311_p n_311 n_310 vdd vdd sky130_fd_pr__pfet_01v8 W=0.7 L=0.15
Xn_314_p1 n_314 n_308 n_314_x vdd sky130_fd_pr__pfet_01v8 W=1.4 L=0.15
Xn_314_p2 n_314_x n_106 vdd vdd sky130_fd_pr__pfet_01v8 W=1.4 L=0.15
Xn_314_n1 n_314 n_308 vss vss sky130_fd_pr__nfet_01v8 W=0.42 L=0.15
Xn_314_n2 n_314 n_106 vss vss sky130_fd_pr__nfet_01v8 W=0.42 L=0.15
Xn_313_p1 n_313 n_314 n_313_x vdd sky130_fd_pr__pfet_01v8 W=1.4 L=0.15
Xn_313_p2 n_313_x n_312 vdd vdd sky130_fd_pr__pfet_01v8 W=1.4 L=0.15
Xn_313_n1 n_313 n_314 vss vss sky130_fd_pr__nfet_01v8 W=0.42 L=0.15
Xn_313_n2 n_313 n_312 vss vss sky130_fd_pr__nfet_01v8 W=0.42 L=0.15
Xn_312_p1 n_312 n_311 n_312_x vdd sky130_fd_pr__pfet_01v8 W=1.4 L=0.15
Xn_312_p2 n_312_x n_313 vdd vdd sky130_fd_pr__pfet_01v8 W=1.4 L=0.15
Xn_312_n1 n_312 n_311 vss vss sky130_fd_pr__nfet_01v8 W=0.42 L=0.15
Xn_312_n2 n_312 n_313 vss vss sky130_fd_pr__nfet_01v8 W=0.42 L=0.15
Xn_315_p1 n_315 n_312 n_315_x vdd sky130_fd_pr__pfet_01v8 W=1.4 L=0.15
Xn_315_p2 n_315_x n_109 vdd vdd sky130_fd_pr__pfet_01v8 W=1.4 L=0.15
Xn_315_n1 n_315 n_312 vss vss sky130_fd_pr__nfet_01v8 W=0.42 L=0.15
Xn_315_n2 n_315 n_109 vss vss sky130_fd_pr__nfet_01v8 W=0.42 L=0.15
Xn_316_p1 n_316 n_315 n_316_x vdd sky130_fd_pr__pfet_01v8 W=1.4 L=0.15
Xn_316_p2 n_316_x n_4 vdd vdd sky130_fd_pr__pfet_01v8 W=1.4 L=0.15
Xn_316_n1 n_316 n_315 vss vss sky130_fd_pr__nfet_01v8 W=0.42 L=0.15
Xn_316_n2 n_316 n_4 vss vss sky130_fd_pr__nfet_01v8 W=0.42 L=0.15
Xn_317_n n_317 n_316 vss vss sky130_fd_pr__nfet_01v8 W=0.42 L=0.15
Xn_317_p n_317 n_316 vdd vdd sky130_fd_pr__pfet_01v8 W=0.7 L=0.15
Xn_319_p1 n_319 n_313 n_319_x vdd sky130_fd_pr__pfet_01v8 W=1.4 L=0.15
Xn_319_p2 n_319_x n_109 vdd vdd sky130_fd_pr__pfet_01v8 W=1.4 L=0.15
Xn_319_n1 n_319 n_313 vss vss sky130_fd_pr__nfet_01v8 W=0.42 L=0.15
Xn_319_n2 n_319 n_109 vss vss sky130_fd_pr__nfet_01v8 W=0.42 L=0.15
Xn_318_p1 n_318 n_319 n_318_x vdd sky130_fd_pr__pfet_01v8 W=1.4 L=0.15
Xn_318_p2 n_318_x w vdd vdd sky130_fd_pr__pfet_01v8 W=1.4 L=0.15
Xn_318_n1 n_318 n_319 vss vss sky130_fd_pr__nfet_01v8 W=0.42 L=0.15
Xn_318_n2 n_318 w vss vss sky130_fd_pr__nfet_01v8 W=0.42 L=0.15
Xw_p1 w n_317 w_x vdd sky130_fd_pr__pfet_01v8 W=1.4 L=0.15
Xw_p2 w_x n_318 vdd vdd sky130_fd_pr__pfet_01v8 W=1.4 L=0.15
Xw_n1 w n_317 vss vss sky130_fd_pr__nfet_01v8 W=0.42 L=0.15
Xw_n2 w n_318 vss vss sky130_fd_pr__nfet_01v8 W=0.42 L=0.15
Xn_320_p1 n_320 s1 vdd vdd sky130_fd_pr__pfet_01v8 W=0.7 L=0.15
Xn_320_p2 n_320 n_138 vdd vdd sky130_fd_pr__pfet_01v8 W=0.7 L=0.15
Xn_320_n1 n_320 s1 n_320_x vss sky130_fd_pr__nfet_01v8 W=0.84 L=0.15
Xn_320_n2 n_320_x n_138 vss vss sky130_fd_pr__nfet_01v8 W=0.84 L=0.15
Xn_321_n n_321 n_320 vss vss sky130_fd_pr__nfet_01v8 W=0.42 L=0.15
Xn_321_p n_321 n_320 vdd vdd sky130_fd_pr__pfet_01v8 W=0.7 L=0.15
Xn_322_p1 n_322 pw n_322_x vdd sky130_fd_pr__pfet_01v8 W=1.4 L=0.15
Xn_322_p2 n_322_x n_321 vdd vdd sky130_fd_pr__pfet_01v8 W=1.4 L=0.15
Xn_322_n1 n_322 pw vss vss sky130_fd_pr__nfet_01v8 W=0.42 L=0.15
Xn_322_n2 n_322 n_321 vss vss sky130_fd_pr__nfet_01v8 W=0.42 L=0.15
Xn_323_n n_323 n_322 vss vss sky130_fd_pr__nfet_01v8 W=0.42 L=0.15
Xn_323_p n_323 n_322 vdd vdd sky130_fd_pr__pfet_01v8 W=0.7 L=0.15
Xn_324_n n_324 n_323 vss vss sky130_fd_pr__nfet_01v8 W=0.42 L=0.15
Xn_324_p n_324 n_323 vdd vdd sky130_fd_pr__pfet_01v8 W=0.7 L=0.15
Xn_325_p1 n_325 n_323 n_325_x vdd sky130_fd_pr__pfet_01v8 W=1.4 L=0.15
Xn_325_p2 n_325_x n_106 vdd vdd sky130_fd_pr__pfet_01v8 W=1.4 L=0.15
Xn_325_n1 n_325 n_323 vss vss sky130_fd_pr__nfet_01v8 W=0.42 L=0.15
Xn_325_n2 n_325 n_106 vss vss sky130_fd_pr__nfet_01v8 W=0.42 L=0.15
Xn_326_p1 n_326 n_325 n_326_x vdd sky130_fd_pr__pfet_01v8 W=1.4 L=0.15
Xn_326_p2 n_326_x n_4 vdd vdd sky130_fd_pr__pfet_01v8 W=1.4 L=0.15
Xn_326_n1 n_326 n_325 vss vss sky130_fd_pr__nfet_01v8 W=0.42 L=0.15
Xn_326_n2 n_326 n_4 vss vss sky130_fd_pr__nfet_01v8 W=0.42 L=0.15
Xn_327_n n_327 n_326 vss vss sky130_fd_pr__nfet_01v8 W=0.42 L=0.15
Xn_327_p n_327 n_326 vdd vdd sky130_fd_pr__pfet_01v8 W=0.7 L=0.15
Xn_330_p1 n_330 n_324 n_330_x vdd sky130_fd_pr__pfet_01v8 W=1.4 L=0.15
Xn_330_p2 n_330_x n_106 vdd vdd sky130_fd_pr__pfet_01v8 W=1.4 L=0.15
Xn_330_n1 n_330 n_324 vss vss sky130_fd_pr__nfet_01v8 W=0.42 L=0.15
Xn_330_n2 n_330 n_106 vss vss sky130_fd_pr__nfet_01v8 W=0.42 L=0.15
Xn_329_p1 n_329 n_330 n_329_x vdd sky130_fd_pr__pfet_01v8 W=1.4 L=0.15
Xn_329_p2 n_329_x n_328 vdd vdd sky130_fd_pr__pfet_01v8 W=1.4 L=0.15
Xn_329_n1 n_329 n_330 vss vss sky130_fd_pr__nfet_01v8 W=0.42 L=0.15
Xn_329_n2 n_329 n_328 vss vss sky130_fd_pr__nfet_01v8 W=0.42 L=0.15
Xn_328_p1 n_328 n_327 n_328_x vdd sky130_fd_pr__pfet_01v8 W=1.4 L=0.15
Xn_328_p2 n_328_x n_329 vdd vdd sky130_fd_pr__pfet_01v8 W=1.4 L=0.15
Xn_328_n1 n_328 n_327 vss vss sky130_fd_pr__nfet_01v8 W=0.42 L=0.15
Xn_328_n2 n_328 n_329 vss vss sky130_fd_pr__nfet_01v8 W=0.42 L=0.15
Xn_331_p1 n_331 n_328 n_331_x vdd sky130_fd_pr__pfet_01v8 W=1.4 L=0.15
Xn_331_p2 n_331_x n_109 vdd vdd sky130_fd_pr__pfet_01v8 W=1.4 L=0.15
Xn_331_n1 n_331 n_328 vss vss sky130_fd_pr__nfet_01v8 W=0.42 L=0.15
Xn_331_n2 n_331 n_109 vss vss sky130_fd_pr__nfet_01v8 W=0.42 L=0.15
Xn_332_p1 n_332 n_331 n_332_x vdd sky130_fd_pr__pfet_01v8 W=1.4 L=0.15
Xn_332_p2 n_332_x n_4 vdd vdd sky130_fd_pr__pfet_01v8 W=1.4 L=0.15
Xn_332_n1 n_332 n_331 vss vss sky130_fd_pr__nfet_01v8 W=0.42 L=0.15
Xn_332_n2 n_332 n_4 vss vss sky130_fd_pr__nfet_01v8 W=0.42 L=0.15
Xn_333_n n_333 n_332 vss vss sky130_fd_pr__nfet_01v8 W=0.42 L=0.15
Xn_333_p n_333 n_332 vdd vdd sky130_fd_pr__pfet_01v8 W=0.7 L=0.15
Xn_335_p1 n_335 n_329 n_335_x vdd sky130_fd_pr__pfet_01v8 W=1.4 L=0.15
Xn_335_p2 n_335_x n_109 vdd vdd sky130_fd_pr__pfet_01v8 W=1.4 L=0.15
Xn_335_n1 n_335 n_329 vss vss sky130_fd_pr__nfet_01v8 W=0.42 L=0.15
Xn_335_n2 n_335 n_109 vss vss sky130_fd_pr__nfet_01v8 W=0.42 L=0.15
Xn_334_p1 n_334 n_335 n_334_x vdd sky130_fd_pr__pfet_01v8 W=1.4 L=0.15
Xn_334_p2 n_334_x pw vdd vdd sky130_fd_pr__pfet_01v8 W=1.4 L=0.15
Xn_334_n1 n_334 n_335 vss vss sky130_fd_pr__nfet_01v8 W=0.42 L=0.15
Xn_334_n2 n_334 pw vss vss sky130_fd_pr__nfet_01v8 W=0.42 L=0.15
Xpw_p1 pw n_333 pw_x vdd sky130_fd_pr__pfet_01v8 W=1.4 L=0.15
Xpw_p2 pw_x n_334 vdd vdd sky130_fd_pr__pfet_01v8 W=1.4 L=0.15
Xpw_n1 pw n_333 vss vss sky130_fd_pr__nfet_01v8 W=0.42 L=0.15
Xpw_n2 pw n_334 vss vss sky130_fd_pr__nfet_01v8 W=0.42 L=0.15
Xn_336_p1 n_336 cnt0 n_336_x vdd sky130_fd_pr__pfet_01v8 W=1.4 L=0.15
Xn_336_p2 n_336_x cnt1 vdd vdd sky130_fd_pr__pfet_01v8 W=1.4 L=0.15
Xn_336_n1 n_336 cnt0 vss vss sky130_fd_pr__nfet_01v8 W=0.42 L=0.15
Xn_336_n2 n_336 cnt1 vss vss sky130_fd_pr__nfet_01v8 W=0.42 L=0.15
Xn_337_n n_337 n_336 vss vss sky130_fd_pr__nfet_01v8 W=0.42 L=0.15
Xn_337_p n_337 n_336 vdd vdd sky130_fd_pr__pfet_01v8 W=0.7 L=0.15
Xn_338_p1 n_338 cnt2 n_338_x vdd sky130_fd_pr__pfet_01v8 W=1.4 L=0.15
Xn_338_p2 n_338_x cnt3 vdd vdd sky130_fd_pr__pfet_01v8 W=1.4 L=0.15
Xn_338_n1 n_338 cnt2 vss vss sky130_fd_pr__nfet_01v8 W=0.42 L=0.15
Xn_338_n2 n_338 cnt3 vss vss sky130_fd_pr__nfet_01v8 W=0.42 L=0.15
Xn_339_n n_339 n_338 vss vss sky130_fd_pr__nfet_01v8 W=0.42 L=0.15
Xn_339_p n_339 n_338 vdd vdd sky130_fd_pr__pfet_01v8 W=0.7 L=0.15
Xn_340_p1 n_340 n_337 n_340_x vdd sky130_fd_pr__pfet_01v8 W=1.4 L=0.15
Xn_340_p2 n_340_x n_339 vdd vdd sky130_fd_pr__pfet_01v8 W=1.4 L=0.15
Xn_340_n1 n_340 n_337 vss vss sky130_fd_pr__nfet_01v8 W=0.42 L=0.15
Xn_340_n2 n_340 n_339 vss vss sky130_fd_pr__nfet_01v8 W=0.42 L=0.15
Xn_341_p1 n_341 n_135 n_341_x vdd sky130_fd_pr__pfet_01v8 W=1.4 L=0.15
Xn_341_p2 n_341_x n_340 vdd vdd sky130_fd_pr__pfet_01v8 W=1.4 L=0.15
Xn_341_n1 n_341 n_135 vss vss sky130_fd_pr__nfet_01v8 W=0.42 L=0.15
Xn_341_n2 n_341 n_340 vss vss sky130_fd_pr__nfet_01v8 W=0.42 L=0.15
Xn_342_n n_342 n_341 vss vss sky130_fd_pr__nfet_01v8 W=0.42 L=0.15
Xn_342_p n_342 n_341 vdd vdd sky130_fd_pr__pfet_01v8 W=0.7 L=0.15
Xn_343_p1 n_343 s1 vdd vdd sky130_fd_pr__pfet_01v8 W=0.7 L=0.15
Xn_343_p2 n_343 n_342 vdd vdd sky130_fd_pr__pfet_01v8 W=0.7 L=0.15
Xn_343_n1 n_343 s1 n_343_x vss sky130_fd_pr__nfet_01v8 W=0.84 L=0.15
Xn_343_n2 n_343_x n_342 vss vss sky130_fd_pr__nfet_01v8 W=0.84 L=0.15
Xn_344_n n_344 n_343 vss vss sky130_fd_pr__nfet_01v8 W=0.42 L=0.15
Xn_344_p n_344 n_343 vdd vdd sky130_fd_pr__pfet_01v8 W=0.7 L=0.15
Xn_345_p1 n_345 p_tile vdd vdd sky130_fd_pr__pfet_01v8 W=0.7 L=0.15
Xn_345_p2 n_345 n_344 vdd vdd sky130_fd_pr__pfet_01v8 W=0.7 L=0.15
Xn_345_n1 n_345 p_tile n_345_x vss sky130_fd_pr__nfet_01v8 W=0.84 L=0.15
Xn_345_n2 n_345_x n_344 vss vss sky130_fd_pr__nfet_01v8 W=0.84 L=0.15
Xn_346_p1 n_346 p_tile vdd vdd sky130_fd_pr__pfet_01v8 W=0.7 L=0.15
Xn_346_p2 n_346 n_345 vdd vdd sky130_fd_pr__pfet_01v8 W=0.7 L=0.15
Xn_346_n1 n_346 p_tile n_346_x vss sky130_fd_pr__nfet_01v8 W=0.84 L=0.15
Xn_346_n2 n_346_x n_345 vss vss sky130_fd_pr__nfet_01v8 W=0.84 L=0.15
Xn_347_p1 n_347 n_344 vdd vdd sky130_fd_pr__pfet_01v8 W=0.7 L=0.15
Xn_347_p2 n_347 n_345 vdd vdd sky130_fd_pr__pfet_01v8 W=0.7 L=0.15
Xn_347_n1 n_347 n_344 n_347_x vss sky130_fd_pr__nfet_01v8 W=0.84 L=0.15
Xn_347_n2 n_347_x n_345 vss vss sky130_fd_pr__nfet_01v8 W=0.84 L=0.15
Xn_348_p1 n_348 n_346 vdd vdd sky130_fd_pr__pfet_01v8 W=0.7 L=0.15
Xn_348_p2 n_348 n_347 vdd vdd sky130_fd_pr__pfet_01v8 W=0.7 L=0.15
Xn_348_n1 n_348 n_346 n_348_x vss sky130_fd_pr__nfet_01v8 W=0.84 L=0.15
Xn_348_n2 n_348_x n_347 vss vss sky130_fd_pr__nfet_01v8 W=0.84 L=0.15
Xn_349_n n_349 n_348 vss vss sky130_fd_pr__nfet_01v8 W=0.42 L=0.15
Xn_349_p n_349 n_348 vdd vdd sky130_fd_pr__pfet_01v8 W=0.7 L=0.15
Xn_350_p1 n_350 n_348 n_350_x vdd sky130_fd_pr__pfet_01v8 W=1.4 L=0.15
Xn_350_p2 n_350_x n_106 vdd vdd sky130_fd_pr__pfet_01v8 W=1.4 L=0.15
Xn_350_n1 n_350 n_348 vss vss sky130_fd_pr__nfet_01v8 W=0.42 L=0.15
Xn_350_n2 n_350 n_106 vss vss sky130_fd_pr__nfet_01v8 W=0.42 L=0.15
Xn_351_p1 n_351 n_350 n_351_x vdd sky130_fd_pr__pfet_01v8 W=1.4 L=0.15
Xn_351_p2 n_351_x n_4 vdd vdd sky130_fd_pr__pfet_01v8 W=1.4 L=0.15
Xn_351_n1 n_351 n_350 vss vss sky130_fd_pr__nfet_01v8 W=0.42 L=0.15
Xn_351_n2 n_351 n_4 vss vss sky130_fd_pr__nfet_01v8 W=0.42 L=0.15
Xn_352_n n_352 n_351 vss vss sky130_fd_pr__nfet_01v8 W=0.42 L=0.15
Xn_352_p n_352 n_351 vdd vdd sky130_fd_pr__pfet_01v8 W=0.7 L=0.15
Xn_355_p1 n_355 n_349 n_355_x vdd sky130_fd_pr__pfet_01v8 W=1.4 L=0.15
Xn_355_p2 n_355_x n_106 vdd vdd sky130_fd_pr__pfet_01v8 W=1.4 L=0.15
Xn_355_n1 n_355 n_349 vss vss sky130_fd_pr__nfet_01v8 W=0.42 L=0.15
Xn_355_n2 n_355 n_106 vss vss sky130_fd_pr__nfet_01v8 W=0.42 L=0.15
Xn_354_p1 n_354 n_355 n_354_x vdd sky130_fd_pr__pfet_01v8 W=1.4 L=0.15
Xn_354_p2 n_354_x n_353 vdd vdd sky130_fd_pr__pfet_01v8 W=1.4 L=0.15
Xn_354_n1 n_354 n_355 vss vss sky130_fd_pr__nfet_01v8 W=0.42 L=0.15
Xn_354_n2 n_354 n_353 vss vss sky130_fd_pr__nfet_01v8 W=0.42 L=0.15
Xn_353_p1 n_353 n_352 n_353_x vdd sky130_fd_pr__pfet_01v8 W=1.4 L=0.15
Xn_353_p2 n_353_x n_354 vdd vdd sky130_fd_pr__pfet_01v8 W=1.4 L=0.15
Xn_353_n1 n_353 n_352 vss vss sky130_fd_pr__nfet_01v8 W=0.42 L=0.15
Xn_353_n2 n_353 n_354 vss vss sky130_fd_pr__nfet_01v8 W=0.42 L=0.15
Xn_356_p1 n_356 n_353 n_356_x vdd sky130_fd_pr__pfet_01v8 W=1.4 L=0.15
Xn_356_p2 n_356_x n_109 vdd vdd sky130_fd_pr__pfet_01v8 W=1.4 L=0.15
Xn_356_n1 n_356 n_353 vss vss sky130_fd_pr__nfet_01v8 W=0.42 L=0.15
Xn_356_n2 n_356 n_109 vss vss sky130_fd_pr__nfet_01v8 W=0.42 L=0.15
Xn_357_p1 n_357 n_356 n_357_x vdd sky130_fd_pr__pfet_01v8 W=1.4 L=0.15
Xn_357_p2 n_357_x n_4 vdd vdd sky130_fd_pr__pfet_01v8 W=1.4 L=0.15
Xn_357_n1 n_357 n_356 vss vss sky130_fd_pr__nfet_01v8 W=0.42 L=0.15
Xn_357_n2 n_357 n_4 vss vss sky130_fd_pr__nfet_01v8 W=0.42 L=0.15
Xn_358_n n_358 n_357 vss vss sky130_fd_pr__nfet_01v8 W=0.42 L=0.15
Xn_358_p n_358 n_357 vdd vdd sky130_fd_pr__pfet_01v8 W=0.7 L=0.15
Xn_360_p1 n_360 n_354 n_360_x vdd sky130_fd_pr__pfet_01v8 W=1.4 L=0.15
Xn_360_p2 n_360_x n_109 vdd vdd sky130_fd_pr__pfet_01v8 W=1.4 L=0.15
Xn_360_n1 n_360 n_354 vss vss sky130_fd_pr__nfet_01v8 W=0.42 L=0.15
Xn_360_n2 n_360 n_109 vss vss sky130_fd_pr__nfet_01v8 W=0.42 L=0.15
Xn_359_p1 n_359 n_360 n_359_x vdd sky130_fd_pr__pfet_01v8 W=1.4 L=0.15
Xn_359_p2 n_359_x p_tile vdd vdd sky130_fd_pr__pfet_01v8 W=1.4 L=0.15
Xn_359_n1 n_359 n_360 vss vss sky130_fd_pr__nfet_01v8 W=0.42 L=0.15
Xn_359_n2 n_359 p_tile vss vss sky130_fd_pr__nfet_01v8 W=0.42 L=0.15
Xp_tile_p1 p_tile n_358 p_tile_x vdd sky130_fd_pr__pfet_01v8 W=1.4 L=0.15
Xp_tile_p2 p_tile_x n_359 vdd vdd sky130_fd_pr__pfet_01v8 W=1.4 L=0.15
Xp_tile_n1 p_tile n_358 vss vss sky130_fd_pr__nfet_01v8 W=0.42 L=0.15
Xp_tile_n2 p_tile n_359 vss vss sky130_fd_pr__nfet_01v8 W=0.42 L=0.15
Xn_361_p1 n_361 pw vdd vdd sky130_fd_pr__pfet_01v8 W=0.7 L=0.15
Xn_361_p2 n_361 lora_en vdd vdd sky130_fd_pr__pfet_01v8 W=0.7 L=0.15
Xn_361_n1 n_361 pw n_361_x vss sky130_fd_pr__nfet_01v8 W=0.84 L=0.15
Xn_361_n2 n_361_x lora_en vss vss sky130_fd_pr__nfet_01v8 W=0.84 L=0.15
Xn_362_n n_362 n_361 vss vss sky130_fd_pr__nfet_01v8 W=0.42 L=0.15
Xn_362_p n_362 n_361 vdd vdd sky130_fd_pr__pfet_01v8 W=0.7 L=0.15
Xn_363_n n_363 cnt2 vss vss sky130_fd_pr__nfet_01v8 W=0.42 L=0.15
Xn_363_p n_363 cnt2 vdd vdd sky130_fd_pr__pfet_01v8 W=0.7 L=0.15
Xn_364_n n_364 cnt3 vss vss sky130_fd_pr__nfet_01v8 W=0.42 L=0.15
Xn_364_p n_364 cnt3 vdd vdd sky130_fd_pr__pfet_01v8 W=0.7 L=0.15
Xn_365_n n_365 cnt4 vss vss sky130_fd_pr__nfet_01v8 W=0.42 L=0.15
Xn_365_p n_365 cnt4 vdd vdd sky130_fd_pr__pfet_01v8 W=0.7 L=0.15
Xn_366_n n_366 cnt5 vss vss sky130_fd_pr__nfet_01v8 W=0.42 L=0.15
Xn_366_p n_366 cnt5 vdd vdd sky130_fd_pr__pfet_01v8 W=0.7 L=0.15
Xn_367_n n_367 cnt6 vss vss sky130_fd_pr__nfet_01v8 W=0.42 L=0.15
Xn_367_p n_367 cnt6 vdd vdd sky130_fd_pr__pfet_01v8 W=0.7 L=0.15
Xn_368_p1 n_368 cnt0 vdd vdd sky130_fd_pr__pfet_01v8 W=0.7 L=0.15
Xn_368_p2 n_368 cnt1 vdd vdd sky130_fd_pr__pfet_01v8 W=0.7 L=0.15
Xn_368_n1 n_368 cnt0 n_368_x vss sky130_fd_pr__nfet_01v8 W=0.84 L=0.15
Xn_368_n2 n_368_x cnt1 vss vss sky130_fd_pr__nfet_01v8 W=0.84 L=0.15
Xn_369_n n_369 n_368 vss vss sky130_fd_pr__nfet_01v8 W=0.42 L=0.15
Xn_369_p n_369 n_368 vdd vdd sky130_fd_pr__pfet_01v8 W=0.7 L=0.15
Xn_370_p1 n_370 n_363 vdd vdd sky130_fd_pr__pfet_01v8 W=0.7 L=0.15
Xn_370_p2 n_370 n_364 vdd vdd sky130_fd_pr__pfet_01v8 W=0.7 L=0.15
Xn_370_n1 n_370 n_363 n_370_x vss sky130_fd_pr__nfet_01v8 W=0.84 L=0.15
Xn_370_n2 n_370_x n_364 vss vss sky130_fd_pr__nfet_01v8 W=0.84 L=0.15
Xn_371_n n_371 n_370 vss vss sky130_fd_pr__nfet_01v8 W=0.42 L=0.15
Xn_371_p n_371 n_370 vdd vdd sky130_fd_pr__pfet_01v8 W=0.7 L=0.15
Xn_372_p1 n_372 n_365 vdd vdd sky130_fd_pr__pfet_01v8 W=0.7 L=0.15
Xn_372_p2 n_372 n_366 vdd vdd sky130_fd_pr__pfet_01v8 W=0.7 L=0.15
Xn_372_n1 n_372 n_365 n_372_x vss sky130_fd_pr__nfet_01v8 W=0.84 L=0.15
Xn_372_n2 n_372_x n_366 vss vss sky130_fd_pr__nfet_01v8 W=0.84 L=0.15
Xn_373_n n_373 n_372 vss vss sky130_fd_pr__nfet_01v8 W=0.42 L=0.15
Xn_373_p n_373 n_372 vdd vdd sky130_fd_pr__pfet_01v8 W=0.7 L=0.15
Xn_374_p1 n_374 n_369 vdd vdd sky130_fd_pr__pfet_01v8 W=0.7 L=0.15
Xn_374_p2 n_374 n_371 vdd vdd sky130_fd_pr__pfet_01v8 W=0.7 L=0.15
Xn_374_n1 n_374 n_369 n_374_x vss sky130_fd_pr__nfet_01v8 W=0.84 L=0.15
Xn_374_n2 n_374_x n_371 vss vss sky130_fd_pr__nfet_01v8 W=0.84 L=0.15
Xn_375_n n_375 n_374 vss vss sky130_fd_pr__nfet_01v8 W=0.42 L=0.15
Xn_375_p n_375 n_374 vdd vdd sky130_fd_pr__pfet_01v8 W=0.7 L=0.15
Xn_376_p1 n_376 n_373 vdd vdd sky130_fd_pr__pfet_01v8 W=0.7 L=0.15
Xn_376_p2 n_376 n_367 vdd vdd sky130_fd_pr__pfet_01v8 W=0.7 L=0.15
Xn_376_n1 n_376 n_373 n_376_x vss sky130_fd_pr__nfet_01v8 W=0.84 L=0.15
Xn_376_n2 n_376_x n_367 vss vss sky130_fd_pr__nfet_01v8 W=0.84 L=0.15
Xn_377_n n_377 n_376 vss vss sky130_fd_pr__nfet_01v8 W=0.42 L=0.15
Xn_377_p n_377 n_376 vdd vdd sky130_fd_pr__pfet_01v8 W=0.7 L=0.15
Xn_378_p1 n_378 n_375 vdd vdd sky130_fd_pr__pfet_01v8 W=0.7 L=0.15
Xn_378_p2 n_378 n_377 vdd vdd sky130_fd_pr__pfet_01v8 W=0.7 L=0.15
Xn_378_n1 n_378 n_375 n_378_x vss sky130_fd_pr__nfet_01v8 W=0.84 L=0.15
Xn_378_n2 n_378_x n_377 vss vss sky130_fd_pr__nfet_01v8 W=0.84 L=0.15
Xn_379_n n_379 n_378 vss vss sky130_fd_pr__nfet_01v8 W=0.42 L=0.15
Xn_379_p n_379 n_378 vdd vdd sky130_fd_pr__pfet_01v8 W=0.7 L=0.15
Xn_380_p1 n_380 n_362 vdd vdd sky130_fd_pr__pfet_01v8 W=0.7 L=0.15
Xn_380_p2 n_380 n_379 vdd vdd sky130_fd_pr__pfet_01v8 W=0.7 L=0.15
Xn_380_n1 n_380 n_362 n_380_x vss sky130_fd_pr__nfet_01v8 W=0.84 L=0.15
Xn_380_n2 n_380_x n_379 vss vss sky130_fd_pr__nfet_01v8 W=0.84 L=0.15
Xn_381_n n_381 n_380 vss vss sky130_fd_pr__nfet_01v8 W=0.42 L=0.15
Xn_381_p n_381 n_380 vdd vdd sky130_fd_pr__pfet_01v8 W=0.7 L=0.15
Xn_382_p1 n_382 r_on n_382_x vdd sky130_fd_pr__pfet_01v8 W=1.4 L=0.15
Xn_382_p2 n_382_x n_381 vdd vdd sky130_fd_pr__pfet_01v8 W=1.4 L=0.15
Xn_382_n1 n_382 r_on vss vss sky130_fd_pr__nfet_01v8 W=0.42 L=0.15
Xn_382_n2 n_382 n_381 vss vss sky130_fd_pr__nfet_01v8 W=0.42 L=0.15
Xn_383_n n_383 n_382 vss vss sky130_fd_pr__nfet_01v8 W=0.42 L=0.15
Xn_383_p n_383 n_382 vdd vdd sky130_fd_pr__pfet_01v8 W=0.7 L=0.15
Xn_384_n n_384 n_383 vss vss sky130_fd_pr__nfet_01v8 W=0.42 L=0.15
Xn_384_p n_384 n_383 vdd vdd sky130_fd_pr__pfet_01v8 W=0.7 L=0.15
Xn_385_p1 n_385 n_383 n_385_x vdd sky130_fd_pr__pfet_01v8 W=1.4 L=0.15
Xn_385_p2 n_385_x n_106 vdd vdd sky130_fd_pr__pfet_01v8 W=1.4 L=0.15
Xn_385_n1 n_385 n_383 vss vss sky130_fd_pr__nfet_01v8 W=0.42 L=0.15
Xn_385_n2 n_385 n_106 vss vss sky130_fd_pr__nfet_01v8 W=0.42 L=0.15
Xn_386_p1 n_386 n_385 n_386_x vdd sky130_fd_pr__pfet_01v8 W=1.4 L=0.15
Xn_386_p2 n_386_x n_4 vdd vdd sky130_fd_pr__pfet_01v8 W=1.4 L=0.15
Xn_386_n1 n_386 n_385 vss vss sky130_fd_pr__nfet_01v8 W=0.42 L=0.15
Xn_386_n2 n_386 n_4 vss vss sky130_fd_pr__nfet_01v8 W=0.42 L=0.15
Xn_387_n n_387 n_386 vss vss sky130_fd_pr__nfet_01v8 W=0.42 L=0.15
Xn_387_p n_387 n_386 vdd vdd sky130_fd_pr__pfet_01v8 W=0.7 L=0.15
Xn_390_p1 n_390 n_384 n_390_x vdd sky130_fd_pr__pfet_01v8 W=1.4 L=0.15
Xn_390_p2 n_390_x n_106 vdd vdd sky130_fd_pr__pfet_01v8 W=1.4 L=0.15
Xn_390_n1 n_390 n_384 vss vss sky130_fd_pr__nfet_01v8 W=0.42 L=0.15
Xn_390_n2 n_390 n_106 vss vss sky130_fd_pr__nfet_01v8 W=0.42 L=0.15
Xn_389_p1 n_389 n_390 n_389_x vdd sky130_fd_pr__pfet_01v8 W=1.4 L=0.15
Xn_389_p2 n_389_x n_388 vdd vdd sky130_fd_pr__pfet_01v8 W=1.4 L=0.15
Xn_389_n1 n_389 n_390 vss vss sky130_fd_pr__nfet_01v8 W=0.42 L=0.15
Xn_389_n2 n_389 n_388 vss vss sky130_fd_pr__nfet_01v8 W=0.42 L=0.15
Xn_388_p1 n_388 n_387 n_388_x vdd sky130_fd_pr__pfet_01v8 W=1.4 L=0.15
Xn_388_p2 n_388_x n_389 vdd vdd sky130_fd_pr__pfet_01v8 W=1.4 L=0.15
Xn_388_n1 n_388 n_387 vss vss sky130_fd_pr__nfet_01v8 W=0.42 L=0.15
Xn_388_n2 n_388 n_389 vss vss sky130_fd_pr__nfet_01v8 W=0.42 L=0.15
Xn_391_p1 n_391 n_388 n_391_x vdd sky130_fd_pr__pfet_01v8 W=1.4 L=0.15
Xn_391_p2 n_391_x n_109 vdd vdd sky130_fd_pr__pfet_01v8 W=1.4 L=0.15
Xn_391_n1 n_391 n_388 vss vss sky130_fd_pr__nfet_01v8 W=0.42 L=0.15
Xn_391_n2 n_391 n_109 vss vss sky130_fd_pr__nfet_01v8 W=0.42 L=0.15
Xn_392_p1 n_392 n_391 n_392_x vdd sky130_fd_pr__pfet_01v8 W=1.4 L=0.15
Xn_392_p2 n_392_x n_4 vdd vdd sky130_fd_pr__pfet_01v8 W=1.4 L=0.15
Xn_392_n1 n_392 n_391 vss vss sky130_fd_pr__nfet_01v8 W=0.42 L=0.15
Xn_392_n2 n_392 n_4 vss vss sky130_fd_pr__nfet_01v8 W=0.42 L=0.15
Xn_393_n n_393 n_392 vss vss sky130_fd_pr__nfet_01v8 W=0.42 L=0.15
Xn_393_p n_393 n_392 vdd vdd sky130_fd_pr__pfet_01v8 W=0.7 L=0.15
Xn_395_p1 n_395 n_389 n_395_x vdd sky130_fd_pr__pfet_01v8 W=1.4 L=0.15
Xn_395_p2 n_395_x n_109 vdd vdd sky130_fd_pr__pfet_01v8 W=1.4 L=0.15
Xn_395_n1 n_395 n_389 vss vss sky130_fd_pr__nfet_01v8 W=0.42 L=0.15
Xn_395_n2 n_395 n_109 vss vss sky130_fd_pr__nfet_01v8 W=0.42 L=0.15
Xn_394_p1 n_394 n_395 n_394_x vdd sky130_fd_pr__pfet_01v8 W=1.4 L=0.15
Xn_394_p2 n_394_x r_on vdd vdd sky130_fd_pr__pfet_01v8 W=1.4 L=0.15
Xn_394_n1 n_394 n_395 vss vss sky130_fd_pr__nfet_01v8 W=0.42 L=0.15
Xn_394_n2 n_394 r_on vss vss sky130_fd_pr__nfet_01v8 W=0.42 L=0.15
Xr_on_p1 r_on n_393 r_on_x vdd sky130_fd_pr__pfet_01v8 W=1.4 L=0.15
Xr_on_p2 r_on_x n_394 vdd vdd sky130_fd_pr__pfet_01v8 W=1.4 L=0.15
Xr_on_n1 r_on n_393 vss vss sky130_fd_pr__nfet_01v8 W=0.42 L=0.15
Xr_on_n2 r_on n_394 vss vss sky130_fd_pr__nfet_01v8 W=0.42 L=0.15
Xn_396_n n_396 cnt1 vss vss sky130_fd_pr__nfet_01v8 W=0.42 L=0.15
Xn_396_p n_396 cnt1 vdd vdd sky130_fd_pr__pfet_01v8 W=0.7 L=0.15
Xn_397_n n_397 cnt3 vss vss sky130_fd_pr__nfet_01v8 W=0.42 L=0.15
Xn_397_p n_397 cnt3 vdd vdd sky130_fd_pr__pfet_01v8 W=0.7 L=0.15
Xn_398_n n_398 cnt6 vss vss sky130_fd_pr__nfet_01v8 W=0.42 L=0.15
Xn_398_p n_398 cnt6 vdd vdd sky130_fd_pr__pfet_01v8 W=0.7 L=0.15
Xn_399_p1 n_399 cnt0 vdd vdd sky130_fd_pr__pfet_01v8 W=0.7 L=0.15
Xn_399_p2 n_399 n_396 vdd vdd sky130_fd_pr__pfet_01v8 W=0.7 L=0.15
Xn_399_n1 n_399 cnt0 n_399_x vss sky130_fd_pr__nfet_01v8 W=0.84 L=0.15
Xn_399_n2 n_399_x n_396 vss vss sky130_fd_pr__nfet_01v8 W=0.84 L=0.15
Xn_400_n n_400 n_399 vss vss sky130_fd_pr__nfet_01v8 W=0.42 L=0.15
Xn_400_p n_400 n_399 vdd vdd sky130_fd_pr__pfet_01v8 W=0.7 L=0.15
Xn_401_p1 n_401 cnt2 vdd vdd sky130_fd_pr__pfet_01v8 W=0.7 L=0.15
Xn_401_p2 n_401 n_397 vdd vdd sky130_fd_pr__pfet_01v8 W=0.7 L=0.15
Xn_401_n1 n_401 cnt2 n_401_x vss sky130_fd_pr__nfet_01v8 W=0.84 L=0.15
Xn_401_n2 n_401_x n_397 vss vss sky130_fd_pr__nfet_01v8 W=0.84 L=0.15
Xn_402_n n_402 n_401 vss vss sky130_fd_pr__nfet_01v8 W=0.42 L=0.15
Xn_402_p n_402 n_401 vdd vdd sky130_fd_pr__pfet_01v8 W=0.7 L=0.15
Xn_403_p1 n_403 cnt4 vdd vdd sky130_fd_pr__pfet_01v8 W=0.7 L=0.15
Xn_403_p2 n_403 cnt5 vdd vdd sky130_fd_pr__pfet_01v8 W=0.7 L=0.15
Xn_403_n1 n_403 cnt4 n_403_x vss sky130_fd_pr__nfet_01v8 W=0.84 L=0.15
Xn_403_n2 n_403_x cnt5 vss vss sky130_fd_pr__nfet_01v8 W=0.84 L=0.15
Xn_404_n n_404 n_403 vss vss sky130_fd_pr__nfet_01v8 W=0.42 L=0.15
Xn_404_p n_404 n_403 vdd vdd sky130_fd_pr__pfet_01v8 W=0.7 L=0.15
Xn_405_p1 n_405 n_400 vdd vdd sky130_fd_pr__pfet_01v8 W=0.7 L=0.15
Xn_405_p2 n_405 n_402 vdd vdd sky130_fd_pr__pfet_01v8 W=0.7 L=0.15
Xn_405_n1 n_405 n_400 n_405_x vss sky130_fd_pr__nfet_01v8 W=0.84 L=0.15
Xn_405_n2 n_405_x n_402 vss vss sky130_fd_pr__nfet_01v8 W=0.84 L=0.15
Xn_406_n n_406 n_405 vss vss sky130_fd_pr__nfet_01v8 W=0.42 L=0.15
Xn_406_p n_406 n_405 vdd vdd sky130_fd_pr__pfet_01v8 W=0.7 L=0.15
Xn_407_p1 n_407 n_404 vdd vdd sky130_fd_pr__pfet_01v8 W=0.7 L=0.15
Xn_407_p2 n_407 n_398 vdd vdd sky130_fd_pr__pfet_01v8 W=0.7 L=0.15
Xn_407_n1 n_407 n_404 n_407_x vss sky130_fd_pr__nfet_01v8 W=0.84 L=0.15
Xn_407_n2 n_407_x n_398 vss vss sky130_fd_pr__nfet_01v8 W=0.84 L=0.15
Xn_408_n n_408 n_407 vss vss sky130_fd_pr__nfet_01v8 W=0.42 L=0.15
Xn_408_p n_408 n_407 vdd vdd sky130_fd_pr__pfet_01v8 W=0.7 L=0.15
Xn_409_p1 n_409 n_406 vdd vdd sky130_fd_pr__pfet_01v8 W=0.7 L=0.15
Xn_409_p2 n_409 n_408 vdd vdd sky130_fd_pr__pfet_01v8 W=0.7 L=0.15
Xn_409_n1 n_409 n_406 n_409_x vss sky130_fd_pr__nfet_01v8 W=0.84 L=0.15
Xn_409_n2 n_409_x n_408 vss vss sky130_fd_pr__nfet_01v8 W=0.84 L=0.15
Xn_410_n n_410 n_409 vss vss sky130_fd_pr__nfet_01v8 W=0.42 L=0.15
Xn_410_p n_410 n_409 vdd vdd sky130_fd_pr__pfet_01v8 W=0.7 L=0.15
Xn_411_p1 n_411 pw vdd vdd sky130_fd_pr__pfet_01v8 W=0.7 L=0.15
Xn_411_p2 n_411 n_410 vdd vdd sky130_fd_pr__pfet_01v8 W=0.7 L=0.15
Xn_411_n1 n_411 pw n_411_x vss sky130_fd_pr__nfet_01v8 W=0.84 L=0.15
Xn_411_n2 n_411_x n_410 vss vss sky130_fd_pr__nfet_01v8 W=0.84 L=0.15
Xn_412_n n_412 n_411 vss vss sky130_fd_pr__nfet_01v8 W=0.42 L=0.15
Xn_412_p n_412 n_411 vdd vdd sky130_fd_pr__pfet_01v8 W=0.7 L=0.15
Xn_413_p1 n_413 r_off n_413_x vdd sky130_fd_pr__pfet_01v8 W=1.4 L=0.15
Xn_413_p2 n_413_x n_412 vdd vdd sky130_fd_pr__pfet_01v8 W=1.4 L=0.15
Xn_413_n1 n_413 r_off vss vss sky130_fd_pr__nfet_01v8 W=0.42 L=0.15
Xn_413_n2 n_413 n_412 vss vss sky130_fd_pr__nfet_01v8 W=0.42 L=0.15
Xn_414_n n_414 n_413 vss vss sky130_fd_pr__nfet_01v8 W=0.42 L=0.15
Xn_414_p n_414 n_413 vdd vdd sky130_fd_pr__pfet_01v8 W=0.7 L=0.15
Xn_415_n n_415 n_414 vss vss sky130_fd_pr__nfet_01v8 W=0.42 L=0.15
Xn_415_p n_415 n_414 vdd vdd sky130_fd_pr__pfet_01v8 W=0.7 L=0.15
Xn_416_p1 n_416 n_414 n_416_x vdd sky130_fd_pr__pfet_01v8 W=1.4 L=0.15
Xn_416_p2 n_416_x n_106 vdd vdd sky130_fd_pr__pfet_01v8 W=1.4 L=0.15
Xn_416_n1 n_416 n_414 vss vss sky130_fd_pr__nfet_01v8 W=0.42 L=0.15
Xn_416_n2 n_416 n_106 vss vss sky130_fd_pr__nfet_01v8 W=0.42 L=0.15
Xn_417_p1 n_417 n_416 n_417_x vdd sky130_fd_pr__pfet_01v8 W=1.4 L=0.15
Xn_417_p2 n_417_x n_4 vdd vdd sky130_fd_pr__pfet_01v8 W=1.4 L=0.15
Xn_417_n1 n_417 n_416 vss vss sky130_fd_pr__nfet_01v8 W=0.42 L=0.15
Xn_417_n2 n_417 n_4 vss vss sky130_fd_pr__nfet_01v8 W=0.42 L=0.15
Xn_418_n n_418 n_417 vss vss sky130_fd_pr__nfet_01v8 W=0.42 L=0.15
Xn_418_p n_418 n_417 vdd vdd sky130_fd_pr__pfet_01v8 W=0.7 L=0.15
Xn_421_p1 n_421 n_415 n_421_x vdd sky130_fd_pr__pfet_01v8 W=1.4 L=0.15
Xn_421_p2 n_421_x n_106 vdd vdd sky130_fd_pr__pfet_01v8 W=1.4 L=0.15
Xn_421_n1 n_421 n_415 vss vss sky130_fd_pr__nfet_01v8 W=0.42 L=0.15
Xn_421_n2 n_421 n_106 vss vss sky130_fd_pr__nfet_01v8 W=0.42 L=0.15
Xn_420_p1 n_420 n_421 n_420_x vdd sky130_fd_pr__pfet_01v8 W=1.4 L=0.15
Xn_420_p2 n_420_x n_419 vdd vdd sky130_fd_pr__pfet_01v8 W=1.4 L=0.15
Xn_420_n1 n_420 n_421 vss vss sky130_fd_pr__nfet_01v8 W=0.42 L=0.15
Xn_420_n2 n_420 n_419 vss vss sky130_fd_pr__nfet_01v8 W=0.42 L=0.15
Xn_419_p1 n_419 n_418 n_419_x vdd sky130_fd_pr__pfet_01v8 W=1.4 L=0.15
Xn_419_p2 n_419_x n_420 vdd vdd sky130_fd_pr__pfet_01v8 W=1.4 L=0.15
Xn_419_n1 n_419 n_418 vss vss sky130_fd_pr__nfet_01v8 W=0.42 L=0.15
Xn_419_n2 n_419 n_420 vss vss sky130_fd_pr__nfet_01v8 W=0.42 L=0.15
Xn_422_p1 n_422 n_419 n_422_x vdd sky130_fd_pr__pfet_01v8 W=1.4 L=0.15
Xn_422_p2 n_422_x n_109 vdd vdd sky130_fd_pr__pfet_01v8 W=1.4 L=0.15
Xn_422_n1 n_422 n_419 vss vss sky130_fd_pr__nfet_01v8 W=0.42 L=0.15
Xn_422_n2 n_422 n_109 vss vss sky130_fd_pr__nfet_01v8 W=0.42 L=0.15
Xn_423_p1 n_423 n_422 n_423_x vdd sky130_fd_pr__pfet_01v8 W=1.4 L=0.15
Xn_423_p2 n_423_x n_4 vdd vdd sky130_fd_pr__pfet_01v8 W=1.4 L=0.15
Xn_423_n1 n_423 n_422 vss vss sky130_fd_pr__nfet_01v8 W=0.42 L=0.15
Xn_423_n2 n_423 n_4 vss vss sky130_fd_pr__nfet_01v8 W=0.42 L=0.15
Xn_424_n n_424 n_423 vss vss sky130_fd_pr__nfet_01v8 W=0.42 L=0.15
Xn_424_p n_424 n_423 vdd vdd sky130_fd_pr__pfet_01v8 W=0.7 L=0.15
Xn_426_p1 n_426 n_420 n_426_x vdd sky130_fd_pr__pfet_01v8 W=1.4 L=0.15
Xn_426_p2 n_426_x n_109 vdd vdd sky130_fd_pr__pfet_01v8 W=1.4 L=0.15
Xn_426_n1 n_426 n_420 vss vss sky130_fd_pr__nfet_01v8 W=0.42 L=0.15
Xn_426_n2 n_426 n_109 vss vss sky130_fd_pr__nfet_01v8 W=0.42 L=0.15
Xn_425_p1 n_425 n_426 n_425_x vdd sky130_fd_pr__pfet_01v8 W=1.4 L=0.15
Xn_425_p2 n_425_x r_off vdd vdd sky130_fd_pr__pfet_01v8 W=1.4 L=0.15
Xn_425_n1 n_425 n_426 vss vss sky130_fd_pr__nfet_01v8 W=0.42 L=0.15
Xn_425_n2 n_425 r_off vss vss sky130_fd_pr__nfet_01v8 W=0.42 L=0.15
Xr_off_p1 r_off n_424 r_off_x vdd sky130_fd_pr__pfet_01v8 W=1.4 L=0.15
Xr_off_p2 r_off_x n_425 vdd vdd sky130_fd_pr__pfet_01v8 W=1.4 L=0.15
Xr_off_n1 r_off n_424 vss vss sky130_fd_pr__nfet_01v8 W=0.42 L=0.15
Xr_off_n2 r_off n_425 vss vss sky130_fd_pr__nfet_01v8 W=0.42 L=0.15
Xn_427_n n_427 r_off vss vss sky130_fd_pr__nfet_01v8 W=0.42 L=0.15
Xn_427_p n_427 r_off vdd vdd sky130_fd_pr__pfet_01v8 W=0.7 L=0.15
Xn_428_p1 n_428 r_on vdd vdd sky130_fd_pr__pfet_01v8 W=0.7 L=0.15
Xn_428_p2 n_428 n_427 vdd vdd sky130_fd_pr__pfet_01v8 W=0.7 L=0.15
Xn_428_n1 n_428 r_on n_428_x vss sky130_fd_pr__nfet_01v8 W=0.84 L=0.15
Xn_428_n2 n_428_x n_427 vss vss sky130_fd_pr__nfet_01v8 W=0.84 L=0.15
Xn_429_n n_429 n_428 vss vss sky130_fd_pr__nfet_01v8 W=0.42 L=0.15
Xn_429_p n_429 n_428 vdd vdd sky130_fd_pr__pfet_01v8 W=0.7 L=0.15
Xn_430_n n_430 n_429 vss vss sky130_fd_pr__nfet_01v8 W=0.84 L=0.15
Xn_430_p n_430 n_429 vdd vdd sky130_fd_pr__pfet_01v8 W=1.4 L=0.15
Xramp_en_n ramp_en n_430 vss vss sky130_fd_pr__nfet_01v8 W=1.68 L=0.15
Xramp_en_p ramp_en n_430 vdd vdd sky130_fd_pr__pfet_01v8 W=2.8 L=0.15
Xn_431_n n_431 cnt6 vss vss sky130_fd_pr__nfet_01v8 W=0.42 L=0.15
Xn_431_p n_431 cnt6 vdd vdd sky130_fd_pr__pfet_01v8 W=0.7 L=0.15
Xn_432_p1 n_432 cnt0 vdd vdd sky130_fd_pr__pfet_01v8 W=0.7 L=0.15
Xn_432_p2 n_432 cnt1 vdd vdd sky130_fd_pr__pfet_01v8 W=0.7 L=0.15
Xn_432_n1 n_432 cnt0 n_432_x vss sky130_fd_pr__nfet_01v8 W=0.84 L=0.15
Xn_432_n2 n_432_x cnt1 vss vss sky130_fd_pr__nfet_01v8 W=0.84 L=0.15
Xn_433_n n_433 n_432 vss vss sky130_fd_pr__nfet_01v8 W=0.42 L=0.15
Xn_433_p n_433 n_432 vdd vdd sky130_fd_pr__pfet_01v8 W=0.7 L=0.15
Xn_434_p1 n_434 cnt2 vdd vdd sky130_fd_pr__pfet_01v8 W=0.7 L=0.15
Xn_434_p2 n_434 cnt3 vdd vdd sky130_fd_pr__pfet_01v8 W=0.7 L=0.15
Xn_434_n1 n_434 cnt2 n_434_x vss sky130_fd_pr__nfet_01v8 W=0.84 L=0.15
Xn_434_n2 n_434_x cnt3 vss vss sky130_fd_pr__nfet_01v8 W=0.84 L=0.15
Xn_435_n n_435 n_434 vss vss sky130_fd_pr__nfet_01v8 W=0.42 L=0.15
Xn_435_p n_435 n_434 vdd vdd sky130_fd_pr__pfet_01v8 W=0.7 L=0.15
Xn_436_p1 n_436 cnt4 vdd vdd sky130_fd_pr__pfet_01v8 W=0.7 L=0.15
Xn_436_p2 n_436 cnt5 vdd vdd sky130_fd_pr__pfet_01v8 W=0.7 L=0.15
Xn_436_n1 n_436 cnt4 n_436_x vss sky130_fd_pr__nfet_01v8 W=0.84 L=0.15
Xn_436_n2 n_436_x cnt5 vss vss sky130_fd_pr__nfet_01v8 W=0.84 L=0.15
Xn_437_n n_437 n_436 vss vss sky130_fd_pr__nfet_01v8 W=0.42 L=0.15
Xn_437_p n_437 n_436 vdd vdd sky130_fd_pr__pfet_01v8 W=0.7 L=0.15
Xn_438_p1 n_438 n_433 vdd vdd sky130_fd_pr__pfet_01v8 W=0.7 L=0.15
Xn_438_p2 n_438 n_435 vdd vdd sky130_fd_pr__pfet_01v8 W=0.7 L=0.15
Xn_438_n1 n_438 n_433 n_438_x vss sky130_fd_pr__nfet_01v8 W=0.84 L=0.15
Xn_438_n2 n_438_x n_435 vss vss sky130_fd_pr__nfet_01v8 W=0.84 L=0.15
Xn_439_n n_439 n_438 vss vss sky130_fd_pr__nfet_01v8 W=0.42 L=0.15
Xn_439_p n_439 n_438 vdd vdd sky130_fd_pr__pfet_01v8 W=0.7 L=0.15
Xn_440_p1 n_440 n_437 vdd vdd sky130_fd_pr__pfet_01v8 W=0.7 L=0.15
Xn_440_p2 n_440 n_431 vdd vdd sky130_fd_pr__pfet_01v8 W=0.7 L=0.15
Xn_440_n1 n_440 n_437 n_440_x vss sky130_fd_pr__nfet_01v8 W=0.84 L=0.15
Xn_440_n2 n_440_x n_431 vss vss sky130_fd_pr__nfet_01v8 W=0.84 L=0.15
Xn_441_n n_441 n_440 vss vss sky130_fd_pr__nfet_01v8 W=0.42 L=0.15
Xn_441_p n_441 n_440 vdd vdd sky130_fd_pr__pfet_01v8 W=0.7 L=0.15
Xn_442_p1 n_442 n_439 vdd vdd sky130_fd_pr__pfet_01v8 W=0.7 L=0.15
Xn_442_p2 n_442 n_441 vdd vdd sky130_fd_pr__pfet_01v8 W=0.7 L=0.15
Xn_442_n1 n_442 n_439 n_442_x vss sky130_fd_pr__nfet_01v8 W=0.84 L=0.15
Xn_442_n2 n_442_x n_441 vss vss sky130_fd_pr__nfet_01v8 W=0.84 L=0.15
Xn_443_n n_443 n_442 vss vss sky130_fd_pr__nfet_01v8 W=0.42 L=0.15
Xn_443_p n_443 n_442 vdd vdd sky130_fd_pr__pfet_01v8 W=0.7 L=0.15
Xn_444_n n_444 cnt3 vss vss sky130_fd_pr__nfet_01v8 W=0.42 L=0.15
Xn_444_p n_444 cnt3 vdd vdd sky130_fd_pr__pfet_01v8 W=0.7 L=0.15
Xn_445_n n_445 cnt4 vss vss sky130_fd_pr__nfet_01v8 W=0.42 L=0.15
Xn_445_p n_445 cnt4 vdd vdd sky130_fd_pr__pfet_01v8 W=0.7 L=0.15
Xn_446_n n_446 cnt5 vss vss sky130_fd_pr__nfet_01v8 W=0.42 L=0.15
Xn_446_p n_446 cnt5 vdd vdd sky130_fd_pr__pfet_01v8 W=0.7 L=0.15
Xn_447_n n_447 cnt6 vss vss sky130_fd_pr__nfet_01v8 W=0.42 L=0.15
Xn_447_p n_447 cnt6 vdd vdd sky130_fd_pr__pfet_01v8 W=0.7 L=0.15
Xn_448_p1 n_448 cnt0 vdd vdd sky130_fd_pr__pfet_01v8 W=0.7 L=0.15
Xn_448_p2 n_448 cnt1 vdd vdd sky130_fd_pr__pfet_01v8 W=0.7 L=0.15
Xn_448_n1 n_448 cnt0 n_448_x vss sky130_fd_pr__nfet_01v8 W=0.84 L=0.15
Xn_448_n2 n_448_x cnt1 vss vss sky130_fd_pr__nfet_01v8 W=0.84 L=0.15
Xn_449_n n_449 n_448 vss vss sky130_fd_pr__nfet_01v8 W=0.42 L=0.15
Xn_449_p n_449 n_448 vdd vdd sky130_fd_pr__pfet_01v8 W=0.7 L=0.15
Xn_450_p1 n_450 cnt2 vdd vdd sky130_fd_pr__pfet_01v8 W=0.7 L=0.15
Xn_450_p2 n_450 n_444 vdd vdd sky130_fd_pr__pfet_01v8 W=0.7 L=0.15
Xn_450_n1 n_450 cnt2 n_450_x vss sky130_fd_pr__nfet_01v8 W=0.84 L=0.15
Xn_450_n2 n_450_x n_444 vss vss sky130_fd_pr__nfet_01v8 W=0.84 L=0.15
Xn_451_n n_451 n_450 vss vss sky130_fd_pr__nfet_01v8 W=0.42 L=0.15
Xn_451_p n_451 n_450 vdd vdd sky130_fd_pr__pfet_01v8 W=0.7 L=0.15
Xn_452_p1 n_452 n_445 vdd vdd sky130_fd_pr__pfet_01v8 W=0.7 L=0.15
Xn_452_p2 n_452 n_446 vdd vdd sky130_fd_pr__pfet_01v8 W=0.7 L=0.15
Xn_452_n1 n_452 n_445 n_452_x vss sky130_fd_pr__nfet_01v8 W=0.84 L=0.15
Xn_452_n2 n_452_x n_446 vss vss sky130_fd_pr__nfet_01v8 W=0.84 L=0.15
Xn_453_n n_453 n_452 vss vss sky130_fd_pr__nfet_01v8 W=0.42 L=0.15
Xn_453_p n_453 n_452 vdd vdd sky130_fd_pr__pfet_01v8 W=0.7 L=0.15
Xn_454_p1 n_454 n_449 vdd vdd sky130_fd_pr__pfet_01v8 W=0.7 L=0.15
Xn_454_p2 n_454 n_451 vdd vdd sky130_fd_pr__pfet_01v8 W=0.7 L=0.15
Xn_454_n1 n_454 n_449 n_454_x vss sky130_fd_pr__nfet_01v8 W=0.84 L=0.15
Xn_454_n2 n_454_x n_451 vss vss sky130_fd_pr__nfet_01v8 W=0.84 L=0.15
Xn_455_n n_455 n_454 vss vss sky130_fd_pr__nfet_01v8 W=0.42 L=0.15
Xn_455_p n_455 n_454 vdd vdd sky130_fd_pr__pfet_01v8 W=0.7 L=0.15
Xn_456_p1 n_456 n_453 vdd vdd sky130_fd_pr__pfet_01v8 W=0.7 L=0.15
Xn_456_p2 n_456 n_447 vdd vdd sky130_fd_pr__pfet_01v8 W=0.7 L=0.15
Xn_456_n1 n_456 n_453 n_456_x vss sky130_fd_pr__nfet_01v8 W=0.84 L=0.15
Xn_456_n2 n_456_x n_447 vss vss sky130_fd_pr__nfet_01v8 W=0.84 L=0.15
Xn_457_n n_457 n_456 vss vss sky130_fd_pr__nfet_01v8 W=0.42 L=0.15
Xn_457_p n_457 n_456 vdd vdd sky130_fd_pr__pfet_01v8 W=0.7 L=0.15
Xn_458_p1 n_458 n_455 vdd vdd sky130_fd_pr__pfet_01v8 W=0.7 L=0.15
Xn_458_p2 n_458 n_457 vdd vdd sky130_fd_pr__pfet_01v8 W=0.7 L=0.15
Xn_458_n1 n_458 n_455 n_458_x vss sky130_fd_pr__nfet_01v8 W=0.84 L=0.15
Xn_458_n2 n_458_x n_457 vss vss sky130_fd_pr__nfet_01v8 W=0.84 L=0.15
Xn_459_n n_459 n_458 vss vss sky130_fd_pr__nfet_01v8 W=0.42 L=0.15
Xn_459_p n_459 n_458 vdd vdd sky130_fd_pr__pfet_01v8 W=0.7 L=0.15
Xn_460_n n_460 lora_en vss vss sky130_fd_pr__nfet_01v8 W=0.42 L=0.15
Xn_460_p n_460 lora_en vdd vdd sky130_fd_pr__pfet_01v8 W=0.7 L=0.15
Xn_461_p1 n_461 lora_en vdd vdd sky130_fd_pr__pfet_01v8 W=0.7 L=0.15
Xn_461_p2 n_461 n_443 vdd vdd sky130_fd_pr__pfet_01v8 W=0.7 L=0.15
Xn_461_n1 n_461 lora_en n_461_x vss sky130_fd_pr__nfet_01v8 W=0.84 L=0.15
Xn_461_n2 n_461_x n_443 vss vss sky130_fd_pr__nfet_01v8 W=0.84 L=0.15
Xn_462_p1 n_462 n_460 vdd vdd sky130_fd_pr__pfet_01v8 W=0.7 L=0.15
Xn_462_p2 n_462 n_459 vdd vdd sky130_fd_pr__pfet_01v8 W=0.7 L=0.15
Xn_462_n1 n_462 n_460 n_462_x vss sky130_fd_pr__nfet_01v8 W=0.84 L=0.15
Xn_462_n2 n_462_x n_459 vss vss sky130_fd_pr__nfet_01v8 W=0.84 L=0.15
Xn_463_p1 n_463 n_461 vdd vdd sky130_fd_pr__pfet_01v8 W=0.7 L=0.15
Xn_463_p2 n_463 n_462 vdd vdd sky130_fd_pr__pfet_01v8 W=0.7 L=0.15
Xn_463_n1 n_463 n_461 n_463_x vss sky130_fd_pr__nfet_01v8 W=0.84 L=0.15
Xn_463_n2 n_463_x n_462 vss vss sky130_fd_pr__nfet_01v8 W=0.84 L=0.15
Xn_464_p1 n_464 pw vdd vdd sky130_fd_pr__pfet_01v8 W=0.7 L=0.15
Xn_464_p2 n_464 n_463 vdd vdd sky130_fd_pr__pfet_01v8 W=0.7 L=0.15
Xn_464_n1 n_464 pw n_464_x vss sky130_fd_pr__nfet_01v8 W=0.84 L=0.15
Xn_464_n2 n_464_x n_463 vss vss sky130_fd_pr__nfet_01v8 W=0.84 L=0.15
Xn_465_n n_465 n_464 vss vss sky130_fd_pr__nfet_01v8 W=0.42 L=0.15
Xn_465_p n_465 n_464 vdd vdd sky130_fd_pr__pfet_01v8 W=0.7 L=0.15
Xn_466_p1 n_466 sg n_466_x vdd sky130_fd_pr__pfet_01v8 W=1.4 L=0.15
Xn_466_p2 n_466_x n_465 vdd vdd sky130_fd_pr__pfet_01v8 W=1.4 L=0.15
Xn_466_n1 n_466 sg vss vss sky130_fd_pr__nfet_01v8 W=0.42 L=0.15
Xn_466_n2 n_466 n_465 vss vss sky130_fd_pr__nfet_01v8 W=0.42 L=0.15
Xn_467_n n_467 n_466 vss vss sky130_fd_pr__nfet_01v8 W=0.42 L=0.15
Xn_467_p n_467 n_466 vdd vdd sky130_fd_pr__pfet_01v8 W=0.7 L=0.15
Xn_468_n n_468 n_467 vss vss sky130_fd_pr__nfet_01v8 W=0.42 L=0.15
Xn_468_p n_468 n_467 vdd vdd sky130_fd_pr__pfet_01v8 W=0.7 L=0.15
Xn_469_p1 n_469 n_467 n_469_x vdd sky130_fd_pr__pfet_01v8 W=1.4 L=0.15
Xn_469_p2 n_469_x n_106 vdd vdd sky130_fd_pr__pfet_01v8 W=1.4 L=0.15
Xn_469_n1 n_469 n_467 vss vss sky130_fd_pr__nfet_01v8 W=0.42 L=0.15
Xn_469_n2 n_469 n_106 vss vss sky130_fd_pr__nfet_01v8 W=0.42 L=0.15
Xn_470_p1 n_470 n_469 n_470_x vdd sky130_fd_pr__pfet_01v8 W=1.4 L=0.15
Xn_470_p2 n_470_x n_4 vdd vdd sky130_fd_pr__pfet_01v8 W=1.4 L=0.15
Xn_470_n1 n_470 n_469 vss vss sky130_fd_pr__nfet_01v8 W=0.42 L=0.15
Xn_470_n2 n_470 n_4 vss vss sky130_fd_pr__nfet_01v8 W=0.42 L=0.15
Xn_471_n n_471 n_470 vss vss sky130_fd_pr__nfet_01v8 W=0.42 L=0.15
Xn_471_p n_471 n_470 vdd vdd sky130_fd_pr__pfet_01v8 W=0.7 L=0.15
Xn_474_p1 n_474 n_468 n_474_x vdd sky130_fd_pr__pfet_01v8 W=1.4 L=0.15
Xn_474_p2 n_474_x n_106 vdd vdd sky130_fd_pr__pfet_01v8 W=1.4 L=0.15
Xn_474_n1 n_474 n_468 vss vss sky130_fd_pr__nfet_01v8 W=0.42 L=0.15
Xn_474_n2 n_474 n_106 vss vss sky130_fd_pr__nfet_01v8 W=0.42 L=0.15
Xn_473_p1 n_473 n_474 n_473_x vdd sky130_fd_pr__pfet_01v8 W=1.4 L=0.15
Xn_473_p2 n_473_x n_472 vdd vdd sky130_fd_pr__pfet_01v8 W=1.4 L=0.15
Xn_473_n1 n_473 n_474 vss vss sky130_fd_pr__nfet_01v8 W=0.42 L=0.15
Xn_473_n2 n_473 n_472 vss vss sky130_fd_pr__nfet_01v8 W=0.42 L=0.15
Xn_472_p1 n_472 n_471 n_472_x vdd sky130_fd_pr__pfet_01v8 W=1.4 L=0.15
Xn_472_p2 n_472_x n_473 vdd vdd sky130_fd_pr__pfet_01v8 W=1.4 L=0.15
Xn_472_n1 n_472 n_471 vss vss sky130_fd_pr__nfet_01v8 W=0.42 L=0.15
Xn_472_n2 n_472 n_473 vss vss sky130_fd_pr__nfet_01v8 W=0.42 L=0.15
Xn_475_p1 n_475 n_472 n_475_x vdd sky130_fd_pr__pfet_01v8 W=1.4 L=0.15
Xn_475_p2 n_475_x n_109 vdd vdd sky130_fd_pr__pfet_01v8 W=1.4 L=0.15
Xn_475_n1 n_475 n_472 vss vss sky130_fd_pr__nfet_01v8 W=0.42 L=0.15
Xn_475_n2 n_475 n_109 vss vss sky130_fd_pr__nfet_01v8 W=0.42 L=0.15
Xn_476_p1 n_476 n_475 n_476_x vdd sky130_fd_pr__pfet_01v8 W=1.4 L=0.15
Xn_476_p2 n_476_x n_4 vdd vdd sky130_fd_pr__pfet_01v8 W=1.4 L=0.15
Xn_476_n1 n_476 n_475 vss vss sky130_fd_pr__nfet_01v8 W=0.42 L=0.15
Xn_476_n2 n_476 n_4 vss vss sky130_fd_pr__nfet_01v8 W=0.42 L=0.15
Xn_477_n n_477 n_476 vss vss sky130_fd_pr__nfet_01v8 W=0.42 L=0.15
Xn_477_p n_477 n_476 vdd vdd sky130_fd_pr__pfet_01v8 W=0.7 L=0.15
Xn_479_p1 n_479 n_473 n_479_x vdd sky130_fd_pr__pfet_01v8 W=1.4 L=0.15
Xn_479_p2 n_479_x n_109 vdd vdd sky130_fd_pr__pfet_01v8 W=1.4 L=0.15
Xn_479_n1 n_479 n_473 vss vss sky130_fd_pr__nfet_01v8 W=0.42 L=0.15
Xn_479_n2 n_479 n_109 vss vss sky130_fd_pr__nfet_01v8 W=0.42 L=0.15
Xn_478_p1 n_478 n_479 n_478_x vdd sky130_fd_pr__pfet_01v8 W=1.4 L=0.15
Xn_478_p2 n_478_x sg vdd vdd sky130_fd_pr__pfet_01v8 W=1.4 L=0.15
Xn_478_n1 n_478 n_479 vss vss sky130_fd_pr__nfet_01v8 W=0.42 L=0.15
Xn_478_n2 n_478 sg vss vss sky130_fd_pr__nfet_01v8 W=0.42 L=0.15
Xsg_p1 sg n_477 sg_x vdd sky130_fd_pr__pfet_01v8 W=1.4 L=0.15
Xsg_p2 sg_x n_478 vdd vdd sky130_fd_pr__pfet_01v8 W=1.4 L=0.15
Xsg_n1 sg n_477 vss vss sky130_fd_pr__nfet_01v8 W=0.42 L=0.15
Xsg_n2 sg n_478 vss vss sky130_fd_pr__nfet_01v8 W=0.42 L=0.15
Xn_480_p1 n_480 win_hi vdd vdd sky130_fd_pr__pfet_01v8 W=0.7 L=0.15
Xn_480_p2 n_480 cnt4 vdd vdd sky130_fd_pr__pfet_01v8 W=0.7 L=0.15
Xn_480_n1 n_480 win_hi n_480_x vss sky130_fd_pr__nfet_01v8 W=0.84 L=0.15
Xn_480_n2 n_480_x cnt4 vss vss sky130_fd_pr__nfet_01v8 W=0.84 L=0.15
Xn_481_p1 n_481 n_135 vdd vdd sky130_fd_pr__pfet_01v8 W=0.7 L=0.15
Xn_481_p2 n_481 cnt0 vdd vdd sky130_fd_pr__pfet_01v8 W=0.7 L=0.15
Xn_481_n1 n_481 n_135 n_481_x vss sky130_fd_pr__nfet_01v8 W=0.84 L=0.15
Xn_481_n2 n_481_x cnt0 vss vss sky130_fd_pr__nfet_01v8 W=0.84 L=0.15
Xn_482_p1 n_482 n_480 vdd vdd sky130_fd_pr__pfet_01v8 W=0.7 L=0.15
Xn_482_p2 n_482 n_481 vdd vdd sky130_fd_pr__pfet_01v8 W=0.7 L=0.15
Xn_482_n1 n_482 n_480 n_482_x vss sky130_fd_pr__nfet_01v8 W=0.84 L=0.15
Xn_482_n2 n_482_x n_481 vss vss sky130_fd_pr__nfet_01v8 W=0.84 L=0.15
Xn_483_p1 n_483 win_hi vdd vdd sky130_fd_pr__pfet_01v8 W=0.7 L=0.15
Xn_483_p2 n_483 cnt5 vdd vdd sky130_fd_pr__pfet_01v8 W=0.7 L=0.15
Xn_483_n1 n_483 win_hi n_483_x vss sky130_fd_pr__nfet_01v8 W=0.84 L=0.15
Xn_483_n2 n_483_x cnt5 vss vss sky130_fd_pr__nfet_01v8 W=0.84 L=0.15
Xn_484_p1 n_484 n_135 vdd vdd sky130_fd_pr__pfet_01v8 W=0.7 L=0.15
Xn_484_p2 n_484 cnt1 vdd vdd sky130_fd_pr__pfet_01v8 W=0.7 L=0.15
Xn_484_n1 n_484 n_135 n_484_x vss sky130_fd_pr__nfet_01v8 W=0.84 L=0.15
Xn_484_n2 n_484_x cnt1 vss vss sky130_fd_pr__nfet_01v8 W=0.84 L=0.15
Xn_485_p1 n_485 n_483 vdd vdd sky130_fd_pr__pfet_01v8 W=0.7 L=0.15
Xn_485_p2 n_485 n_484 vdd vdd sky130_fd_pr__pfet_01v8 W=0.7 L=0.15
Xn_485_n1 n_485 n_483 n_485_x vss sky130_fd_pr__nfet_01v8 W=0.84 L=0.15
Xn_485_n2 n_485_x n_484 vss vss sky130_fd_pr__nfet_01v8 W=0.84 L=0.15
Xn_486_p1 n_486 win_hi vdd vdd sky130_fd_pr__pfet_01v8 W=0.7 L=0.15
Xn_486_p2 n_486 cnt6 vdd vdd sky130_fd_pr__pfet_01v8 W=0.7 L=0.15
Xn_486_n1 n_486 win_hi n_486_x vss sky130_fd_pr__nfet_01v8 W=0.84 L=0.15
Xn_486_n2 n_486_x cnt6 vss vss sky130_fd_pr__nfet_01v8 W=0.84 L=0.15
Xn_487_p1 n_487 n_135 vdd vdd sky130_fd_pr__pfet_01v8 W=0.7 L=0.15
Xn_487_p2 n_487 cnt2 vdd vdd sky130_fd_pr__pfet_01v8 W=0.7 L=0.15
Xn_487_n1 n_487 n_135 n_487_x vss sky130_fd_pr__nfet_01v8 W=0.84 L=0.15
Xn_487_n2 n_487_x cnt2 vss vss sky130_fd_pr__nfet_01v8 W=0.84 L=0.15
Xn_488_p1 n_488 n_486 vdd vdd sky130_fd_pr__pfet_01v8 W=0.7 L=0.15
Xn_488_p2 n_488 n_487 vdd vdd sky130_fd_pr__pfet_01v8 W=0.7 L=0.15
Xn_488_n1 n_488 n_486 n_488_x vss sky130_fd_pr__nfet_01v8 W=0.84 L=0.15
Xn_488_n2 n_488_x n_487 vss vss sky130_fd_pr__nfet_01v8 W=0.84 L=0.15
Xn_489_p1 n_489 n_135 vdd vdd sky130_fd_pr__pfet_01v8 W=0.7 L=0.15
Xn_489_p2 n_489 cnt3 vdd vdd sky130_fd_pr__pfet_01v8 W=0.7 L=0.15
Xn_489_n1 n_489 n_135 n_489_x vss sky130_fd_pr__nfet_01v8 W=0.84 L=0.15
Xn_489_n2 n_489_x cnt3 vss vss sky130_fd_pr__nfet_01v8 W=0.84 L=0.15
Xn_490_n n_490 n_489 vss vss sky130_fd_pr__nfet_01v8 W=0.42 L=0.15
Xn_490_p n_490 n_489 vdd vdd sky130_fd_pr__pfet_01v8 W=0.7 L=0.15
Xn_491_n n_491 n_482 vss vss sky130_fd_pr__nfet_01v8 W=0.42 L=0.15
Xn_491_p n_491 n_482 vdd vdd sky130_fd_pr__pfet_01v8 W=0.7 L=0.15
Xn_492_n n_492 n_485 vss vss sky130_fd_pr__nfet_01v8 W=0.42 L=0.15
Xn_492_p n_492 n_485 vdd vdd sky130_fd_pr__pfet_01v8 W=0.7 L=0.15
Xn_493_n n_493 n_488 vss vss sky130_fd_pr__nfet_01v8 W=0.42 L=0.15
Xn_493_p n_493 n_488 vdd vdd sky130_fd_pr__pfet_01v8 W=0.7 L=0.15
Xn_494_n n_494 n_490 vss vss sky130_fd_pr__nfet_01v8 W=0.42 L=0.15
Xn_494_p n_494 n_490 vdd vdd sky130_fd_pr__pfet_01v8 W=0.7 L=0.15
Xn_495_n n_495 n_344 vss vss sky130_fd_pr__nfet_01v8 W=0.42 L=0.15
Xn_495_p n_495 n_344 vdd vdd sky130_fd_pr__pfet_01v8 W=0.7 L=0.15
Xn_496_p1 n_496 n_491 vdd vdd sky130_fd_pr__pfet_01v8 W=0.7 L=0.15
Xn_496_p2 n_496 x_mag0 vdd vdd sky130_fd_pr__pfet_01v8 W=0.7 L=0.15
Xn_496_n1 n_496 n_491 n_496_x vss sky130_fd_pr__nfet_01v8 W=0.84 L=0.15
Xn_496_n2 n_496_x x_mag0 vss vss sky130_fd_pr__nfet_01v8 W=0.84 L=0.15
Xn_497_n n_497 n_496 vss vss sky130_fd_pr__nfet_01v8 W=0.42 L=0.15
Xn_497_p n_497 n_496 vdd vdd sky130_fd_pr__pfet_01v8 W=0.7 L=0.15
Xn_498_p1 n_498 n_492 vdd vdd sky130_fd_pr__pfet_01v8 W=0.7 L=0.15
Xn_498_p2 n_498 x_mag1 vdd vdd sky130_fd_pr__pfet_01v8 W=0.7 L=0.15
Xn_498_n1 n_498 n_492 n_498_x vss sky130_fd_pr__nfet_01v8 W=0.84 L=0.15
Xn_498_n2 n_498_x x_mag1 vss vss sky130_fd_pr__nfet_01v8 W=0.84 L=0.15
Xn_499_p1 n_499 n_492 n_499_x vdd sky130_fd_pr__pfet_01v8 W=1.4 L=0.15
Xn_499_p2 n_499_x x_mag1 vdd vdd sky130_fd_pr__pfet_01v8 W=1.4 L=0.15
Xn_499_n1 n_499 n_492 vss vss sky130_fd_pr__nfet_01v8 W=0.42 L=0.15
Xn_499_n2 n_499 x_mag1 vss vss sky130_fd_pr__nfet_01v8 W=0.42 L=0.15
Xn_500_n n_500 n_499 vss vss sky130_fd_pr__nfet_01v8 W=0.42 L=0.15
Xn_500_p n_500 n_499 vdd vdd sky130_fd_pr__pfet_01v8 W=0.7 L=0.15
Xn_501_p1 n_501 n_497 vdd vdd sky130_fd_pr__pfet_01v8 W=0.7 L=0.15
Xn_501_p2 n_501 n_500 vdd vdd sky130_fd_pr__pfet_01v8 W=0.7 L=0.15
Xn_501_n1 n_501 n_497 n_501_x vss sky130_fd_pr__nfet_01v8 W=0.84 L=0.15
Xn_501_n2 n_501_x n_500 vss vss sky130_fd_pr__nfet_01v8 W=0.84 L=0.15
Xn_502_p1 n_502 n_498 vdd vdd sky130_fd_pr__pfet_01v8 W=0.7 L=0.15
Xn_502_p2 n_502 n_501 vdd vdd sky130_fd_pr__pfet_01v8 W=0.7 L=0.15
Xn_502_n1 n_502 n_498 n_502_x vss sky130_fd_pr__nfet_01v8 W=0.84 L=0.15
Xn_502_n2 n_502_x n_501 vss vss sky130_fd_pr__nfet_01v8 W=0.84 L=0.15
Xn_503_p1 n_503 n_493 vdd vdd sky130_fd_pr__pfet_01v8 W=0.7 L=0.15
Xn_503_p2 n_503 x_mag2 vdd vdd sky130_fd_pr__pfet_01v8 W=0.7 L=0.15
Xn_503_n1 n_503 n_493 n_503_x vss sky130_fd_pr__nfet_01v8 W=0.84 L=0.15
Xn_503_n2 n_503_x x_mag2 vss vss sky130_fd_pr__nfet_01v8 W=0.84 L=0.15
Xn_504_p1 n_504 n_493 n_504_x vdd sky130_fd_pr__pfet_01v8 W=1.4 L=0.15
Xn_504_p2 n_504_x x_mag2 vdd vdd sky130_fd_pr__pfet_01v8 W=1.4 L=0.15
Xn_504_n1 n_504 n_493 vss vss sky130_fd_pr__nfet_01v8 W=0.42 L=0.15
Xn_504_n2 n_504 x_mag2 vss vss sky130_fd_pr__nfet_01v8 W=0.42 L=0.15
Xn_505_n n_505 n_504 vss vss sky130_fd_pr__nfet_01v8 W=0.42 L=0.15
Xn_505_p n_505 n_504 vdd vdd sky130_fd_pr__pfet_01v8 W=0.7 L=0.15
Xn_506_p1 n_506 n_502 vdd vdd sky130_fd_pr__pfet_01v8 W=0.7 L=0.15
Xn_506_p2 n_506 n_505 vdd vdd sky130_fd_pr__pfet_01v8 W=0.7 L=0.15
Xn_506_n1 n_506 n_502 n_506_x vss sky130_fd_pr__nfet_01v8 W=0.84 L=0.15
Xn_506_n2 n_506_x n_505 vss vss sky130_fd_pr__nfet_01v8 W=0.84 L=0.15
Xn_507_p1 n_507 n_503 vdd vdd sky130_fd_pr__pfet_01v8 W=0.7 L=0.15
Xn_507_p2 n_507 n_506 vdd vdd sky130_fd_pr__pfet_01v8 W=0.7 L=0.15
Xn_507_n1 n_507 n_503 n_507_x vss sky130_fd_pr__nfet_01v8 W=0.84 L=0.15
Xn_507_n2 n_507_x n_506 vss vss sky130_fd_pr__nfet_01v8 W=0.84 L=0.15
Xn_508_p1 n_508 n_494 vdd vdd sky130_fd_pr__pfet_01v8 W=0.7 L=0.15
Xn_508_p2 n_508 x_mag3 vdd vdd sky130_fd_pr__pfet_01v8 W=0.7 L=0.15
Xn_508_n1 n_508 n_494 n_508_x vss sky130_fd_pr__nfet_01v8 W=0.84 L=0.15
Xn_508_n2 n_508_x x_mag3 vss vss sky130_fd_pr__nfet_01v8 W=0.84 L=0.15
Xn_509_p1 n_509 n_494 n_509_x vdd sky130_fd_pr__pfet_01v8 W=1.4 L=0.15
Xn_509_p2 n_509_x x_mag3 vdd vdd sky130_fd_pr__pfet_01v8 W=1.4 L=0.15
Xn_509_n1 n_509 n_494 vss vss sky130_fd_pr__nfet_01v8 W=0.42 L=0.15
Xn_509_n2 n_509 x_mag3 vss vss sky130_fd_pr__nfet_01v8 W=0.42 L=0.15
Xn_510_n n_510 n_509 vss vss sky130_fd_pr__nfet_01v8 W=0.42 L=0.15
Xn_510_p n_510 n_509 vdd vdd sky130_fd_pr__pfet_01v8 W=0.7 L=0.15
Xn_511_p1 n_511 n_507 vdd vdd sky130_fd_pr__pfet_01v8 W=0.7 L=0.15
Xn_511_p2 n_511 n_510 vdd vdd sky130_fd_pr__pfet_01v8 W=0.7 L=0.15
Xn_511_n1 n_511 n_507 n_511_x vss sky130_fd_pr__nfet_01v8 W=0.84 L=0.15
Xn_511_n2 n_511_x n_510 vss vss sky130_fd_pr__nfet_01v8 W=0.84 L=0.15
Xn_512_p1 n_512 n_508 vdd vdd sky130_fd_pr__pfet_01v8 W=0.7 L=0.15
Xn_512_p2 n_512 n_511 vdd vdd sky130_fd_pr__pfet_01v8 W=0.7 L=0.15
Xn_512_n1 n_512 n_508 n_512_x vss sky130_fd_pr__nfet_01v8 W=0.84 L=0.15
Xn_512_n2 n_512_x n_511 vss vss sky130_fd_pr__nfet_01v8 W=0.84 L=0.15
Xn_513_p1 n_513 n_307 vdd vdd sky130_fd_pr__pfet_01v8 W=0.7 L=0.15
Xn_513_p2 n_513 n_512 vdd vdd sky130_fd_pr__pfet_01v8 W=0.7 L=0.15
Xn_513_n1 n_513 n_307 n_513_x vss sky130_fd_pr__nfet_01v8 W=0.84 L=0.15
Xn_513_n2 n_513_x n_512 vss vss sky130_fd_pr__nfet_01v8 W=0.84 L=0.15
Xn_514_n n_514 n_513 vss vss sky130_fd_pr__nfet_01v8 W=0.42 L=0.15
Xn_514_p n_514 n_513 vdd vdd sky130_fd_pr__pfet_01v8 W=0.7 L=0.15
Xn_515_p1 n_515 n_344 vdd vdd sky130_fd_pr__pfet_01v8 W=0.7 L=0.15
Xn_515_p2 n_515 n_514 vdd vdd sky130_fd_pr__pfet_01v8 W=0.7 L=0.15
Xn_515_n1 n_515 n_344 n_515_x vss sky130_fd_pr__nfet_01v8 W=0.84 L=0.15
Xn_515_n2 n_515_x n_514 vss vss sky130_fd_pr__nfet_01v8 W=0.84 L=0.15
Xn_516_p1 n_516 n_495 vdd vdd sky130_fd_pr__pfet_01v8 W=0.7 L=0.15
Xn_516_p2 n_516 env0 vdd vdd sky130_fd_pr__pfet_01v8 W=0.7 L=0.15
Xn_516_n1 n_516 n_495 n_516_x vss sky130_fd_pr__nfet_01v8 W=0.84 L=0.15
Xn_516_n2 n_516_x env0 vss vss sky130_fd_pr__nfet_01v8 W=0.84 L=0.15
Xn_517_p1 n_517 n_515 vdd vdd sky130_fd_pr__pfet_01v8 W=0.7 L=0.15
Xn_517_p2 n_517 n_516 vdd vdd sky130_fd_pr__pfet_01v8 W=0.7 L=0.15
Xn_517_n1 n_517 n_515 n_517_x vss sky130_fd_pr__nfet_01v8 W=0.84 L=0.15
Xn_517_n2 n_517_x n_516 vss vss sky130_fd_pr__nfet_01v8 W=0.84 L=0.15
Xn_518_n n_518 n_517 vss vss sky130_fd_pr__nfet_01v8 W=0.42 L=0.15
Xn_518_p n_518 n_517 vdd vdd sky130_fd_pr__pfet_01v8 W=0.7 L=0.15
Xn_519_p1 n_519 n_517 n_519_x vdd sky130_fd_pr__pfet_01v8 W=1.4 L=0.15
Xn_519_p2 n_519_x n_106 vdd vdd sky130_fd_pr__pfet_01v8 W=1.4 L=0.15
Xn_519_n1 n_519 n_517 vss vss sky130_fd_pr__nfet_01v8 W=0.42 L=0.15
Xn_519_n2 n_519 n_106 vss vss sky130_fd_pr__nfet_01v8 W=0.42 L=0.15
Xn_520_p1 n_520 n_519 n_520_x vdd sky130_fd_pr__pfet_01v8 W=1.4 L=0.15
Xn_520_p2 n_520_x n_4 vdd vdd sky130_fd_pr__pfet_01v8 W=1.4 L=0.15
Xn_520_n1 n_520 n_519 vss vss sky130_fd_pr__nfet_01v8 W=0.42 L=0.15
Xn_520_n2 n_520 n_4 vss vss sky130_fd_pr__nfet_01v8 W=0.42 L=0.15
Xn_521_n n_521 n_520 vss vss sky130_fd_pr__nfet_01v8 W=0.42 L=0.15
Xn_521_p n_521 n_520 vdd vdd sky130_fd_pr__pfet_01v8 W=0.7 L=0.15
Xn_524_p1 n_524 n_518 n_524_x vdd sky130_fd_pr__pfet_01v8 W=1.4 L=0.15
Xn_524_p2 n_524_x n_106 vdd vdd sky130_fd_pr__pfet_01v8 W=1.4 L=0.15
Xn_524_n1 n_524 n_518 vss vss sky130_fd_pr__nfet_01v8 W=0.42 L=0.15
Xn_524_n2 n_524 n_106 vss vss sky130_fd_pr__nfet_01v8 W=0.42 L=0.15
Xn_523_p1 n_523 n_524 n_523_x vdd sky130_fd_pr__pfet_01v8 W=1.4 L=0.15
Xn_523_p2 n_523_x n_522 vdd vdd sky130_fd_pr__pfet_01v8 W=1.4 L=0.15
Xn_523_n1 n_523 n_524 vss vss sky130_fd_pr__nfet_01v8 W=0.42 L=0.15
Xn_523_n2 n_523 n_522 vss vss sky130_fd_pr__nfet_01v8 W=0.42 L=0.15
Xn_522_p1 n_522 n_521 n_522_x vdd sky130_fd_pr__pfet_01v8 W=1.4 L=0.15
Xn_522_p2 n_522_x n_523 vdd vdd sky130_fd_pr__pfet_01v8 W=1.4 L=0.15
Xn_522_n1 n_522 n_521 vss vss sky130_fd_pr__nfet_01v8 W=0.42 L=0.15
Xn_522_n2 n_522 n_523 vss vss sky130_fd_pr__nfet_01v8 W=0.42 L=0.15
Xn_525_p1 n_525 n_522 n_525_x vdd sky130_fd_pr__pfet_01v8 W=1.4 L=0.15
Xn_525_p2 n_525_x n_109 vdd vdd sky130_fd_pr__pfet_01v8 W=1.4 L=0.15
Xn_525_n1 n_525 n_522 vss vss sky130_fd_pr__nfet_01v8 W=0.42 L=0.15
Xn_525_n2 n_525 n_109 vss vss sky130_fd_pr__nfet_01v8 W=0.42 L=0.15
Xn_526_p1 n_526 n_525 n_526_x vdd sky130_fd_pr__pfet_01v8 W=1.4 L=0.15
Xn_526_p2 n_526_x n_4 vdd vdd sky130_fd_pr__pfet_01v8 W=1.4 L=0.15
Xn_526_n1 n_526 n_525 vss vss sky130_fd_pr__nfet_01v8 W=0.42 L=0.15
Xn_526_n2 n_526 n_4 vss vss sky130_fd_pr__nfet_01v8 W=0.42 L=0.15
Xn_527_n n_527 n_526 vss vss sky130_fd_pr__nfet_01v8 W=0.42 L=0.15
Xn_527_p n_527 n_526 vdd vdd sky130_fd_pr__pfet_01v8 W=0.7 L=0.15
Xn_529_p1 n_529 n_523 n_529_x vdd sky130_fd_pr__pfet_01v8 W=1.4 L=0.15
Xn_529_p2 n_529_x n_109 vdd vdd sky130_fd_pr__pfet_01v8 W=1.4 L=0.15
Xn_529_n1 n_529 n_523 vss vss sky130_fd_pr__nfet_01v8 W=0.42 L=0.15
Xn_529_n2 n_529 n_109 vss vss sky130_fd_pr__nfet_01v8 W=0.42 L=0.15
Xn_528_p1 n_528 n_529 n_528_x vdd sky130_fd_pr__pfet_01v8 W=1.4 L=0.15
Xn_528_p2 n_528_x env0 vdd vdd sky130_fd_pr__pfet_01v8 W=1.4 L=0.15
Xn_528_n1 n_528 n_529 vss vss sky130_fd_pr__nfet_01v8 W=0.42 L=0.15
Xn_528_n2 n_528 env0 vss vss sky130_fd_pr__nfet_01v8 W=0.42 L=0.15
Xenv0_p1 env0 n_527 env0_x vdd sky130_fd_pr__pfet_01v8 W=1.4 L=0.15
Xenv0_p2 env0_x n_528 vdd vdd sky130_fd_pr__pfet_01v8 W=1.4 L=0.15
Xenv0_n1 env0 n_527 vss vss sky130_fd_pr__nfet_01v8 W=0.42 L=0.15
Xenv0_n2 env0 n_528 vss vss sky130_fd_pr__nfet_01v8 W=0.42 L=0.15
Xn_530_n n_530 env0 vss vss sky130_fd_pr__nfet_01v8 W=0.42 L=0.15
Xn_530_p n_530 env0 vdd vdd sky130_fd_pr__pfet_01v8 W=0.7 L=0.15
Xn_531_p1 n_531 env0 vdd vdd sky130_fd_pr__pfet_01v8 W=0.7 L=0.15
Xn_531_p2 n_531 t_ck vdd vdd sky130_fd_pr__pfet_01v8 W=0.7 L=0.15
Xn_531_n1 n_531 env0 n_531_x vss sky130_fd_pr__nfet_01v8 W=0.84 L=0.15
Xn_531_n2 n_531_x t_ck vss vss sky130_fd_pr__nfet_01v8 W=0.84 L=0.15
Xn_532_n n_532 n_531 vss vss sky130_fd_pr__nfet_01v8 W=0.42 L=0.15
Xn_532_p n_532 n_531 vdd vdd sky130_fd_pr__pfet_01v8 W=0.7 L=0.15
Xn_533_p1 n_533 n_530 vdd vdd sky130_fd_pr__pfet_01v8 W=0.7 L=0.15
Xn_533_p2 n_533 t_ck vdd vdd sky130_fd_pr__pfet_01v8 W=0.7 L=0.15
Xn_533_n1 n_533 n_530 n_533_x vss sky130_fd_pr__nfet_01v8 W=0.84 L=0.15
Xn_533_n2 n_533_x t_ck vss vss sky130_fd_pr__nfet_01v8 W=0.84 L=0.15
Xn_534_n n_534 n_533 vss vss sky130_fd_pr__nfet_01v8 W=0.42 L=0.15
Xn_534_p n_534 n_533 vdd vdd sky130_fd_pr__pfet_01v8 W=0.7 L=0.15
Xn_535_p1 n_535 n_534 n_535_x vdd sky130_fd_pr__pfet_01v8 W=1.4 L=0.15
Xn_535_p2 n_535_x n_4 vdd vdd sky130_fd_pr__pfet_01v8 W=1.4 L=0.15
Xn_535_n1 n_535 n_534 vss vss sky130_fd_pr__nfet_01v8 W=0.42 L=0.15
Xn_535_n2 n_535 n_4 vss vss sky130_fd_pr__nfet_01v8 W=0.42 L=0.15
Xn_536_n n_536 n_535 vss vss sky130_fd_pr__nfet_01v8 W=0.42 L=0.15
Xn_536_p n_536 n_535 vdd vdd sky130_fd_pr__pfet_01v8 W=0.7 L=0.15
Xn_538_p1 n_538 n_532 n_538_x vdd sky130_fd_pr__pfet_01v8 W=1.4 L=0.15
Xn_538_p2 n_538_x n_537 vdd vdd sky130_fd_pr__pfet_01v8 W=1.4 L=0.15
Xn_538_n1 n_538 n_532 vss vss sky130_fd_pr__nfet_01v8 W=0.42 L=0.15
Xn_538_n2 n_538 n_537 vss vss sky130_fd_pr__nfet_01v8 W=0.42 L=0.15
Xn_537_p1 n_537 n_536 n_537_x vdd sky130_fd_pr__pfet_01v8 W=1.4 L=0.15
Xn_537_p2 n_537_x n_538 vdd vdd sky130_fd_pr__pfet_01v8 W=1.4 L=0.15
Xn_537_n1 n_537 n_536 vss vss sky130_fd_pr__nfet_01v8 W=0.42 L=0.15
Xn_537_n2 n_537 n_538 vss vss sky130_fd_pr__nfet_01v8 W=0.42 L=0.15
Xn_539_n n_539 x_neg0 vss vss sky130_fd_pr__nfet_01v8 W=0.42 L=0.15
Xn_539_p n_539 x_neg0 vdd vdd sky130_fd_pr__pfet_01v8 W=0.7 L=0.15
Xn_540_p1 n_540 n_537 vdd vdd sky130_fd_pr__pfet_01v8 W=0.7 L=0.15
Xn_540_p2 n_540 n_539 vdd vdd sky130_fd_pr__pfet_01v8 W=0.7 L=0.15
Xn_540_n1 n_540 n_537 n_540_x vss sky130_fd_pr__nfet_01v8 W=0.84 L=0.15
Xn_540_n2 n_540_x n_539 vss vss sky130_fd_pr__nfet_01v8 W=0.84 L=0.15
Xxin_p_r0_n xin_p_r0 n_540 vss vss sky130_fd_pr__nfet_01v8 W=0.42 L=0.15
Xxin_p_r0_p xin_p_r0 n_540 vdd vdd sky130_fd_pr__pfet_01v8 W=0.7 L=0.15
Xn_541_p1 n_541 n_537 vdd vdd sky130_fd_pr__pfet_01v8 W=0.7 L=0.15
Xn_541_p2 n_541 x_neg0 vdd vdd sky130_fd_pr__pfet_01v8 W=0.7 L=0.15
Xn_541_n1 n_541 n_537 n_541_x vss sky130_fd_pr__nfet_01v8 W=0.84 L=0.15
Xn_541_n2 n_541_x x_neg0 vss vss sky130_fd_pr__nfet_01v8 W=0.84 L=0.15
Xxin_n_r0_n xin_n_r0 n_541 vss vss sky130_fd_pr__nfet_01v8 W=0.42 L=0.15
Xxin_n_r0_p xin_n_r0 n_541 vdd vdd sky130_fd_pr__pfet_01v8 W=0.7 L=0.15
Xn_542_p1 n_542 n_537 vdd vdd sky130_fd_pr__pfet_01v8 W=0.7 L=0.15
Xn_542_p2 n_542 lora_en vdd vdd sky130_fd_pr__pfet_01v8 W=0.7 L=0.15
Xn_542_n1 n_542 n_537 n_542_x vss sky130_fd_pr__nfet_01v8 W=0.84 L=0.15
Xn_542_n2 n_542_x lora_en vss vss sky130_fd_pr__nfet_01v8 W=0.84 L=0.15
Xxrd_en0_n xrd_en0 n_542 vss vss sky130_fd_pr__nfet_01v8 W=0.42 L=0.15
Xxrd_en0_p xrd_en0 n_542 vdd vdd sky130_fd_pr__pfet_01v8 W=0.7 L=0.15
Xn_543_p1 n_543 n_491 vdd vdd sky130_fd_pr__pfet_01v8 W=0.7 L=0.15
Xn_543_p2 n_543 x_mag4 vdd vdd sky130_fd_pr__pfet_01v8 W=0.7 L=0.15
Xn_543_n1 n_543 n_491 n_543_x vss sky130_fd_pr__nfet_01v8 W=0.84 L=0.15
Xn_543_n2 n_543_x x_mag4 vss vss sky130_fd_pr__nfet_01v8 W=0.84 L=0.15
Xn_544_n n_544 n_543 vss vss sky130_fd_pr__nfet_01v8 W=0.42 L=0.15
Xn_544_p n_544 n_543 vdd vdd sky130_fd_pr__pfet_01v8 W=0.7 L=0.15
Xn_545_p1 n_545 n_492 vdd vdd sky130_fd_pr__pfet_01v8 W=0.7 L=0.15
Xn_545_p2 n_545 x_mag5 vdd vdd sky130_fd_pr__pfet_01v8 W=0.7 L=0.15
Xn_545_n1 n_545 n_492 n_545_x vss sky130_fd_pr__nfet_01v8 W=0.84 L=0.15
Xn_545_n2 n_545_x x_mag5 vss vss sky130_fd_pr__nfet_01v8 W=0.84 L=0.15
Xn_546_p1 n_546 n_492 n_546_x vdd sky130_fd_pr__pfet_01v8 W=1.4 L=0.15
Xn_546_p2 n_546_x x_mag5 vdd vdd sky130_fd_pr__pfet_01v8 W=1.4 L=0.15
Xn_546_n1 n_546 n_492 vss vss sky130_fd_pr__nfet_01v8 W=0.42 L=0.15
Xn_546_n2 n_546 x_mag5 vss vss sky130_fd_pr__nfet_01v8 W=0.42 L=0.15
Xn_547_n n_547 n_546 vss vss sky130_fd_pr__nfet_01v8 W=0.42 L=0.15
Xn_547_p n_547 n_546 vdd vdd sky130_fd_pr__pfet_01v8 W=0.7 L=0.15
Xn_548_p1 n_548 n_544 vdd vdd sky130_fd_pr__pfet_01v8 W=0.7 L=0.15
Xn_548_p2 n_548 n_547 vdd vdd sky130_fd_pr__pfet_01v8 W=0.7 L=0.15
Xn_548_n1 n_548 n_544 n_548_x vss sky130_fd_pr__nfet_01v8 W=0.84 L=0.15
Xn_548_n2 n_548_x n_547 vss vss sky130_fd_pr__nfet_01v8 W=0.84 L=0.15
Xn_549_p1 n_549 n_545 vdd vdd sky130_fd_pr__pfet_01v8 W=0.7 L=0.15
Xn_549_p2 n_549 n_548 vdd vdd sky130_fd_pr__pfet_01v8 W=0.7 L=0.15
Xn_549_n1 n_549 n_545 n_549_x vss sky130_fd_pr__nfet_01v8 W=0.84 L=0.15
Xn_549_n2 n_549_x n_548 vss vss sky130_fd_pr__nfet_01v8 W=0.84 L=0.15
Xn_550_p1 n_550 n_493 vdd vdd sky130_fd_pr__pfet_01v8 W=0.7 L=0.15
Xn_550_p2 n_550 x_mag6 vdd vdd sky130_fd_pr__pfet_01v8 W=0.7 L=0.15
Xn_550_n1 n_550 n_493 n_550_x vss sky130_fd_pr__nfet_01v8 W=0.84 L=0.15
Xn_550_n2 n_550_x x_mag6 vss vss sky130_fd_pr__nfet_01v8 W=0.84 L=0.15
Xn_551_p1 n_551 n_493 n_551_x vdd sky130_fd_pr__pfet_01v8 W=1.4 L=0.15
Xn_551_p2 n_551_x x_mag6 vdd vdd sky130_fd_pr__pfet_01v8 W=1.4 L=0.15
Xn_551_n1 n_551 n_493 vss vss sky130_fd_pr__nfet_01v8 W=0.42 L=0.15
Xn_551_n2 n_551 x_mag6 vss vss sky130_fd_pr__nfet_01v8 W=0.42 L=0.15
Xn_552_n n_552 n_551 vss vss sky130_fd_pr__nfet_01v8 W=0.42 L=0.15
Xn_552_p n_552 n_551 vdd vdd sky130_fd_pr__pfet_01v8 W=0.7 L=0.15
Xn_553_p1 n_553 n_549 vdd vdd sky130_fd_pr__pfet_01v8 W=0.7 L=0.15
Xn_553_p2 n_553 n_552 vdd vdd sky130_fd_pr__pfet_01v8 W=0.7 L=0.15
Xn_553_n1 n_553 n_549 n_553_x vss sky130_fd_pr__nfet_01v8 W=0.84 L=0.15
Xn_553_n2 n_553_x n_552 vss vss sky130_fd_pr__nfet_01v8 W=0.84 L=0.15
Xn_554_p1 n_554 n_550 vdd vdd sky130_fd_pr__pfet_01v8 W=0.7 L=0.15
Xn_554_p2 n_554 n_553 vdd vdd sky130_fd_pr__pfet_01v8 W=0.7 L=0.15
Xn_554_n1 n_554 n_550 n_554_x vss sky130_fd_pr__nfet_01v8 W=0.84 L=0.15
Xn_554_n2 n_554_x n_553 vss vss sky130_fd_pr__nfet_01v8 W=0.84 L=0.15
Xn_555_p1 n_555 n_494 vdd vdd sky130_fd_pr__pfet_01v8 W=0.7 L=0.15
Xn_555_p2 n_555 x_mag7 vdd vdd sky130_fd_pr__pfet_01v8 W=0.7 L=0.15
Xn_555_n1 n_555 n_494 n_555_x vss sky130_fd_pr__nfet_01v8 W=0.84 L=0.15
Xn_555_n2 n_555_x x_mag7 vss vss sky130_fd_pr__nfet_01v8 W=0.84 L=0.15
Xn_556_p1 n_556 n_494 n_556_x vdd sky130_fd_pr__pfet_01v8 W=1.4 L=0.15
Xn_556_p2 n_556_x x_mag7 vdd vdd sky130_fd_pr__pfet_01v8 W=1.4 L=0.15
Xn_556_n1 n_556 n_494 vss vss sky130_fd_pr__nfet_01v8 W=0.42 L=0.15
Xn_556_n2 n_556 x_mag7 vss vss sky130_fd_pr__nfet_01v8 W=0.42 L=0.15
Xn_557_n n_557 n_556 vss vss sky130_fd_pr__nfet_01v8 W=0.42 L=0.15
Xn_557_p n_557 n_556 vdd vdd sky130_fd_pr__pfet_01v8 W=0.7 L=0.15
Xn_558_p1 n_558 n_554 vdd vdd sky130_fd_pr__pfet_01v8 W=0.7 L=0.15
Xn_558_p2 n_558 n_557 vdd vdd sky130_fd_pr__pfet_01v8 W=0.7 L=0.15
Xn_558_n1 n_558 n_554 n_558_x vss sky130_fd_pr__nfet_01v8 W=0.84 L=0.15
Xn_558_n2 n_558_x n_557 vss vss sky130_fd_pr__nfet_01v8 W=0.84 L=0.15
Xn_559_p1 n_559 n_555 vdd vdd sky130_fd_pr__pfet_01v8 W=0.7 L=0.15
Xn_559_p2 n_559 n_558 vdd vdd sky130_fd_pr__pfet_01v8 W=0.7 L=0.15
Xn_559_n1 n_559 n_555 n_559_x vss sky130_fd_pr__nfet_01v8 W=0.84 L=0.15
Xn_559_n2 n_559_x n_558 vss vss sky130_fd_pr__nfet_01v8 W=0.84 L=0.15
Xn_560_p1 n_560 n_307 vdd vdd sky130_fd_pr__pfet_01v8 W=0.7 L=0.15
Xn_560_p2 n_560 n_559 vdd vdd sky130_fd_pr__pfet_01v8 W=0.7 L=0.15
Xn_560_n1 n_560 n_307 n_560_x vss sky130_fd_pr__nfet_01v8 W=0.84 L=0.15
Xn_560_n2 n_560_x n_559 vss vss sky130_fd_pr__nfet_01v8 W=0.84 L=0.15
Xn_561_n n_561 n_560 vss vss sky130_fd_pr__nfet_01v8 W=0.42 L=0.15
Xn_561_p n_561 n_560 vdd vdd sky130_fd_pr__pfet_01v8 W=0.7 L=0.15
Xn_562_p1 n_562 n_344 vdd vdd sky130_fd_pr__pfet_01v8 W=0.7 L=0.15
Xn_562_p2 n_562 n_561 vdd vdd sky130_fd_pr__pfet_01v8 W=0.7 L=0.15
Xn_562_n1 n_562 n_344 n_562_x vss sky130_fd_pr__nfet_01v8 W=0.84 L=0.15
Xn_562_n2 n_562_x n_561 vss vss sky130_fd_pr__nfet_01v8 W=0.84 L=0.15
Xn_563_p1 n_563 n_495 vdd vdd sky130_fd_pr__pfet_01v8 W=0.7 L=0.15
Xn_563_p2 n_563 env1 vdd vdd sky130_fd_pr__pfet_01v8 W=0.7 L=0.15
Xn_563_n1 n_563 n_495 n_563_x vss sky130_fd_pr__nfet_01v8 W=0.84 L=0.15
Xn_563_n2 n_563_x env1 vss vss sky130_fd_pr__nfet_01v8 W=0.84 L=0.15
Xn_564_p1 n_564 n_562 vdd vdd sky130_fd_pr__pfet_01v8 W=0.7 L=0.15
Xn_564_p2 n_564 n_563 vdd vdd sky130_fd_pr__pfet_01v8 W=0.7 L=0.15
Xn_564_n1 n_564 n_562 n_564_x vss sky130_fd_pr__nfet_01v8 W=0.84 L=0.15
Xn_564_n2 n_564_x n_563 vss vss sky130_fd_pr__nfet_01v8 W=0.84 L=0.15
Xn_565_n n_565 n_564 vss vss sky130_fd_pr__nfet_01v8 W=0.42 L=0.15
Xn_565_p n_565 n_564 vdd vdd sky130_fd_pr__pfet_01v8 W=0.7 L=0.15
Xn_566_p1 n_566 n_564 n_566_x vdd sky130_fd_pr__pfet_01v8 W=1.4 L=0.15
Xn_566_p2 n_566_x n_106 vdd vdd sky130_fd_pr__pfet_01v8 W=1.4 L=0.15
Xn_566_n1 n_566 n_564 vss vss sky130_fd_pr__nfet_01v8 W=0.42 L=0.15
Xn_566_n2 n_566 n_106 vss vss sky130_fd_pr__nfet_01v8 W=0.42 L=0.15
Xn_567_p1 n_567 n_566 n_567_x vdd sky130_fd_pr__pfet_01v8 W=1.4 L=0.15
Xn_567_p2 n_567_x n_4 vdd vdd sky130_fd_pr__pfet_01v8 W=1.4 L=0.15
Xn_567_n1 n_567 n_566 vss vss sky130_fd_pr__nfet_01v8 W=0.42 L=0.15
Xn_567_n2 n_567 n_4 vss vss sky130_fd_pr__nfet_01v8 W=0.42 L=0.15
Xn_568_n n_568 n_567 vss vss sky130_fd_pr__nfet_01v8 W=0.42 L=0.15
Xn_568_p n_568 n_567 vdd vdd sky130_fd_pr__pfet_01v8 W=0.7 L=0.15
Xn_571_p1 n_571 n_565 n_571_x vdd sky130_fd_pr__pfet_01v8 W=1.4 L=0.15
Xn_571_p2 n_571_x n_106 vdd vdd sky130_fd_pr__pfet_01v8 W=1.4 L=0.15
Xn_571_n1 n_571 n_565 vss vss sky130_fd_pr__nfet_01v8 W=0.42 L=0.15
Xn_571_n2 n_571 n_106 vss vss sky130_fd_pr__nfet_01v8 W=0.42 L=0.15
Xn_570_p1 n_570 n_571 n_570_x vdd sky130_fd_pr__pfet_01v8 W=1.4 L=0.15
Xn_570_p2 n_570_x n_569 vdd vdd sky130_fd_pr__pfet_01v8 W=1.4 L=0.15
Xn_570_n1 n_570 n_571 vss vss sky130_fd_pr__nfet_01v8 W=0.42 L=0.15
Xn_570_n2 n_570 n_569 vss vss sky130_fd_pr__nfet_01v8 W=0.42 L=0.15
Xn_569_p1 n_569 n_568 n_569_x vdd sky130_fd_pr__pfet_01v8 W=1.4 L=0.15
Xn_569_p2 n_569_x n_570 vdd vdd sky130_fd_pr__pfet_01v8 W=1.4 L=0.15
Xn_569_n1 n_569 n_568 vss vss sky130_fd_pr__nfet_01v8 W=0.42 L=0.15
Xn_569_n2 n_569 n_570 vss vss sky130_fd_pr__nfet_01v8 W=0.42 L=0.15
Xn_572_p1 n_572 n_569 n_572_x vdd sky130_fd_pr__pfet_01v8 W=1.4 L=0.15
Xn_572_p2 n_572_x n_109 vdd vdd sky130_fd_pr__pfet_01v8 W=1.4 L=0.15
Xn_572_n1 n_572 n_569 vss vss sky130_fd_pr__nfet_01v8 W=0.42 L=0.15
Xn_572_n2 n_572 n_109 vss vss sky130_fd_pr__nfet_01v8 W=0.42 L=0.15
Xn_573_p1 n_573 n_572 n_573_x vdd sky130_fd_pr__pfet_01v8 W=1.4 L=0.15
Xn_573_p2 n_573_x n_4 vdd vdd sky130_fd_pr__pfet_01v8 W=1.4 L=0.15
Xn_573_n1 n_573 n_572 vss vss sky130_fd_pr__nfet_01v8 W=0.42 L=0.15
Xn_573_n2 n_573 n_4 vss vss sky130_fd_pr__nfet_01v8 W=0.42 L=0.15
Xn_574_n n_574 n_573 vss vss sky130_fd_pr__nfet_01v8 W=0.42 L=0.15
Xn_574_p n_574 n_573 vdd vdd sky130_fd_pr__pfet_01v8 W=0.7 L=0.15
Xn_576_p1 n_576 n_570 n_576_x vdd sky130_fd_pr__pfet_01v8 W=1.4 L=0.15
Xn_576_p2 n_576_x n_109 vdd vdd sky130_fd_pr__pfet_01v8 W=1.4 L=0.15
Xn_576_n1 n_576 n_570 vss vss sky130_fd_pr__nfet_01v8 W=0.42 L=0.15
Xn_576_n2 n_576 n_109 vss vss sky130_fd_pr__nfet_01v8 W=0.42 L=0.15
Xn_575_p1 n_575 n_576 n_575_x vdd sky130_fd_pr__pfet_01v8 W=1.4 L=0.15
Xn_575_p2 n_575_x env1 vdd vdd sky130_fd_pr__pfet_01v8 W=1.4 L=0.15
Xn_575_n1 n_575 n_576 vss vss sky130_fd_pr__nfet_01v8 W=0.42 L=0.15
Xn_575_n2 n_575 env1 vss vss sky130_fd_pr__nfet_01v8 W=0.42 L=0.15
Xenv1_p1 env1 n_574 env1_x vdd sky130_fd_pr__pfet_01v8 W=1.4 L=0.15
Xenv1_p2 env1_x n_575 vdd vdd sky130_fd_pr__pfet_01v8 W=1.4 L=0.15
Xenv1_n1 env1 n_574 vss vss sky130_fd_pr__nfet_01v8 W=0.42 L=0.15
Xenv1_n2 env1 n_575 vss vss sky130_fd_pr__nfet_01v8 W=0.42 L=0.15
Xn_577_n n_577 env1 vss vss sky130_fd_pr__nfet_01v8 W=0.42 L=0.15
Xn_577_p n_577 env1 vdd vdd sky130_fd_pr__pfet_01v8 W=0.7 L=0.15
Xn_578_p1 n_578 env1 vdd vdd sky130_fd_pr__pfet_01v8 W=0.7 L=0.15
Xn_578_p2 n_578 t_ck vdd vdd sky130_fd_pr__pfet_01v8 W=0.7 L=0.15
Xn_578_n1 n_578 env1 n_578_x vss sky130_fd_pr__nfet_01v8 W=0.84 L=0.15
Xn_578_n2 n_578_x t_ck vss vss sky130_fd_pr__nfet_01v8 W=0.84 L=0.15
Xn_579_n n_579 n_578 vss vss sky130_fd_pr__nfet_01v8 W=0.42 L=0.15
Xn_579_p n_579 n_578 vdd vdd sky130_fd_pr__pfet_01v8 W=0.7 L=0.15
Xn_580_p1 n_580 n_577 vdd vdd sky130_fd_pr__pfet_01v8 W=0.7 L=0.15
Xn_580_p2 n_580 t_ck vdd vdd sky130_fd_pr__pfet_01v8 W=0.7 L=0.15
Xn_580_n1 n_580 n_577 n_580_x vss sky130_fd_pr__nfet_01v8 W=0.84 L=0.15
Xn_580_n2 n_580_x t_ck vss vss sky130_fd_pr__nfet_01v8 W=0.84 L=0.15
Xn_581_n n_581 n_580 vss vss sky130_fd_pr__nfet_01v8 W=0.42 L=0.15
Xn_581_p n_581 n_580 vdd vdd sky130_fd_pr__pfet_01v8 W=0.7 L=0.15
Xn_582_p1 n_582 n_581 n_582_x vdd sky130_fd_pr__pfet_01v8 W=1.4 L=0.15
Xn_582_p2 n_582_x n_4 vdd vdd sky130_fd_pr__pfet_01v8 W=1.4 L=0.15
Xn_582_n1 n_582 n_581 vss vss sky130_fd_pr__nfet_01v8 W=0.42 L=0.15
Xn_582_n2 n_582 n_4 vss vss sky130_fd_pr__nfet_01v8 W=0.42 L=0.15
Xn_583_n n_583 n_582 vss vss sky130_fd_pr__nfet_01v8 W=0.42 L=0.15
Xn_583_p n_583 n_582 vdd vdd sky130_fd_pr__pfet_01v8 W=0.7 L=0.15
Xn_585_p1 n_585 n_579 n_585_x vdd sky130_fd_pr__pfet_01v8 W=1.4 L=0.15
Xn_585_p2 n_585_x n_584 vdd vdd sky130_fd_pr__pfet_01v8 W=1.4 L=0.15
Xn_585_n1 n_585 n_579 vss vss sky130_fd_pr__nfet_01v8 W=0.42 L=0.15
Xn_585_n2 n_585 n_584 vss vss sky130_fd_pr__nfet_01v8 W=0.42 L=0.15
Xn_584_p1 n_584 n_583 n_584_x vdd sky130_fd_pr__pfet_01v8 W=1.4 L=0.15
Xn_584_p2 n_584_x n_585 vdd vdd sky130_fd_pr__pfet_01v8 W=1.4 L=0.15
Xn_584_n1 n_584 n_583 vss vss sky130_fd_pr__nfet_01v8 W=0.42 L=0.15
Xn_584_n2 n_584 n_585 vss vss sky130_fd_pr__nfet_01v8 W=0.42 L=0.15
Xn_586_n n_586 x_neg1 vss vss sky130_fd_pr__nfet_01v8 W=0.42 L=0.15
Xn_586_p n_586 x_neg1 vdd vdd sky130_fd_pr__pfet_01v8 W=0.7 L=0.15
Xn_587_p1 n_587 n_584 vdd vdd sky130_fd_pr__pfet_01v8 W=0.7 L=0.15
Xn_587_p2 n_587 n_586 vdd vdd sky130_fd_pr__pfet_01v8 W=0.7 L=0.15
Xn_587_n1 n_587 n_584 n_587_x vss sky130_fd_pr__nfet_01v8 W=0.84 L=0.15
Xn_587_n2 n_587_x n_586 vss vss sky130_fd_pr__nfet_01v8 W=0.84 L=0.15
Xxin_p_r1_n xin_p_r1 n_587 vss vss sky130_fd_pr__nfet_01v8 W=0.42 L=0.15
Xxin_p_r1_p xin_p_r1 n_587 vdd vdd sky130_fd_pr__pfet_01v8 W=0.7 L=0.15
Xn_588_p1 n_588 n_584 vdd vdd sky130_fd_pr__pfet_01v8 W=0.7 L=0.15
Xn_588_p2 n_588 x_neg1 vdd vdd sky130_fd_pr__pfet_01v8 W=0.7 L=0.15
Xn_588_n1 n_588 n_584 n_588_x vss sky130_fd_pr__nfet_01v8 W=0.84 L=0.15
Xn_588_n2 n_588_x x_neg1 vss vss sky130_fd_pr__nfet_01v8 W=0.84 L=0.15
Xxin_n_r1_n xin_n_r1 n_588 vss vss sky130_fd_pr__nfet_01v8 W=0.42 L=0.15
Xxin_n_r1_p xin_n_r1 n_588 vdd vdd sky130_fd_pr__pfet_01v8 W=0.7 L=0.15
Xn_589_p1 n_589 n_584 vdd vdd sky130_fd_pr__pfet_01v8 W=0.7 L=0.15
Xn_589_p2 n_589 lora_en vdd vdd sky130_fd_pr__pfet_01v8 W=0.7 L=0.15
Xn_589_n1 n_589 n_584 n_589_x vss sky130_fd_pr__nfet_01v8 W=0.84 L=0.15
Xn_589_n2 n_589_x lora_en vss vss sky130_fd_pr__nfet_01v8 W=0.84 L=0.15
Xxrd_en1_n xrd_en1 n_589 vss vss sky130_fd_pr__nfet_01v8 W=0.42 L=0.15
Xxrd_en1_p xrd_en1 n_589 vdd vdd sky130_fd_pr__pfet_01v8 W=0.7 L=0.15
Xn_590_p1 n_590 n_491 vdd vdd sky130_fd_pr__pfet_01v8 W=0.7 L=0.15
Xn_590_p2 n_590 x_mag8 vdd vdd sky130_fd_pr__pfet_01v8 W=0.7 L=0.15
Xn_590_n1 n_590 n_491 n_590_x vss sky130_fd_pr__nfet_01v8 W=0.84 L=0.15
Xn_590_n2 n_590_x x_mag8 vss vss sky130_fd_pr__nfet_01v8 W=0.84 L=0.15
Xn_591_n n_591 n_590 vss vss sky130_fd_pr__nfet_01v8 W=0.42 L=0.15
Xn_591_p n_591 n_590 vdd vdd sky130_fd_pr__pfet_01v8 W=0.7 L=0.15
Xn_592_p1 n_592 n_492 vdd vdd sky130_fd_pr__pfet_01v8 W=0.7 L=0.15
Xn_592_p2 n_592 x_mag9 vdd vdd sky130_fd_pr__pfet_01v8 W=0.7 L=0.15
Xn_592_n1 n_592 n_492 n_592_x vss sky130_fd_pr__nfet_01v8 W=0.84 L=0.15
Xn_592_n2 n_592_x x_mag9 vss vss sky130_fd_pr__nfet_01v8 W=0.84 L=0.15
Xn_593_p1 n_593 n_492 n_593_x vdd sky130_fd_pr__pfet_01v8 W=1.4 L=0.15
Xn_593_p2 n_593_x x_mag9 vdd vdd sky130_fd_pr__pfet_01v8 W=1.4 L=0.15
Xn_593_n1 n_593 n_492 vss vss sky130_fd_pr__nfet_01v8 W=0.42 L=0.15
Xn_593_n2 n_593 x_mag9 vss vss sky130_fd_pr__nfet_01v8 W=0.42 L=0.15
Xn_594_n n_594 n_593 vss vss sky130_fd_pr__nfet_01v8 W=0.42 L=0.15
Xn_594_p n_594 n_593 vdd vdd sky130_fd_pr__pfet_01v8 W=0.7 L=0.15
Xn_595_p1 n_595 n_591 vdd vdd sky130_fd_pr__pfet_01v8 W=0.7 L=0.15
Xn_595_p2 n_595 n_594 vdd vdd sky130_fd_pr__pfet_01v8 W=0.7 L=0.15
Xn_595_n1 n_595 n_591 n_595_x vss sky130_fd_pr__nfet_01v8 W=0.84 L=0.15
Xn_595_n2 n_595_x n_594 vss vss sky130_fd_pr__nfet_01v8 W=0.84 L=0.15
Xn_596_p1 n_596 n_592 vdd vdd sky130_fd_pr__pfet_01v8 W=0.7 L=0.15
Xn_596_p2 n_596 n_595 vdd vdd sky130_fd_pr__pfet_01v8 W=0.7 L=0.15
Xn_596_n1 n_596 n_592 n_596_x vss sky130_fd_pr__nfet_01v8 W=0.84 L=0.15
Xn_596_n2 n_596_x n_595 vss vss sky130_fd_pr__nfet_01v8 W=0.84 L=0.15
Xn_597_p1 n_597 n_493 vdd vdd sky130_fd_pr__pfet_01v8 W=0.7 L=0.15
Xn_597_p2 n_597 x_mag10 vdd vdd sky130_fd_pr__pfet_01v8 W=0.7 L=0.15
Xn_597_n1 n_597 n_493 n_597_x vss sky130_fd_pr__nfet_01v8 W=0.84 L=0.15
Xn_597_n2 n_597_x x_mag10 vss vss sky130_fd_pr__nfet_01v8 W=0.84 L=0.15
Xn_598_p1 n_598 n_493 n_598_x vdd sky130_fd_pr__pfet_01v8 W=1.4 L=0.15
Xn_598_p2 n_598_x x_mag10 vdd vdd sky130_fd_pr__pfet_01v8 W=1.4 L=0.15
Xn_598_n1 n_598 n_493 vss vss sky130_fd_pr__nfet_01v8 W=0.42 L=0.15
Xn_598_n2 n_598 x_mag10 vss vss sky130_fd_pr__nfet_01v8 W=0.42 L=0.15
Xn_599_n n_599 n_598 vss vss sky130_fd_pr__nfet_01v8 W=0.42 L=0.15
Xn_599_p n_599 n_598 vdd vdd sky130_fd_pr__pfet_01v8 W=0.7 L=0.15
Xn_600_p1 n_600 n_596 vdd vdd sky130_fd_pr__pfet_01v8 W=0.7 L=0.15
Xn_600_p2 n_600 n_599 vdd vdd sky130_fd_pr__pfet_01v8 W=0.7 L=0.15
Xn_600_n1 n_600 n_596 n_600_x vss sky130_fd_pr__nfet_01v8 W=0.84 L=0.15
Xn_600_n2 n_600_x n_599 vss vss sky130_fd_pr__nfet_01v8 W=0.84 L=0.15
Xn_601_p1 n_601 n_597 vdd vdd sky130_fd_pr__pfet_01v8 W=0.7 L=0.15
Xn_601_p2 n_601 n_600 vdd vdd sky130_fd_pr__pfet_01v8 W=0.7 L=0.15
Xn_601_n1 n_601 n_597 n_601_x vss sky130_fd_pr__nfet_01v8 W=0.84 L=0.15
Xn_601_n2 n_601_x n_600 vss vss sky130_fd_pr__nfet_01v8 W=0.84 L=0.15
Xn_602_p1 n_602 n_494 vdd vdd sky130_fd_pr__pfet_01v8 W=0.7 L=0.15
Xn_602_p2 n_602 x_mag11 vdd vdd sky130_fd_pr__pfet_01v8 W=0.7 L=0.15
Xn_602_n1 n_602 n_494 n_602_x vss sky130_fd_pr__nfet_01v8 W=0.84 L=0.15
Xn_602_n2 n_602_x x_mag11 vss vss sky130_fd_pr__nfet_01v8 W=0.84 L=0.15
Xn_603_p1 n_603 n_494 n_603_x vdd sky130_fd_pr__pfet_01v8 W=1.4 L=0.15
Xn_603_p2 n_603_x x_mag11 vdd vdd sky130_fd_pr__pfet_01v8 W=1.4 L=0.15
Xn_603_n1 n_603 n_494 vss vss sky130_fd_pr__nfet_01v8 W=0.42 L=0.15
Xn_603_n2 n_603 x_mag11 vss vss sky130_fd_pr__nfet_01v8 W=0.42 L=0.15
Xn_604_n n_604 n_603 vss vss sky130_fd_pr__nfet_01v8 W=0.42 L=0.15
Xn_604_p n_604 n_603 vdd vdd sky130_fd_pr__pfet_01v8 W=0.7 L=0.15
Xn_605_p1 n_605 n_601 vdd vdd sky130_fd_pr__pfet_01v8 W=0.7 L=0.15
Xn_605_p2 n_605 n_604 vdd vdd sky130_fd_pr__pfet_01v8 W=0.7 L=0.15
Xn_605_n1 n_605 n_601 n_605_x vss sky130_fd_pr__nfet_01v8 W=0.84 L=0.15
Xn_605_n2 n_605_x n_604 vss vss sky130_fd_pr__nfet_01v8 W=0.84 L=0.15
Xn_606_p1 n_606 n_602 vdd vdd sky130_fd_pr__pfet_01v8 W=0.7 L=0.15
Xn_606_p2 n_606 n_605 vdd vdd sky130_fd_pr__pfet_01v8 W=0.7 L=0.15
Xn_606_n1 n_606 n_602 n_606_x vss sky130_fd_pr__nfet_01v8 W=0.84 L=0.15
Xn_606_n2 n_606_x n_605 vss vss sky130_fd_pr__nfet_01v8 W=0.84 L=0.15
Xn_607_p1 n_607 n_307 vdd vdd sky130_fd_pr__pfet_01v8 W=0.7 L=0.15
Xn_607_p2 n_607 n_606 vdd vdd sky130_fd_pr__pfet_01v8 W=0.7 L=0.15
Xn_607_n1 n_607 n_307 n_607_x vss sky130_fd_pr__nfet_01v8 W=0.84 L=0.15
Xn_607_n2 n_607_x n_606 vss vss sky130_fd_pr__nfet_01v8 W=0.84 L=0.15
Xn_608_n n_608 n_607 vss vss sky130_fd_pr__nfet_01v8 W=0.42 L=0.15
Xn_608_p n_608 n_607 vdd vdd sky130_fd_pr__pfet_01v8 W=0.7 L=0.15
Xn_609_p1 n_609 n_344 vdd vdd sky130_fd_pr__pfet_01v8 W=0.7 L=0.15
Xn_609_p2 n_609 n_608 vdd vdd sky130_fd_pr__pfet_01v8 W=0.7 L=0.15
Xn_609_n1 n_609 n_344 n_609_x vss sky130_fd_pr__nfet_01v8 W=0.84 L=0.15
Xn_609_n2 n_609_x n_608 vss vss sky130_fd_pr__nfet_01v8 W=0.84 L=0.15
Xn_610_p1 n_610 n_495 vdd vdd sky130_fd_pr__pfet_01v8 W=0.7 L=0.15
Xn_610_p2 n_610 env2 vdd vdd sky130_fd_pr__pfet_01v8 W=0.7 L=0.15
Xn_610_n1 n_610 n_495 n_610_x vss sky130_fd_pr__nfet_01v8 W=0.84 L=0.15
Xn_610_n2 n_610_x env2 vss vss sky130_fd_pr__nfet_01v8 W=0.84 L=0.15
Xn_611_p1 n_611 n_609 vdd vdd sky130_fd_pr__pfet_01v8 W=0.7 L=0.15
Xn_611_p2 n_611 n_610 vdd vdd sky130_fd_pr__pfet_01v8 W=0.7 L=0.15
Xn_611_n1 n_611 n_609 n_611_x vss sky130_fd_pr__nfet_01v8 W=0.84 L=0.15
Xn_611_n2 n_611_x n_610 vss vss sky130_fd_pr__nfet_01v8 W=0.84 L=0.15
Xn_612_n n_612 n_611 vss vss sky130_fd_pr__nfet_01v8 W=0.42 L=0.15
Xn_612_p n_612 n_611 vdd vdd sky130_fd_pr__pfet_01v8 W=0.7 L=0.15
Xn_613_p1 n_613 n_611 n_613_x vdd sky130_fd_pr__pfet_01v8 W=1.4 L=0.15
Xn_613_p2 n_613_x n_106 vdd vdd sky130_fd_pr__pfet_01v8 W=1.4 L=0.15
Xn_613_n1 n_613 n_611 vss vss sky130_fd_pr__nfet_01v8 W=0.42 L=0.15
Xn_613_n2 n_613 n_106 vss vss sky130_fd_pr__nfet_01v8 W=0.42 L=0.15
Xn_614_p1 n_614 n_613 n_614_x vdd sky130_fd_pr__pfet_01v8 W=1.4 L=0.15
Xn_614_p2 n_614_x n_4 vdd vdd sky130_fd_pr__pfet_01v8 W=1.4 L=0.15
Xn_614_n1 n_614 n_613 vss vss sky130_fd_pr__nfet_01v8 W=0.42 L=0.15
Xn_614_n2 n_614 n_4 vss vss sky130_fd_pr__nfet_01v8 W=0.42 L=0.15
Xn_615_n n_615 n_614 vss vss sky130_fd_pr__nfet_01v8 W=0.42 L=0.15
Xn_615_p n_615 n_614 vdd vdd sky130_fd_pr__pfet_01v8 W=0.7 L=0.15
Xn_618_p1 n_618 n_612 n_618_x vdd sky130_fd_pr__pfet_01v8 W=1.4 L=0.15
Xn_618_p2 n_618_x n_106 vdd vdd sky130_fd_pr__pfet_01v8 W=1.4 L=0.15
Xn_618_n1 n_618 n_612 vss vss sky130_fd_pr__nfet_01v8 W=0.42 L=0.15
Xn_618_n2 n_618 n_106 vss vss sky130_fd_pr__nfet_01v8 W=0.42 L=0.15
Xn_617_p1 n_617 n_618 n_617_x vdd sky130_fd_pr__pfet_01v8 W=1.4 L=0.15
Xn_617_p2 n_617_x n_616 vdd vdd sky130_fd_pr__pfet_01v8 W=1.4 L=0.15
Xn_617_n1 n_617 n_618 vss vss sky130_fd_pr__nfet_01v8 W=0.42 L=0.15
Xn_617_n2 n_617 n_616 vss vss sky130_fd_pr__nfet_01v8 W=0.42 L=0.15
Xn_616_p1 n_616 n_615 n_616_x vdd sky130_fd_pr__pfet_01v8 W=1.4 L=0.15
Xn_616_p2 n_616_x n_617 vdd vdd sky130_fd_pr__pfet_01v8 W=1.4 L=0.15
Xn_616_n1 n_616 n_615 vss vss sky130_fd_pr__nfet_01v8 W=0.42 L=0.15
Xn_616_n2 n_616 n_617 vss vss sky130_fd_pr__nfet_01v8 W=0.42 L=0.15
Xn_619_p1 n_619 n_616 n_619_x vdd sky130_fd_pr__pfet_01v8 W=1.4 L=0.15
Xn_619_p2 n_619_x n_109 vdd vdd sky130_fd_pr__pfet_01v8 W=1.4 L=0.15
Xn_619_n1 n_619 n_616 vss vss sky130_fd_pr__nfet_01v8 W=0.42 L=0.15
Xn_619_n2 n_619 n_109 vss vss sky130_fd_pr__nfet_01v8 W=0.42 L=0.15
Xn_620_p1 n_620 n_619 n_620_x vdd sky130_fd_pr__pfet_01v8 W=1.4 L=0.15
Xn_620_p2 n_620_x n_4 vdd vdd sky130_fd_pr__pfet_01v8 W=1.4 L=0.15
Xn_620_n1 n_620 n_619 vss vss sky130_fd_pr__nfet_01v8 W=0.42 L=0.15
Xn_620_n2 n_620 n_4 vss vss sky130_fd_pr__nfet_01v8 W=0.42 L=0.15
Xn_621_n n_621 n_620 vss vss sky130_fd_pr__nfet_01v8 W=0.42 L=0.15
Xn_621_p n_621 n_620 vdd vdd sky130_fd_pr__pfet_01v8 W=0.7 L=0.15
Xn_623_p1 n_623 n_617 n_623_x vdd sky130_fd_pr__pfet_01v8 W=1.4 L=0.15
Xn_623_p2 n_623_x n_109 vdd vdd sky130_fd_pr__pfet_01v8 W=1.4 L=0.15
Xn_623_n1 n_623 n_617 vss vss sky130_fd_pr__nfet_01v8 W=0.42 L=0.15
Xn_623_n2 n_623 n_109 vss vss sky130_fd_pr__nfet_01v8 W=0.42 L=0.15
Xn_622_p1 n_622 n_623 n_622_x vdd sky130_fd_pr__pfet_01v8 W=1.4 L=0.15
Xn_622_p2 n_622_x env2 vdd vdd sky130_fd_pr__pfet_01v8 W=1.4 L=0.15
Xn_622_n1 n_622 n_623 vss vss sky130_fd_pr__nfet_01v8 W=0.42 L=0.15
Xn_622_n2 n_622 env2 vss vss sky130_fd_pr__nfet_01v8 W=0.42 L=0.15
Xenv2_p1 env2 n_621 env2_x vdd sky130_fd_pr__pfet_01v8 W=1.4 L=0.15
Xenv2_p2 env2_x n_622 vdd vdd sky130_fd_pr__pfet_01v8 W=1.4 L=0.15
Xenv2_n1 env2 n_621 vss vss sky130_fd_pr__nfet_01v8 W=0.42 L=0.15
Xenv2_n2 env2 n_622 vss vss sky130_fd_pr__nfet_01v8 W=0.42 L=0.15
Xn_624_n n_624 env2 vss vss sky130_fd_pr__nfet_01v8 W=0.42 L=0.15
Xn_624_p n_624 env2 vdd vdd sky130_fd_pr__pfet_01v8 W=0.7 L=0.15
Xn_625_p1 n_625 env2 vdd vdd sky130_fd_pr__pfet_01v8 W=0.7 L=0.15
Xn_625_p2 n_625 t_ck vdd vdd sky130_fd_pr__pfet_01v8 W=0.7 L=0.15
Xn_625_n1 n_625 env2 n_625_x vss sky130_fd_pr__nfet_01v8 W=0.84 L=0.15
Xn_625_n2 n_625_x t_ck vss vss sky130_fd_pr__nfet_01v8 W=0.84 L=0.15
Xn_626_n n_626 n_625 vss vss sky130_fd_pr__nfet_01v8 W=0.42 L=0.15
Xn_626_p n_626 n_625 vdd vdd sky130_fd_pr__pfet_01v8 W=0.7 L=0.15
Xn_627_p1 n_627 n_624 vdd vdd sky130_fd_pr__pfet_01v8 W=0.7 L=0.15
Xn_627_p2 n_627 t_ck vdd vdd sky130_fd_pr__pfet_01v8 W=0.7 L=0.15
Xn_627_n1 n_627 n_624 n_627_x vss sky130_fd_pr__nfet_01v8 W=0.84 L=0.15
Xn_627_n2 n_627_x t_ck vss vss sky130_fd_pr__nfet_01v8 W=0.84 L=0.15
Xn_628_n n_628 n_627 vss vss sky130_fd_pr__nfet_01v8 W=0.42 L=0.15
Xn_628_p n_628 n_627 vdd vdd sky130_fd_pr__pfet_01v8 W=0.7 L=0.15
Xn_629_p1 n_629 n_628 n_629_x vdd sky130_fd_pr__pfet_01v8 W=1.4 L=0.15
Xn_629_p2 n_629_x n_4 vdd vdd sky130_fd_pr__pfet_01v8 W=1.4 L=0.15
Xn_629_n1 n_629 n_628 vss vss sky130_fd_pr__nfet_01v8 W=0.42 L=0.15
Xn_629_n2 n_629 n_4 vss vss sky130_fd_pr__nfet_01v8 W=0.42 L=0.15
Xn_630_n n_630 n_629 vss vss sky130_fd_pr__nfet_01v8 W=0.42 L=0.15
Xn_630_p n_630 n_629 vdd vdd sky130_fd_pr__pfet_01v8 W=0.7 L=0.15
Xn_632_p1 n_632 n_626 n_632_x vdd sky130_fd_pr__pfet_01v8 W=1.4 L=0.15
Xn_632_p2 n_632_x n_631 vdd vdd sky130_fd_pr__pfet_01v8 W=1.4 L=0.15
Xn_632_n1 n_632 n_626 vss vss sky130_fd_pr__nfet_01v8 W=0.42 L=0.15
Xn_632_n2 n_632 n_631 vss vss sky130_fd_pr__nfet_01v8 W=0.42 L=0.15
Xn_631_p1 n_631 n_630 n_631_x vdd sky130_fd_pr__pfet_01v8 W=1.4 L=0.15
Xn_631_p2 n_631_x n_632 vdd vdd sky130_fd_pr__pfet_01v8 W=1.4 L=0.15
Xn_631_n1 n_631 n_630 vss vss sky130_fd_pr__nfet_01v8 W=0.42 L=0.15
Xn_631_n2 n_631 n_632 vss vss sky130_fd_pr__nfet_01v8 W=0.42 L=0.15
Xn_633_n n_633 x_neg2 vss vss sky130_fd_pr__nfet_01v8 W=0.42 L=0.15
Xn_633_p n_633 x_neg2 vdd vdd sky130_fd_pr__pfet_01v8 W=0.7 L=0.15
Xn_634_p1 n_634 n_631 vdd vdd sky130_fd_pr__pfet_01v8 W=0.7 L=0.15
Xn_634_p2 n_634 n_633 vdd vdd sky130_fd_pr__pfet_01v8 W=0.7 L=0.15
Xn_634_n1 n_634 n_631 n_634_x vss sky130_fd_pr__nfet_01v8 W=0.84 L=0.15
Xn_634_n2 n_634_x n_633 vss vss sky130_fd_pr__nfet_01v8 W=0.84 L=0.15
Xxin_p_r2_n xin_p_r2 n_634 vss vss sky130_fd_pr__nfet_01v8 W=0.42 L=0.15
Xxin_p_r2_p xin_p_r2 n_634 vdd vdd sky130_fd_pr__pfet_01v8 W=0.7 L=0.15
Xn_635_p1 n_635 n_631 vdd vdd sky130_fd_pr__pfet_01v8 W=0.7 L=0.15
Xn_635_p2 n_635 x_neg2 vdd vdd sky130_fd_pr__pfet_01v8 W=0.7 L=0.15
Xn_635_n1 n_635 n_631 n_635_x vss sky130_fd_pr__nfet_01v8 W=0.84 L=0.15
Xn_635_n2 n_635_x x_neg2 vss vss sky130_fd_pr__nfet_01v8 W=0.84 L=0.15
Xxin_n_r2_n xin_n_r2 n_635 vss vss sky130_fd_pr__nfet_01v8 W=0.42 L=0.15
Xxin_n_r2_p xin_n_r2 n_635 vdd vdd sky130_fd_pr__pfet_01v8 W=0.7 L=0.15
Xn_636_p1 n_636 n_631 vdd vdd sky130_fd_pr__pfet_01v8 W=0.7 L=0.15
Xn_636_p2 n_636 lora_en vdd vdd sky130_fd_pr__pfet_01v8 W=0.7 L=0.15
Xn_636_n1 n_636 n_631 n_636_x vss sky130_fd_pr__nfet_01v8 W=0.84 L=0.15
Xn_636_n2 n_636_x lora_en vss vss sky130_fd_pr__nfet_01v8 W=0.84 L=0.15
Xxrd_en2_n xrd_en2 n_636 vss vss sky130_fd_pr__nfet_01v8 W=0.42 L=0.15
Xxrd_en2_p xrd_en2 n_636 vdd vdd sky130_fd_pr__pfet_01v8 W=0.7 L=0.15
Xn_637_p1 n_637 n_491 vdd vdd sky130_fd_pr__pfet_01v8 W=0.7 L=0.15
Xn_637_p2 n_637 x_mag12 vdd vdd sky130_fd_pr__pfet_01v8 W=0.7 L=0.15
Xn_637_n1 n_637 n_491 n_637_x vss sky130_fd_pr__nfet_01v8 W=0.84 L=0.15
Xn_637_n2 n_637_x x_mag12 vss vss sky130_fd_pr__nfet_01v8 W=0.84 L=0.15
Xn_638_n n_638 n_637 vss vss sky130_fd_pr__nfet_01v8 W=0.42 L=0.15
Xn_638_p n_638 n_637 vdd vdd sky130_fd_pr__pfet_01v8 W=0.7 L=0.15
Xn_639_p1 n_639 n_492 vdd vdd sky130_fd_pr__pfet_01v8 W=0.7 L=0.15
Xn_639_p2 n_639 x_mag13 vdd vdd sky130_fd_pr__pfet_01v8 W=0.7 L=0.15
Xn_639_n1 n_639 n_492 n_639_x vss sky130_fd_pr__nfet_01v8 W=0.84 L=0.15
Xn_639_n2 n_639_x x_mag13 vss vss sky130_fd_pr__nfet_01v8 W=0.84 L=0.15
Xn_640_p1 n_640 n_492 n_640_x vdd sky130_fd_pr__pfet_01v8 W=1.4 L=0.15
Xn_640_p2 n_640_x x_mag13 vdd vdd sky130_fd_pr__pfet_01v8 W=1.4 L=0.15
Xn_640_n1 n_640 n_492 vss vss sky130_fd_pr__nfet_01v8 W=0.42 L=0.15
Xn_640_n2 n_640 x_mag13 vss vss sky130_fd_pr__nfet_01v8 W=0.42 L=0.15
Xn_641_n n_641 n_640 vss vss sky130_fd_pr__nfet_01v8 W=0.42 L=0.15
Xn_641_p n_641 n_640 vdd vdd sky130_fd_pr__pfet_01v8 W=0.7 L=0.15
Xn_642_p1 n_642 n_638 vdd vdd sky130_fd_pr__pfet_01v8 W=0.7 L=0.15
Xn_642_p2 n_642 n_641 vdd vdd sky130_fd_pr__pfet_01v8 W=0.7 L=0.15
Xn_642_n1 n_642 n_638 n_642_x vss sky130_fd_pr__nfet_01v8 W=0.84 L=0.15
Xn_642_n2 n_642_x n_641 vss vss sky130_fd_pr__nfet_01v8 W=0.84 L=0.15
Xn_643_p1 n_643 n_639 vdd vdd sky130_fd_pr__pfet_01v8 W=0.7 L=0.15
Xn_643_p2 n_643 n_642 vdd vdd sky130_fd_pr__pfet_01v8 W=0.7 L=0.15
Xn_643_n1 n_643 n_639 n_643_x vss sky130_fd_pr__nfet_01v8 W=0.84 L=0.15
Xn_643_n2 n_643_x n_642 vss vss sky130_fd_pr__nfet_01v8 W=0.84 L=0.15
Xn_644_p1 n_644 n_493 vdd vdd sky130_fd_pr__pfet_01v8 W=0.7 L=0.15
Xn_644_p2 n_644 x_mag14 vdd vdd sky130_fd_pr__pfet_01v8 W=0.7 L=0.15
Xn_644_n1 n_644 n_493 n_644_x vss sky130_fd_pr__nfet_01v8 W=0.84 L=0.15
Xn_644_n2 n_644_x x_mag14 vss vss sky130_fd_pr__nfet_01v8 W=0.84 L=0.15
Xn_645_p1 n_645 n_493 n_645_x vdd sky130_fd_pr__pfet_01v8 W=1.4 L=0.15
Xn_645_p2 n_645_x x_mag14 vdd vdd sky130_fd_pr__pfet_01v8 W=1.4 L=0.15
Xn_645_n1 n_645 n_493 vss vss sky130_fd_pr__nfet_01v8 W=0.42 L=0.15
Xn_645_n2 n_645 x_mag14 vss vss sky130_fd_pr__nfet_01v8 W=0.42 L=0.15
Xn_646_n n_646 n_645 vss vss sky130_fd_pr__nfet_01v8 W=0.42 L=0.15
Xn_646_p n_646 n_645 vdd vdd sky130_fd_pr__pfet_01v8 W=0.7 L=0.15
Xn_647_p1 n_647 n_643 vdd vdd sky130_fd_pr__pfet_01v8 W=0.7 L=0.15
Xn_647_p2 n_647 n_646 vdd vdd sky130_fd_pr__pfet_01v8 W=0.7 L=0.15
Xn_647_n1 n_647 n_643 n_647_x vss sky130_fd_pr__nfet_01v8 W=0.84 L=0.15
Xn_647_n2 n_647_x n_646 vss vss sky130_fd_pr__nfet_01v8 W=0.84 L=0.15
Xn_648_p1 n_648 n_644 vdd vdd sky130_fd_pr__pfet_01v8 W=0.7 L=0.15
Xn_648_p2 n_648 n_647 vdd vdd sky130_fd_pr__pfet_01v8 W=0.7 L=0.15
Xn_648_n1 n_648 n_644 n_648_x vss sky130_fd_pr__nfet_01v8 W=0.84 L=0.15
Xn_648_n2 n_648_x n_647 vss vss sky130_fd_pr__nfet_01v8 W=0.84 L=0.15
Xn_649_p1 n_649 n_494 vdd vdd sky130_fd_pr__pfet_01v8 W=0.7 L=0.15
Xn_649_p2 n_649 x_mag15 vdd vdd sky130_fd_pr__pfet_01v8 W=0.7 L=0.15
Xn_649_n1 n_649 n_494 n_649_x vss sky130_fd_pr__nfet_01v8 W=0.84 L=0.15
Xn_649_n2 n_649_x x_mag15 vss vss sky130_fd_pr__nfet_01v8 W=0.84 L=0.15
Xn_650_p1 n_650 n_494 n_650_x vdd sky130_fd_pr__pfet_01v8 W=1.4 L=0.15
Xn_650_p2 n_650_x x_mag15 vdd vdd sky130_fd_pr__pfet_01v8 W=1.4 L=0.15
Xn_650_n1 n_650 n_494 vss vss sky130_fd_pr__nfet_01v8 W=0.42 L=0.15
Xn_650_n2 n_650 x_mag15 vss vss sky130_fd_pr__nfet_01v8 W=0.42 L=0.15
Xn_651_n n_651 n_650 vss vss sky130_fd_pr__nfet_01v8 W=0.42 L=0.15
Xn_651_p n_651 n_650 vdd vdd sky130_fd_pr__pfet_01v8 W=0.7 L=0.15
Xn_652_p1 n_652 n_648 vdd vdd sky130_fd_pr__pfet_01v8 W=0.7 L=0.15
Xn_652_p2 n_652 n_651 vdd vdd sky130_fd_pr__pfet_01v8 W=0.7 L=0.15
Xn_652_n1 n_652 n_648 n_652_x vss sky130_fd_pr__nfet_01v8 W=0.84 L=0.15
Xn_652_n2 n_652_x n_651 vss vss sky130_fd_pr__nfet_01v8 W=0.84 L=0.15
Xn_653_p1 n_653 n_649 vdd vdd sky130_fd_pr__pfet_01v8 W=0.7 L=0.15
Xn_653_p2 n_653 n_652 vdd vdd sky130_fd_pr__pfet_01v8 W=0.7 L=0.15
Xn_653_n1 n_653 n_649 n_653_x vss sky130_fd_pr__nfet_01v8 W=0.84 L=0.15
Xn_653_n2 n_653_x n_652 vss vss sky130_fd_pr__nfet_01v8 W=0.84 L=0.15
Xn_654_p1 n_654 n_307 vdd vdd sky130_fd_pr__pfet_01v8 W=0.7 L=0.15
Xn_654_p2 n_654 n_653 vdd vdd sky130_fd_pr__pfet_01v8 W=0.7 L=0.15
Xn_654_n1 n_654 n_307 n_654_x vss sky130_fd_pr__nfet_01v8 W=0.84 L=0.15
Xn_654_n2 n_654_x n_653 vss vss sky130_fd_pr__nfet_01v8 W=0.84 L=0.15
Xn_655_n n_655 n_654 vss vss sky130_fd_pr__nfet_01v8 W=0.42 L=0.15
Xn_655_p n_655 n_654 vdd vdd sky130_fd_pr__pfet_01v8 W=0.7 L=0.15
Xn_656_p1 n_656 n_344 vdd vdd sky130_fd_pr__pfet_01v8 W=0.7 L=0.15
Xn_656_p2 n_656 n_655 vdd vdd sky130_fd_pr__pfet_01v8 W=0.7 L=0.15
Xn_656_n1 n_656 n_344 n_656_x vss sky130_fd_pr__nfet_01v8 W=0.84 L=0.15
Xn_656_n2 n_656_x n_655 vss vss sky130_fd_pr__nfet_01v8 W=0.84 L=0.15
Xn_657_p1 n_657 n_495 vdd vdd sky130_fd_pr__pfet_01v8 W=0.7 L=0.15
Xn_657_p2 n_657 env3 vdd vdd sky130_fd_pr__pfet_01v8 W=0.7 L=0.15
Xn_657_n1 n_657 n_495 n_657_x vss sky130_fd_pr__nfet_01v8 W=0.84 L=0.15
Xn_657_n2 n_657_x env3 vss vss sky130_fd_pr__nfet_01v8 W=0.84 L=0.15
Xn_658_p1 n_658 n_656 vdd vdd sky130_fd_pr__pfet_01v8 W=0.7 L=0.15
Xn_658_p2 n_658 n_657 vdd vdd sky130_fd_pr__pfet_01v8 W=0.7 L=0.15
Xn_658_n1 n_658 n_656 n_658_x vss sky130_fd_pr__nfet_01v8 W=0.84 L=0.15
Xn_658_n2 n_658_x n_657 vss vss sky130_fd_pr__nfet_01v8 W=0.84 L=0.15
Xn_659_n n_659 n_658 vss vss sky130_fd_pr__nfet_01v8 W=0.42 L=0.15
Xn_659_p n_659 n_658 vdd vdd sky130_fd_pr__pfet_01v8 W=0.7 L=0.15
Xn_660_p1 n_660 n_658 n_660_x vdd sky130_fd_pr__pfet_01v8 W=1.4 L=0.15
Xn_660_p2 n_660_x n_106 vdd vdd sky130_fd_pr__pfet_01v8 W=1.4 L=0.15
Xn_660_n1 n_660 n_658 vss vss sky130_fd_pr__nfet_01v8 W=0.42 L=0.15
Xn_660_n2 n_660 n_106 vss vss sky130_fd_pr__nfet_01v8 W=0.42 L=0.15
Xn_661_p1 n_661 n_660 n_661_x vdd sky130_fd_pr__pfet_01v8 W=1.4 L=0.15
Xn_661_p2 n_661_x n_4 vdd vdd sky130_fd_pr__pfet_01v8 W=1.4 L=0.15
Xn_661_n1 n_661 n_660 vss vss sky130_fd_pr__nfet_01v8 W=0.42 L=0.15
Xn_661_n2 n_661 n_4 vss vss sky130_fd_pr__nfet_01v8 W=0.42 L=0.15
Xn_662_n n_662 n_661 vss vss sky130_fd_pr__nfet_01v8 W=0.42 L=0.15
Xn_662_p n_662 n_661 vdd vdd sky130_fd_pr__pfet_01v8 W=0.7 L=0.15
Xn_665_p1 n_665 n_659 n_665_x vdd sky130_fd_pr__pfet_01v8 W=1.4 L=0.15
Xn_665_p2 n_665_x n_106 vdd vdd sky130_fd_pr__pfet_01v8 W=1.4 L=0.15
Xn_665_n1 n_665 n_659 vss vss sky130_fd_pr__nfet_01v8 W=0.42 L=0.15
Xn_665_n2 n_665 n_106 vss vss sky130_fd_pr__nfet_01v8 W=0.42 L=0.15
Xn_664_p1 n_664 n_665 n_664_x vdd sky130_fd_pr__pfet_01v8 W=1.4 L=0.15
Xn_664_p2 n_664_x n_663 vdd vdd sky130_fd_pr__pfet_01v8 W=1.4 L=0.15
Xn_664_n1 n_664 n_665 vss vss sky130_fd_pr__nfet_01v8 W=0.42 L=0.15
Xn_664_n2 n_664 n_663 vss vss sky130_fd_pr__nfet_01v8 W=0.42 L=0.15
Xn_663_p1 n_663 n_662 n_663_x vdd sky130_fd_pr__pfet_01v8 W=1.4 L=0.15
Xn_663_p2 n_663_x n_664 vdd vdd sky130_fd_pr__pfet_01v8 W=1.4 L=0.15
Xn_663_n1 n_663 n_662 vss vss sky130_fd_pr__nfet_01v8 W=0.42 L=0.15
Xn_663_n2 n_663 n_664 vss vss sky130_fd_pr__nfet_01v8 W=0.42 L=0.15
Xn_666_p1 n_666 n_663 n_666_x vdd sky130_fd_pr__pfet_01v8 W=1.4 L=0.15
Xn_666_p2 n_666_x n_109 vdd vdd sky130_fd_pr__pfet_01v8 W=1.4 L=0.15
Xn_666_n1 n_666 n_663 vss vss sky130_fd_pr__nfet_01v8 W=0.42 L=0.15
Xn_666_n2 n_666 n_109 vss vss sky130_fd_pr__nfet_01v8 W=0.42 L=0.15
Xn_667_p1 n_667 n_666 n_667_x vdd sky130_fd_pr__pfet_01v8 W=1.4 L=0.15
Xn_667_p2 n_667_x n_4 vdd vdd sky130_fd_pr__pfet_01v8 W=1.4 L=0.15
Xn_667_n1 n_667 n_666 vss vss sky130_fd_pr__nfet_01v8 W=0.42 L=0.15
Xn_667_n2 n_667 n_4 vss vss sky130_fd_pr__nfet_01v8 W=0.42 L=0.15
Xn_668_n n_668 n_667 vss vss sky130_fd_pr__nfet_01v8 W=0.42 L=0.15
Xn_668_p n_668 n_667 vdd vdd sky130_fd_pr__pfet_01v8 W=0.7 L=0.15
Xn_670_p1 n_670 n_664 n_670_x vdd sky130_fd_pr__pfet_01v8 W=1.4 L=0.15
Xn_670_p2 n_670_x n_109 vdd vdd sky130_fd_pr__pfet_01v8 W=1.4 L=0.15
Xn_670_n1 n_670 n_664 vss vss sky130_fd_pr__nfet_01v8 W=0.42 L=0.15
Xn_670_n2 n_670 n_109 vss vss sky130_fd_pr__nfet_01v8 W=0.42 L=0.15
Xn_669_p1 n_669 n_670 n_669_x vdd sky130_fd_pr__pfet_01v8 W=1.4 L=0.15
Xn_669_p2 n_669_x env3 vdd vdd sky130_fd_pr__pfet_01v8 W=1.4 L=0.15
Xn_669_n1 n_669 n_670 vss vss sky130_fd_pr__nfet_01v8 W=0.42 L=0.15
Xn_669_n2 n_669 env3 vss vss sky130_fd_pr__nfet_01v8 W=0.42 L=0.15
Xenv3_p1 env3 n_668 env3_x vdd sky130_fd_pr__pfet_01v8 W=1.4 L=0.15
Xenv3_p2 env3_x n_669 vdd vdd sky130_fd_pr__pfet_01v8 W=1.4 L=0.15
Xenv3_n1 env3 n_668 vss vss sky130_fd_pr__nfet_01v8 W=0.42 L=0.15
Xenv3_n2 env3 n_669 vss vss sky130_fd_pr__nfet_01v8 W=0.42 L=0.15
Xn_671_n n_671 env3 vss vss sky130_fd_pr__nfet_01v8 W=0.42 L=0.15
Xn_671_p n_671 env3 vdd vdd sky130_fd_pr__pfet_01v8 W=0.7 L=0.15
Xn_672_p1 n_672 env3 vdd vdd sky130_fd_pr__pfet_01v8 W=0.7 L=0.15
Xn_672_p2 n_672 t_ck vdd vdd sky130_fd_pr__pfet_01v8 W=0.7 L=0.15
Xn_672_n1 n_672 env3 n_672_x vss sky130_fd_pr__nfet_01v8 W=0.84 L=0.15
Xn_672_n2 n_672_x t_ck vss vss sky130_fd_pr__nfet_01v8 W=0.84 L=0.15
Xn_673_n n_673 n_672 vss vss sky130_fd_pr__nfet_01v8 W=0.42 L=0.15
Xn_673_p n_673 n_672 vdd vdd sky130_fd_pr__pfet_01v8 W=0.7 L=0.15
Xn_674_p1 n_674 n_671 vdd vdd sky130_fd_pr__pfet_01v8 W=0.7 L=0.15
Xn_674_p2 n_674 t_ck vdd vdd sky130_fd_pr__pfet_01v8 W=0.7 L=0.15
Xn_674_n1 n_674 n_671 n_674_x vss sky130_fd_pr__nfet_01v8 W=0.84 L=0.15
Xn_674_n2 n_674_x t_ck vss vss sky130_fd_pr__nfet_01v8 W=0.84 L=0.15
Xn_675_n n_675 n_674 vss vss sky130_fd_pr__nfet_01v8 W=0.42 L=0.15
Xn_675_p n_675 n_674 vdd vdd sky130_fd_pr__pfet_01v8 W=0.7 L=0.15
Xn_676_p1 n_676 n_675 n_676_x vdd sky130_fd_pr__pfet_01v8 W=1.4 L=0.15
Xn_676_p2 n_676_x n_4 vdd vdd sky130_fd_pr__pfet_01v8 W=1.4 L=0.15
Xn_676_n1 n_676 n_675 vss vss sky130_fd_pr__nfet_01v8 W=0.42 L=0.15
Xn_676_n2 n_676 n_4 vss vss sky130_fd_pr__nfet_01v8 W=0.42 L=0.15
Xn_677_n n_677 n_676 vss vss sky130_fd_pr__nfet_01v8 W=0.42 L=0.15
Xn_677_p n_677 n_676 vdd vdd sky130_fd_pr__pfet_01v8 W=0.7 L=0.15
Xn_679_p1 n_679 n_673 n_679_x vdd sky130_fd_pr__pfet_01v8 W=1.4 L=0.15
Xn_679_p2 n_679_x n_678 vdd vdd sky130_fd_pr__pfet_01v8 W=1.4 L=0.15
Xn_679_n1 n_679 n_673 vss vss sky130_fd_pr__nfet_01v8 W=0.42 L=0.15
Xn_679_n2 n_679 n_678 vss vss sky130_fd_pr__nfet_01v8 W=0.42 L=0.15
Xn_678_p1 n_678 n_677 n_678_x vdd sky130_fd_pr__pfet_01v8 W=1.4 L=0.15
Xn_678_p2 n_678_x n_679 vdd vdd sky130_fd_pr__pfet_01v8 W=1.4 L=0.15
Xn_678_n1 n_678 n_677 vss vss sky130_fd_pr__nfet_01v8 W=0.42 L=0.15
Xn_678_n2 n_678 n_679 vss vss sky130_fd_pr__nfet_01v8 W=0.42 L=0.15
Xn_680_n n_680 x_neg3 vss vss sky130_fd_pr__nfet_01v8 W=0.42 L=0.15
Xn_680_p n_680 x_neg3 vdd vdd sky130_fd_pr__pfet_01v8 W=0.7 L=0.15
Xn_681_p1 n_681 n_678 vdd vdd sky130_fd_pr__pfet_01v8 W=0.7 L=0.15
Xn_681_p2 n_681 n_680 vdd vdd sky130_fd_pr__pfet_01v8 W=0.7 L=0.15
Xn_681_n1 n_681 n_678 n_681_x vss sky130_fd_pr__nfet_01v8 W=0.84 L=0.15
Xn_681_n2 n_681_x n_680 vss vss sky130_fd_pr__nfet_01v8 W=0.84 L=0.15
Xxin_p_r3_n xin_p_r3 n_681 vss vss sky130_fd_pr__nfet_01v8 W=0.42 L=0.15
Xxin_p_r3_p xin_p_r3 n_681 vdd vdd sky130_fd_pr__pfet_01v8 W=0.7 L=0.15
Xn_682_p1 n_682 n_678 vdd vdd sky130_fd_pr__pfet_01v8 W=0.7 L=0.15
Xn_682_p2 n_682 x_neg3 vdd vdd sky130_fd_pr__pfet_01v8 W=0.7 L=0.15
Xn_682_n1 n_682 n_678 n_682_x vss sky130_fd_pr__nfet_01v8 W=0.84 L=0.15
Xn_682_n2 n_682_x x_neg3 vss vss sky130_fd_pr__nfet_01v8 W=0.84 L=0.15
Xxin_n_r3_n xin_n_r3 n_682 vss vss sky130_fd_pr__nfet_01v8 W=0.42 L=0.15
Xxin_n_r3_p xin_n_r3 n_682 vdd vdd sky130_fd_pr__pfet_01v8 W=0.7 L=0.15
Xn_683_p1 n_683 n_678 vdd vdd sky130_fd_pr__pfet_01v8 W=0.7 L=0.15
Xn_683_p2 n_683 lora_en vdd vdd sky130_fd_pr__pfet_01v8 W=0.7 L=0.15
Xn_683_n1 n_683 n_678 n_683_x vss sky130_fd_pr__nfet_01v8 W=0.84 L=0.15
Xn_683_n2 n_683_x lora_en vss vss sky130_fd_pr__nfet_01v8 W=0.84 L=0.15
Xxrd_en3_n xrd_en3 n_683 vss vss sky130_fd_pr__nfet_01v8 W=0.42 L=0.15
Xxrd_en3_p xrd_en3 n_683 vdd vdd sky130_fd_pr__pfet_01v8 W=0.7 L=0.15
Xn_684_p1 n_684 n_491 vdd vdd sky130_fd_pr__pfet_01v8 W=0.7 L=0.15
Xn_684_p2 n_684 x_mag16 vdd vdd sky130_fd_pr__pfet_01v8 W=0.7 L=0.15
Xn_684_n1 n_684 n_491 n_684_x vss sky130_fd_pr__nfet_01v8 W=0.84 L=0.15
Xn_684_n2 n_684_x x_mag16 vss vss sky130_fd_pr__nfet_01v8 W=0.84 L=0.15
Xn_685_n n_685 n_684 vss vss sky130_fd_pr__nfet_01v8 W=0.42 L=0.15
Xn_685_p n_685 n_684 vdd vdd sky130_fd_pr__pfet_01v8 W=0.7 L=0.15
Xn_686_p1 n_686 n_492 vdd vdd sky130_fd_pr__pfet_01v8 W=0.7 L=0.15
Xn_686_p2 n_686 x_mag17 vdd vdd sky130_fd_pr__pfet_01v8 W=0.7 L=0.15
Xn_686_n1 n_686 n_492 n_686_x vss sky130_fd_pr__nfet_01v8 W=0.84 L=0.15
Xn_686_n2 n_686_x x_mag17 vss vss sky130_fd_pr__nfet_01v8 W=0.84 L=0.15
Xn_687_p1 n_687 n_492 n_687_x vdd sky130_fd_pr__pfet_01v8 W=1.4 L=0.15
Xn_687_p2 n_687_x x_mag17 vdd vdd sky130_fd_pr__pfet_01v8 W=1.4 L=0.15
Xn_687_n1 n_687 n_492 vss vss sky130_fd_pr__nfet_01v8 W=0.42 L=0.15
Xn_687_n2 n_687 x_mag17 vss vss sky130_fd_pr__nfet_01v8 W=0.42 L=0.15
Xn_688_n n_688 n_687 vss vss sky130_fd_pr__nfet_01v8 W=0.42 L=0.15
Xn_688_p n_688 n_687 vdd vdd sky130_fd_pr__pfet_01v8 W=0.7 L=0.15
Xn_689_p1 n_689 n_685 vdd vdd sky130_fd_pr__pfet_01v8 W=0.7 L=0.15
Xn_689_p2 n_689 n_688 vdd vdd sky130_fd_pr__pfet_01v8 W=0.7 L=0.15
Xn_689_n1 n_689 n_685 n_689_x vss sky130_fd_pr__nfet_01v8 W=0.84 L=0.15
Xn_689_n2 n_689_x n_688 vss vss sky130_fd_pr__nfet_01v8 W=0.84 L=0.15
Xn_690_p1 n_690 n_686 vdd vdd sky130_fd_pr__pfet_01v8 W=0.7 L=0.15
Xn_690_p2 n_690 n_689 vdd vdd sky130_fd_pr__pfet_01v8 W=0.7 L=0.15
Xn_690_n1 n_690 n_686 n_690_x vss sky130_fd_pr__nfet_01v8 W=0.84 L=0.15
Xn_690_n2 n_690_x n_689 vss vss sky130_fd_pr__nfet_01v8 W=0.84 L=0.15
Xn_691_p1 n_691 n_493 vdd vdd sky130_fd_pr__pfet_01v8 W=0.7 L=0.15
Xn_691_p2 n_691 x_mag18 vdd vdd sky130_fd_pr__pfet_01v8 W=0.7 L=0.15
Xn_691_n1 n_691 n_493 n_691_x vss sky130_fd_pr__nfet_01v8 W=0.84 L=0.15
Xn_691_n2 n_691_x x_mag18 vss vss sky130_fd_pr__nfet_01v8 W=0.84 L=0.15
Xn_692_p1 n_692 n_493 n_692_x vdd sky130_fd_pr__pfet_01v8 W=1.4 L=0.15
Xn_692_p2 n_692_x x_mag18 vdd vdd sky130_fd_pr__pfet_01v8 W=1.4 L=0.15
Xn_692_n1 n_692 n_493 vss vss sky130_fd_pr__nfet_01v8 W=0.42 L=0.15
Xn_692_n2 n_692 x_mag18 vss vss sky130_fd_pr__nfet_01v8 W=0.42 L=0.15
Xn_693_n n_693 n_692 vss vss sky130_fd_pr__nfet_01v8 W=0.42 L=0.15
Xn_693_p n_693 n_692 vdd vdd sky130_fd_pr__pfet_01v8 W=0.7 L=0.15
Xn_694_p1 n_694 n_690 vdd vdd sky130_fd_pr__pfet_01v8 W=0.7 L=0.15
Xn_694_p2 n_694 n_693 vdd vdd sky130_fd_pr__pfet_01v8 W=0.7 L=0.15
Xn_694_n1 n_694 n_690 n_694_x vss sky130_fd_pr__nfet_01v8 W=0.84 L=0.15
Xn_694_n2 n_694_x n_693 vss vss sky130_fd_pr__nfet_01v8 W=0.84 L=0.15
Xn_695_p1 n_695 n_691 vdd vdd sky130_fd_pr__pfet_01v8 W=0.7 L=0.15
Xn_695_p2 n_695 n_694 vdd vdd sky130_fd_pr__pfet_01v8 W=0.7 L=0.15
Xn_695_n1 n_695 n_691 n_695_x vss sky130_fd_pr__nfet_01v8 W=0.84 L=0.15
Xn_695_n2 n_695_x n_694 vss vss sky130_fd_pr__nfet_01v8 W=0.84 L=0.15
Xn_696_p1 n_696 n_494 vdd vdd sky130_fd_pr__pfet_01v8 W=0.7 L=0.15
Xn_696_p2 n_696 x_mag19 vdd vdd sky130_fd_pr__pfet_01v8 W=0.7 L=0.15
Xn_696_n1 n_696 n_494 n_696_x vss sky130_fd_pr__nfet_01v8 W=0.84 L=0.15
Xn_696_n2 n_696_x x_mag19 vss vss sky130_fd_pr__nfet_01v8 W=0.84 L=0.15
Xn_697_p1 n_697 n_494 n_697_x vdd sky130_fd_pr__pfet_01v8 W=1.4 L=0.15
Xn_697_p2 n_697_x x_mag19 vdd vdd sky130_fd_pr__pfet_01v8 W=1.4 L=0.15
Xn_697_n1 n_697 n_494 vss vss sky130_fd_pr__nfet_01v8 W=0.42 L=0.15
Xn_697_n2 n_697 x_mag19 vss vss sky130_fd_pr__nfet_01v8 W=0.42 L=0.15
Xn_698_n n_698 n_697 vss vss sky130_fd_pr__nfet_01v8 W=0.42 L=0.15
Xn_698_p n_698 n_697 vdd vdd sky130_fd_pr__pfet_01v8 W=0.7 L=0.15
Xn_699_p1 n_699 n_695 vdd vdd sky130_fd_pr__pfet_01v8 W=0.7 L=0.15
Xn_699_p2 n_699 n_698 vdd vdd sky130_fd_pr__pfet_01v8 W=0.7 L=0.15
Xn_699_n1 n_699 n_695 n_699_x vss sky130_fd_pr__nfet_01v8 W=0.84 L=0.15
Xn_699_n2 n_699_x n_698 vss vss sky130_fd_pr__nfet_01v8 W=0.84 L=0.15
Xn_700_p1 n_700 n_696 vdd vdd sky130_fd_pr__pfet_01v8 W=0.7 L=0.15
Xn_700_p2 n_700 n_699 vdd vdd sky130_fd_pr__pfet_01v8 W=0.7 L=0.15
Xn_700_n1 n_700 n_696 n_700_x vss sky130_fd_pr__nfet_01v8 W=0.84 L=0.15
Xn_700_n2 n_700_x n_699 vss vss sky130_fd_pr__nfet_01v8 W=0.84 L=0.15
Xn_701_p1 n_701 n_307 vdd vdd sky130_fd_pr__pfet_01v8 W=0.7 L=0.15
Xn_701_p2 n_701 n_700 vdd vdd sky130_fd_pr__pfet_01v8 W=0.7 L=0.15
Xn_701_n1 n_701 n_307 n_701_x vss sky130_fd_pr__nfet_01v8 W=0.84 L=0.15
Xn_701_n2 n_701_x n_700 vss vss sky130_fd_pr__nfet_01v8 W=0.84 L=0.15
Xn_702_n n_702 n_701 vss vss sky130_fd_pr__nfet_01v8 W=0.42 L=0.15
Xn_702_p n_702 n_701 vdd vdd sky130_fd_pr__pfet_01v8 W=0.7 L=0.15
Xn_703_p1 n_703 n_344 vdd vdd sky130_fd_pr__pfet_01v8 W=0.7 L=0.15
Xn_703_p2 n_703 n_702 vdd vdd sky130_fd_pr__pfet_01v8 W=0.7 L=0.15
Xn_703_n1 n_703 n_344 n_703_x vss sky130_fd_pr__nfet_01v8 W=0.84 L=0.15
Xn_703_n2 n_703_x n_702 vss vss sky130_fd_pr__nfet_01v8 W=0.84 L=0.15
Xn_704_p1 n_704 n_495 vdd vdd sky130_fd_pr__pfet_01v8 W=0.7 L=0.15
Xn_704_p2 n_704 env4 vdd vdd sky130_fd_pr__pfet_01v8 W=0.7 L=0.15
Xn_704_n1 n_704 n_495 n_704_x vss sky130_fd_pr__nfet_01v8 W=0.84 L=0.15
Xn_704_n2 n_704_x env4 vss vss sky130_fd_pr__nfet_01v8 W=0.84 L=0.15
Xn_705_p1 n_705 n_703 vdd vdd sky130_fd_pr__pfet_01v8 W=0.7 L=0.15
Xn_705_p2 n_705 n_704 vdd vdd sky130_fd_pr__pfet_01v8 W=0.7 L=0.15
Xn_705_n1 n_705 n_703 n_705_x vss sky130_fd_pr__nfet_01v8 W=0.84 L=0.15
Xn_705_n2 n_705_x n_704 vss vss sky130_fd_pr__nfet_01v8 W=0.84 L=0.15
Xn_706_n n_706 n_705 vss vss sky130_fd_pr__nfet_01v8 W=0.42 L=0.15
Xn_706_p n_706 n_705 vdd vdd sky130_fd_pr__pfet_01v8 W=0.7 L=0.15
Xn_707_p1 n_707 n_705 n_707_x vdd sky130_fd_pr__pfet_01v8 W=1.4 L=0.15
Xn_707_p2 n_707_x n_106 vdd vdd sky130_fd_pr__pfet_01v8 W=1.4 L=0.15
Xn_707_n1 n_707 n_705 vss vss sky130_fd_pr__nfet_01v8 W=0.42 L=0.15
Xn_707_n2 n_707 n_106 vss vss sky130_fd_pr__nfet_01v8 W=0.42 L=0.15
Xn_708_p1 n_708 n_707 n_708_x vdd sky130_fd_pr__pfet_01v8 W=1.4 L=0.15
Xn_708_p2 n_708_x n_4 vdd vdd sky130_fd_pr__pfet_01v8 W=1.4 L=0.15
Xn_708_n1 n_708 n_707 vss vss sky130_fd_pr__nfet_01v8 W=0.42 L=0.15
Xn_708_n2 n_708 n_4 vss vss sky130_fd_pr__nfet_01v8 W=0.42 L=0.15
Xn_709_n n_709 n_708 vss vss sky130_fd_pr__nfet_01v8 W=0.42 L=0.15
Xn_709_p n_709 n_708 vdd vdd sky130_fd_pr__pfet_01v8 W=0.7 L=0.15
Xn_712_p1 n_712 n_706 n_712_x vdd sky130_fd_pr__pfet_01v8 W=1.4 L=0.15
Xn_712_p2 n_712_x n_106 vdd vdd sky130_fd_pr__pfet_01v8 W=1.4 L=0.15
Xn_712_n1 n_712 n_706 vss vss sky130_fd_pr__nfet_01v8 W=0.42 L=0.15
Xn_712_n2 n_712 n_106 vss vss sky130_fd_pr__nfet_01v8 W=0.42 L=0.15
Xn_711_p1 n_711 n_712 n_711_x vdd sky130_fd_pr__pfet_01v8 W=1.4 L=0.15
Xn_711_p2 n_711_x n_710 vdd vdd sky130_fd_pr__pfet_01v8 W=1.4 L=0.15
Xn_711_n1 n_711 n_712 vss vss sky130_fd_pr__nfet_01v8 W=0.42 L=0.15
Xn_711_n2 n_711 n_710 vss vss sky130_fd_pr__nfet_01v8 W=0.42 L=0.15
Xn_710_p1 n_710 n_709 n_710_x vdd sky130_fd_pr__pfet_01v8 W=1.4 L=0.15
Xn_710_p2 n_710_x n_711 vdd vdd sky130_fd_pr__pfet_01v8 W=1.4 L=0.15
Xn_710_n1 n_710 n_709 vss vss sky130_fd_pr__nfet_01v8 W=0.42 L=0.15
Xn_710_n2 n_710 n_711 vss vss sky130_fd_pr__nfet_01v8 W=0.42 L=0.15
Xn_713_p1 n_713 n_710 n_713_x vdd sky130_fd_pr__pfet_01v8 W=1.4 L=0.15
Xn_713_p2 n_713_x n_109 vdd vdd sky130_fd_pr__pfet_01v8 W=1.4 L=0.15
Xn_713_n1 n_713 n_710 vss vss sky130_fd_pr__nfet_01v8 W=0.42 L=0.15
Xn_713_n2 n_713 n_109 vss vss sky130_fd_pr__nfet_01v8 W=0.42 L=0.15
Xn_714_p1 n_714 n_713 n_714_x vdd sky130_fd_pr__pfet_01v8 W=1.4 L=0.15
Xn_714_p2 n_714_x n_4 vdd vdd sky130_fd_pr__pfet_01v8 W=1.4 L=0.15
Xn_714_n1 n_714 n_713 vss vss sky130_fd_pr__nfet_01v8 W=0.42 L=0.15
Xn_714_n2 n_714 n_4 vss vss sky130_fd_pr__nfet_01v8 W=0.42 L=0.15
Xn_715_n n_715 n_714 vss vss sky130_fd_pr__nfet_01v8 W=0.42 L=0.15
Xn_715_p n_715 n_714 vdd vdd sky130_fd_pr__pfet_01v8 W=0.7 L=0.15
Xn_717_p1 n_717 n_711 n_717_x vdd sky130_fd_pr__pfet_01v8 W=1.4 L=0.15
Xn_717_p2 n_717_x n_109 vdd vdd sky130_fd_pr__pfet_01v8 W=1.4 L=0.15
Xn_717_n1 n_717 n_711 vss vss sky130_fd_pr__nfet_01v8 W=0.42 L=0.15
Xn_717_n2 n_717 n_109 vss vss sky130_fd_pr__nfet_01v8 W=0.42 L=0.15
Xn_716_p1 n_716 n_717 n_716_x vdd sky130_fd_pr__pfet_01v8 W=1.4 L=0.15
Xn_716_p2 n_716_x env4 vdd vdd sky130_fd_pr__pfet_01v8 W=1.4 L=0.15
Xn_716_n1 n_716 n_717 vss vss sky130_fd_pr__nfet_01v8 W=0.42 L=0.15
Xn_716_n2 n_716 env4 vss vss sky130_fd_pr__nfet_01v8 W=0.42 L=0.15
Xenv4_p1 env4 n_715 env4_x vdd sky130_fd_pr__pfet_01v8 W=1.4 L=0.15
Xenv4_p2 env4_x n_716 vdd vdd sky130_fd_pr__pfet_01v8 W=1.4 L=0.15
Xenv4_n1 env4 n_715 vss vss sky130_fd_pr__nfet_01v8 W=0.42 L=0.15
Xenv4_n2 env4 n_716 vss vss sky130_fd_pr__nfet_01v8 W=0.42 L=0.15
Xn_718_n n_718 env4 vss vss sky130_fd_pr__nfet_01v8 W=0.42 L=0.15
Xn_718_p n_718 env4 vdd vdd sky130_fd_pr__pfet_01v8 W=0.7 L=0.15
Xn_719_p1 n_719 env4 vdd vdd sky130_fd_pr__pfet_01v8 W=0.7 L=0.15
Xn_719_p2 n_719 t_ck vdd vdd sky130_fd_pr__pfet_01v8 W=0.7 L=0.15
Xn_719_n1 n_719 env4 n_719_x vss sky130_fd_pr__nfet_01v8 W=0.84 L=0.15
Xn_719_n2 n_719_x t_ck vss vss sky130_fd_pr__nfet_01v8 W=0.84 L=0.15
Xn_720_n n_720 n_719 vss vss sky130_fd_pr__nfet_01v8 W=0.42 L=0.15
Xn_720_p n_720 n_719 vdd vdd sky130_fd_pr__pfet_01v8 W=0.7 L=0.15
Xn_721_p1 n_721 n_718 vdd vdd sky130_fd_pr__pfet_01v8 W=0.7 L=0.15
Xn_721_p2 n_721 t_ck vdd vdd sky130_fd_pr__pfet_01v8 W=0.7 L=0.15
Xn_721_n1 n_721 n_718 n_721_x vss sky130_fd_pr__nfet_01v8 W=0.84 L=0.15
Xn_721_n2 n_721_x t_ck vss vss sky130_fd_pr__nfet_01v8 W=0.84 L=0.15
Xn_722_n n_722 n_721 vss vss sky130_fd_pr__nfet_01v8 W=0.42 L=0.15
Xn_722_p n_722 n_721 vdd vdd sky130_fd_pr__pfet_01v8 W=0.7 L=0.15
Xn_723_p1 n_723 n_722 n_723_x vdd sky130_fd_pr__pfet_01v8 W=1.4 L=0.15
Xn_723_p2 n_723_x n_4 vdd vdd sky130_fd_pr__pfet_01v8 W=1.4 L=0.15
Xn_723_n1 n_723 n_722 vss vss sky130_fd_pr__nfet_01v8 W=0.42 L=0.15
Xn_723_n2 n_723 n_4 vss vss sky130_fd_pr__nfet_01v8 W=0.42 L=0.15
Xn_724_n n_724 n_723 vss vss sky130_fd_pr__nfet_01v8 W=0.42 L=0.15
Xn_724_p n_724 n_723 vdd vdd sky130_fd_pr__pfet_01v8 W=0.7 L=0.15
Xn_726_p1 n_726 n_720 n_726_x vdd sky130_fd_pr__pfet_01v8 W=1.4 L=0.15
Xn_726_p2 n_726_x n_725 vdd vdd sky130_fd_pr__pfet_01v8 W=1.4 L=0.15
Xn_726_n1 n_726 n_720 vss vss sky130_fd_pr__nfet_01v8 W=0.42 L=0.15
Xn_726_n2 n_726 n_725 vss vss sky130_fd_pr__nfet_01v8 W=0.42 L=0.15
Xn_725_p1 n_725 n_724 n_725_x vdd sky130_fd_pr__pfet_01v8 W=1.4 L=0.15
Xn_725_p2 n_725_x n_726 vdd vdd sky130_fd_pr__pfet_01v8 W=1.4 L=0.15
Xn_725_n1 n_725 n_724 vss vss sky130_fd_pr__nfet_01v8 W=0.42 L=0.15
Xn_725_n2 n_725 n_726 vss vss sky130_fd_pr__nfet_01v8 W=0.42 L=0.15
Xn_727_n n_727 x_neg4 vss vss sky130_fd_pr__nfet_01v8 W=0.42 L=0.15
Xn_727_p n_727 x_neg4 vdd vdd sky130_fd_pr__pfet_01v8 W=0.7 L=0.15
Xn_728_p1 n_728 n_725 vdd vdd sky130_fd_pr__pfet_01v8 W=0.7 L=0.15
Xn_728_p2 n_728 n_727 vdd vdd sky130_fd_pr__pfet_01v8 W=0.7 L=0.15
Xn_728_n1 n_728 n_725 n_728_x vss sky130_fd_pr__nfet_01v8 W=0.84 L=0.15
Xn_728_n2 n_728_x n_727 vss vss sky130_fd_pr__nfet_01v8 W=0.84 L=0.15
Xxin_p_r4_n xin_p_r4 n_728 vss vss sky130_fd_pr__nfet_01v8 W=0.42 L=0.15
Xxin_p_r4_p xin_p_r4 n_728 vdd vdd sky130_fd_pr__pfet_01v8 W=0.7 L=0.15
Xn_729_p1 n_729 n_725 vdd vdd sky130_fd_pr__pfet_01v8 W=0.7 L=0.15
Xn_729_p2 n_729 x_neg4 vdd vdd sky130_fd_pr__pfet_01v8 W=0.7 L=0.15
Xn_729_n1 n_729 n_725 n_729_x vss sky130_fd_pr__nfet_01v8 W=0.84 L=0.15
Xn_729_n2 n_729_x x_neg4 vss vss sky130_fd_pr__nfet_01v8 W=0.84 L=0.15
Xxin_n_r4_n xin_n_r4 n_729 vss vss sky130_fd_pr__nfet_01v8 W=0.42 L=0.15
Xxin_n_r4_p xin_n_r4 n_729 vdd vdd sky130_fd_pr__pfet_01v8 W=0.7 L=0.15
Xn_730_p1 n_730 n_725 vdd vdd sky130_fd_pr__pfet_01v8 W=0.7 L=0.15
Xn_730_p2 n_730 lora_en vdd vdd sky130_fd_pr__pfet_01v8 W=0.7 L=0.15
Xn_730_n1 n_730 n_725 n_730_x vss sky130_fd_pr__nfet_01v8 W=0.84 L=0.15
Xn_730_n2 n_730_x lora_en vss vss sky130_fd_pr__nfet_01v8 W=0.84 L=0.15
Xxrd_en4_n xrd_en4 n_730 vss vss sky130_fd_pr__nfet_01v8 W=0.42 L=0.15
Xxrd_en4_p xrd_en4 n_730 vdd vdd sky130_fd_pr__pfet_01v8 W=0.7 L=0.15
Xn_731_p1 n_731 n_491 vdd vdd sky130_fd_pr__pfet_01v8 W=0.7 L=0.15
Xn_731_p2 n_731 x_mag20 vdd vdd sky130_fd_pr__pfet_01v8 W=0.7 L=0.15
Xn_731_n1 n_731 n_491 n_731_x vss sky130_fd_pr__nfet_01v8 W=0.84 L=0.15
Xn_731_n2 n_731_x x_mag20 vss vss sky130_fd_pr__nfet_01v8 W=0.84 L=0.15
Xn_732_n n_732 n_731 vss vss sky130_fd_pr__nfet_01v8 W=0.42 L=0.15
Xn_732_p n_732 n_731 vdd vdd sky130_fd_pr__pfet_01v8 W=0.7 L=0.15
Xn_733_p1 n_733 n_492 vdd vdd sky130_fd_pr__pfet_01v8 W=0.7 L=0.15
Xn_733_p2 n_733 x_mag21 vdd vdd sky130_fd_pr__pfet_01v8 W=0.7 L=0.15
Xn_733_n1 n_733 n_492 n_733_x vss sky130_fd_pr__nfet_01v8 W=0.84 L=0.15
Xn_733_n2 n_733_x x_mag21 vss vss sky130_fd_pr__nfet_01v8 W=0.84 L=0.15
Xn_734_p1 n_734 n_492 n_734_x vdd sky130_fd_pr__pfet_01v8 W=1.4 L=0.15
Xn_734_p2 n_734_x x_mag21 vdd vdd sky130_fd_pr__pfet_01v8 W=1.4 L=0.15
Xn_734_n1 n_734 n_492 vss vss sky130_fd_pr__nfet_01v8 W=0.42 L=0.15
Xn_734_n2 n_734 x_mag21 vss vss sky130_fd_pr__nfet_01v8 W=0.42 L=0.15
Xn_735_n n_735 n_734 vss vss sky130_fd_pr__nfet_01v8 W=0.42 L=0.15
Xn_735_p n_735 n_734 vdd vdd sky130_fd_pr__pfet_01v8 W=0.7 L=0.15
Xn_736_p1 n_736 n_732 vdd vdd sky130_fd_pr__pfet_01v8 W=0.7 L=0.15
Xn_736_p2 n_736 n_735 vdd vdd sky130_fd_pr__pfet_01v8 W=0.7 L=0.15
Xn_736_n1 n_736 n_732 n_736_x vss sky130_fd_pr__nfet_01v8 W=0.84 L=0.15
Xn_736_n2 n_736_x n_735 vss vss sky130_fd_pr__nfet_01v8 W=0.84 L=0.15
Xn_737_p1 n_737 n_733 vdd vdd sky130_fd_pr__pfet_01v8 W=0.7 L=0.15
Xn_737_p2 n_737 n_736 vdd vdd sky130_fd_pr__pfet_01v8 W=0.7 L=0.15
Xn_737_n1 n_737 n_733 n_737_x vss sky130_fd_pr__nfet_01v8 W=0.84 L=0.15
Xn_737_n2 n_737_x n_736 vss vss sky130_fd_pr__nfet_01v8 W=0.84 L=0.15
Xn_738_p1 n_738 n_493 vdd vdd sky130_fd_pr__pfet_01v8 W=0.7 L=0.15
Xn_738_p2 n_738 x_mag22 vdd vdd sky130_fd_pr__pfet_01v8 W=0.7 L=0.15
Xn_738_n1 n_738 n_493 n_738_x vss sky130_fd_pr__nfet_01v8 W=0.84 L=0.15
Xn_738_n2 n_738_x x_mag22 vss vss sky130_fd_pr__nfet_01v8 W=0.84 L=0.15
Xn_739_p1 n_739 n_493 n_739_x vdd sky130_fd_pr__pfet_01v8 W=1.4 L=0.15
Xn_739_p2 n_739_x x_mag22 vdd vdd sky130_fd_pr__pfet_01v8 W=1.4 L=0.15
Xn_739_n1 n_739 n_493 vss vss sky130_fd_pr__nfet_01v8 W=0.42 L=0.15
Xn_739_n2 n_739 x_mag22 vss vss sky130_fd_pr__nfet_01v8 W=0.42 L=0.15
Xn_740_n n_740 n_739 vss vss sky130_fd_pr__nfet_01v8 W=0.42 L=0.15
Xn_740_p n_740 n_739 vdd vdd sky130_fd_pr__pfet_01v8 W=0.7 L=0.15
Xn_741_p1 n_741 n_737 vdd vdd sky130_fd_pr__pfet_01v8 W=0.7 L=0.15
Xn_741_p2 n_741 n_740 vdd vdd sky130_fd_pr__pfet_01v8 W=0.7 L=0.15
Xn_741_n1 n_741 n_737 n_741_x vss sky130_fd_pr__nfet_01v8 W=0.84 L=0.15
Xn_741_n2 n_741_x n_740 vss vss sky130_fd_pr__nfet_01v8 W=0.84 L=0.15
Xn_742_p1 n_742 n_738 vdd vdd sky130_fd_pr__pfet_01v8 W=0.7 L=0.15
Xn_742_p2 n_742 n_741 vdd vdd sky130_fd_pr__pfet_01v8 W=0.7 L=0.15
Xn_742_n1 n_742 n_738 n_742_x vss sky130_fd_pr__nfet_01v8 W=0.84 L=0.15
Xn_742_n2 n_742_x n_741 vss vss sky130_fd_pr__nfet_01v8 W=0.84 L=0.15
Xn_743_p1 n_743 n_494 vdd vdd sky130_fd_pr__pfet_01v8 W=0.7 L=0.15
Xn_743_p2 n_743 x_mag23 vdd vdd sky130_fd_pr__pfet_01v8 W=0.7 L=0.15
Xn_743_n1 n_743 n_494 n_743_x vss sky130_fd_pr__nfet_01v8 W=0.84 L=0.15
Xn_743_n2 n_743_x x_mag23 vss vss sky130_fd_pr__nfet_01v8 W=0.84 L=0.15
Xn_744_p1 n_744 n_494 n_744_x vdd sky130_fd_pr__pfet_01v8 W=1.4 L=0.15
Xn_744_p2 n_744_x x_mag23 vdd vdd sky130_fd_pr__pfet_01v8 W=1.4 L=0.15
Xn_744_n1 n_744 n_494 vss vss sky130_fd_pr__nfet_01v8 W=0.42 L=0.15
Xn_744_n2 n_744 x_mag23 vss vss sky130_fd_pr__nfet_01v8 W=0.42 L=0.15
Xn_745_n n_745 n_744 vss vss sky130_fd_pr__nfet_01v8 W=0.42 L=0.15
Xn_745_p n_745 n_744 vdd vdd sky130_fd_pr__pfet_01v8 W=0.7 L=0.15
Xn_746_p1 n_746 n_742 vdd vdd sky130_fd_pr__pfet_01v8 W=0.7 L=0.15
Xn_746_p2 n_746 n_745 vdd vdd sky130_fd_pr__pfet_01v8 W=0.7 L=0.15
Xn_746_n1 n_746 n_742 n_746_x vss sky130_fd_pr__nfet_01v8 W=0.84 L=0.15
Xn_746_n2 n_746_x n_745 vss vss sky130_fd_pr__nfet_01v8 W=0.84 L=0.15
Xn_747_p1 n_747 n_743 vdd vdd sky130_fd_pr__pfet_01v8 W=0.7 L=0.15
Xn_747_p2 n_747 n_746 vdd vdd sky130_fd_pr__pfet_01v8 W=0.7 L=0.15
Xn_747_n1 n_747 n_743 n_747_x vss sky130_fd_pr__nfet_01v8 W=0.84 L=0.15
Xn_747_n2 n_747_x n_746 vss vss sky130_fd_pr__nfet_01v8 W=0.84 L=0.15
Xn_748_p1 n_748 n_307 vdd vdd sky130_fd_pr__pfet_01v8 W=0.7 L=0.15
Xn_748_p2 n_748 n_747 vdd vdd sky130_fd_pr__pfet_01v8 W=0.7 L=0.15
Xn_748_n1 n_748 n_307 n_748_x vss sky130_fd_pr__nfet_01v8 W=0.84 L=0.15
Xn_748_n2 n_748_x n_747 vss vss sky130_fd_pr__nfet_01v8 W=0.84 L=0.15
Xn_749_n n_749 n_748 vss vss sky130_fd_pr__nfet_01v8 W=0.42 L=0.15
Xn_749_p n_749 n_748 vdd vdd sky130_fd_pr__pfet_01v8 W=0.7 L=0.15
Xn_750_p1 n_750 n_344 vdd vdd sky130_fd_pr__pfet_01v8 W=0.7 L=0.15
Xn_750_p2 n_750 n_749 vdd vdd sky130_fd_pr__pfet_01v8 W=0.7 L=0.15
Xn_750_n1 n_750 n_344 n_750_x vss sky130_fd_pr__nfet_01v8 W=0.84 L=0.15
Xn_750_n2 n_750_x n_749 vss vss sky130_fd_pr__nfet_01v8 W=0.84 L=0.15
Xn_751_p1 n_751 n_495 vdd vdd sky130_fd_pr__pfet_01v8 W=0.7 L=0.15
Xn_751_p2 n_751 env5 vdd vdd sky130_fd_pr__pfet_01v8 W=0.7 L=0.15
Xn_751_n1 n_751 n_495 n_751_x vss sky130_fd_pr__nfet_01v8 W=0.84 L=0.15
Xn_751_n2 n_751_x env5 vss vss sky130_fd_pr__nfet_01v8 W=0.84 L=0.15
Xn_752_p1 n_752 n_750 vdd vdd sky130_fd_pr__pfet_01v8 W=0.7 L=0.15
Xn_752_p2 n_752 n_751 vdd vdd sky130_fd_pr__pfet_01v8 W=0.7 L=0.15
Xn_752_n1 n_752 n_750 n_752_x vss sky130_fd_pr__nfet_01v8 W=0.84 L=0.15
Xn_752_n2 n_752_x n_751 vss vss sky130_fd_pr__nfet_01v8 W=0.84 L=0.15
Xn_753_n n_753 n_752 vss vss sky130_fd_pr__nfet_01v8 W=0.42 L=0.15
Xn_753_p n_753 n_752 vdd vdd sky130_fd_pr__pfet_01v8 W=0.7 L=0.15
Xn_754_p1 n_754 n_752 n_754_x vdd sky130_fd_pr__pfet_01v8 W=1.4 L=0.15
Xn_754_p2 n_754_x n_106 vdd vdd sky130_fd_pr__pfet_01v8 W=1.4 L=0.15
Xn_754_n1 n_754 n_752 vss vss sky130_fd_pr__nfet_01v8 W=0.42 L=0.15
Xn_754_n2 n_754 n_106 vss vss sky130_fd_pr__nfet_01v8 W=0.42 L=0.15
Xn_755_p1 n_755 n_754 n_755_x vdd sky130_fd_pr__pfet_01v8 W=1.4 L=0.15
Xn_755_p2 n_755_x n_4 vdd vdd sky130_fd_pr__pfet_01v8 W=1.4 L=0.15
Xn_755_n1 n_755 n_754 vss vss sky130_fd_pr__nfet_01v8 W=0.42 L=0.15
Xn_755_n2 n_755 n_4 vss vss sky130_fd_pr__nfet_01v8 W=0.42 L=0.15
Xn_756_n n_756 n_755 vss vss sky130_fd_pr__nfet_01v8 W=0.42 L=0.15
Xn_756_p n_756 n_755 vdd vdd sky130_fd_pr__pfet_01v8 W=0.7 L=0.15
Xn_759_p1 n_759 n_753 n_759_x vdd sky130_fd_pr__pfet_01v8 W=1.4 L=0.15
Xn_759_p2 n_759_x n_106 vdd vdd sky130_fd_pr__pfet_01v8 W=1.4 L=0.15
Xn_759_n1 n_759 n_753 vss vss sky130_fd_pr__nfet_01v8 W=0.42 L=0.15
Xn_759_n2 n_759 n_106 vss vss sky130_fd_pr__nfet_01v8 W=0.42 L=0.15
Xn_758_p1 n_758 n_759 n_758_x vdd sky130_fd_pr__pfet_01v8 W=1.4 L=0.15
Xn_758_p2 n_758_x n_757 vdd vdd sky130_fd_pr__pfet_01v8 W=1.4 L=0.15
Xn_758_n1 n_758 n_759 vss vss sky130_fd_pr__nfet_01v8 W=0.42 L=0.15
Xn_758_n2 n_758 n_757 vss vss sky130_fd_pr__nfet_01v8 W=0.42 L=0.15
Xn_757_p1 n_757 n_756 n_757_x vdd sky130_fd_pr__pfet_01v8 W=1.4 L=0.15
Xn_757_p2 n_757_x n_758 vdd vdd sky130_fd_pr__pfet_01v8 W=1.4 L=0.15
Xn_757_n1 n_757 n_756 vss vss sky130_fd_pr__nfet_01v8 W=0.42 L=0.15
Xn_757_n2 n_757 n_758 vss vss sky130_fd_pr__nfet_01v8 W=0.42 L=0.15
Xn_760_p1 n_760 n_757 n_760_x vdd sky130_fd_pr__pfet_01v8 W=1.4 L=0.15
Xn_760_p2 n_760_x n_109 vdd vdd sky130_fd_pr__pfet_01v8 W=1.4 L=0.15
Xn_760_n1 n_760 n_757 vss vss sky130_fd_pr__nfet_01v8 W=0.42 L=0.15
Xn_760_n2 n_760 n_109 vss vss sky130_fd_pr__nfet_01v8 W=0.42 L=0.15
Xn_761_p1 n_761 n_760 n_761_x vdd sky130_fd_pr__pfet_01v8 W=1.4 L=0.15
Xn_761_p2 n_761_x n_4 vdd vdd sky130_fd_pr__pfet_01v8 W=1.4 L=0.15
Xn_761_n1 n_761 n_760 vss vss sky130_fd_pr__nfet_01v8 W=0.42 L=0.15
Xn_761_n2 n_761 n_4 vss vss sky130_fd_pr__nfet_01v8 W=0.42 L=0.15
Xn_762_n n_762 n_761 vss vss sky130_fd_pr__nfet_01v8 W=0.42 L=0.15
Xn_762_p n_762 n_761 vdd vdd sky130_fd_pr__pfet_01v8 W=0.7 L=0.15
Xn_764_p1 n_764 n_758 n_764_x vdd sky130_fd_pr__pfet_01v8 W=1.4 L=0.15
Xn_764_p2 n_764_x n_109 vdd vdd sky130_fd_pr__pfet_01v8 W=1.4 L=0.15
Xn_764_n1 n_764 n_758 vss vss sky130_fd_pr__nfet_01v8 W=0.42 L=0.15
Xn_764_n2 n_764 n_109 vss vss sky130_fd_pr__nfet_01v8 W=0.42 L=0.15
Xn_763_p1 n_763 n_764 n_763_x vdd sky130_fd_pr__pfet_01v8 W=1.4 L=0.15
Xn_763_p2 n_763_x env5 vdd vdd sky130_fd_pr__pfet_01v8 W=1.4 L=0.15
Xn_763_n1 n_763 n_764 vss vss sky130_fd_pr__nfet_01v8 W=0.42 L=0.15
Xn_763_n2 n_763 env5 vss vss sky130_fd_pr__nfet_01v8 W=0.42 L=0.15
Xenv5_p1 env5 n_762 env5_x vdd sky130_fd_pr__pfet_01v8 W=1.4 L=0.15
Xenv5_p2 env5_x n_763 vdd vdd sky130_fd_pr__pfet_01v8 W=1.4 L=0.15
Xenv5_n1 env5 n_762 vss vss sky130_fd_pr__nfet_01v8 W=0.42 L=0.15
Xenv5_n2 env5 n_763 vss vss sky130_fd_pr__nfet_01v8 W=0.42 L=0.15
Xn_765_n n_765 env5 vss vss sky130_fd_pr__nfet_01v8 W=0.42 L=0.15
Xn_765_p n_765 env5 vdd vdd sky130_fd_pr__pfet_01v8 W=0.7 L=0.15
Xn_766_p1 n_766 env5 vdd vdd sky130_fd_pr__pfet_01v8 W=0.7 L=0.15
Xn_766_p2 n_766 t_ck vdd vdd sky130_fd_pr__pfet_01v8 W=0.7 L=0.15
Xn_766_n1 n_766 env5 n_766_x vss sky130_fd_pr__nfet_01v8 W=0.84 L=0.15
Xn_766_n2 n_766_x t_ck vss vss sky130_fd_pr__nfet_01v8 W=0.84 L=0.15
Xn_767_n n_767 n_766 vss vss sky130_fd_pr__nfet_01v8 W=0.42 L=0.15
Xn_767_p n_767 n_766 vdd vdd sky130_fd_pr__pfet_01v8 W=0.7 L=0.15
Xn_768_p1 n_768 n_765 vdd vdd sky130_fd_pr__pfet_01v8 W=0.7 L=0.15
Xn_768_p2 n_768 t_ck vdd vdd sky130_fd_pr__pfet_01v8 W=0.7 L=0.15
Xn_768_n1 n_768 n_765 n_768_x vss sky130_fd_pr__nfet_01v8 W=0.84 L=0.15
Xn_768_n2 n_768_x t_ck vss vss sky130_fd_pr__nfet_01v8 W=0.84 L=0.15
Xn_769_n n_769 n_768 vss vss sky130_fd_pr__nfet_01v8 W=0.42 L=0.15
Xn_769_p n_769 n_768 vdd vdd sky130_fd_pr__pfet_01v8 W=0.7 L=0.15
Xn_770_p1 n_770 n_769 n_770_x vdd sky130_fd_pr__pfet_01v8 W=1.4 L=0.15
Xn_770_p2 n_770_x n_4 vdd vdd sky130_fd_pr__pfet_01v8 W=1.4 L=0.15
Xn_770_n1 n_770 n_769 vss vss sky130_fd_pr__nfet_01v8 W=0.42 L=0.15
Xn_770_n2 n_770 n_4 vss vss sky130_fd_pr__nfet_01v8 W=0.42 L=0.15
Xn_771_n n_771 n_770 vss vss sky130_fd_pr__nfet_01v8 W=0.42 L=0.15
Xn_771_p n_771 n_770 vdd vdd sky130_fd_pr__pfet_01v8 W=0.7 L=0.15
Xn_773_p1 n_773 n_767 n_773_x vdd sky130_fd_pr__pfet_01v8 W=1.4 L=0.15
Xn_773_p2 n_773_x n_772 vdd vdd sky130_fd_pr__pfet_01v8 W=1.4 L=0.15
Xn_773_n1 n_773 n_767 vss vss sky130_fd_pr__nfet_01v8 W=0.42 L=0.15
Xn_773_n2 n_773 n_772 vss vss sky130_fd_pr__nfet_01v8 W=0.42 L=0.15
Xn_772_p1 n_772 n_771 n_772_x vdd sky130_fd_pr__pfet_01v8 W=1.4 L=0.15
Xn_772_p2 n_772_x n_773 vdd vdd sky130_fd_pr__pfet_01v8 W=1.4 L=0.15
Xn_772_n1 n_772 n_771 vss vss sky130_fd_pr__nfet_01v8 W=0.42 L=0.15
Xn_772_n2 n_772 n_773 vss vss sky130_fd_pr__nfet_01v8 W=0.42 L=0.15
Xn_774_n n_774 x_neg5 vss vss sky130_fd_pr__nfet_01v8 W=0.42 L=0.15
Xn_774_p n_774 x_neg5 vdd vdd sky130_fd_pr__pfet_01v8 W=0.7 L=0.15
Xn_775_p1 n_775 n_772 vdd vdd sky130_fd_pr__pfet_01v8 W=0.7 L=0.15
Xn_775_p2 n_775 n_774 vdd vdd sky130_fd_pr__pfet_01v8 W=0.7 L=0.15
Xn_775_n1 n_775 n_772 n_775_x vss sky130_fd_pr__nfet_01v8 W=0.84 L=0.15
Xn_775_n2 n_775_x n_774 vss vss sky130_fd_pr__nfet_01v8 W=0.84 L=0.15
Xxin_p_r5_n xin_p_r5 n_775 vss vss sky130_fd_pr__nfet_01v8 W=0.42 L=0.15
Xxin_p_r5_p xin_p_r5 n_775 vdd vdd sky130_fd_pr__pfet_01v8 W=0.7 L=0.15
Xn_776_p1 n_776 n_772 vdd vdd sky130_fd_pr__pfet_01v8 W=0.7 L=0.15
Xn_776_p2 n_776 x_neg5 vdd vdd sky130_fd_pr__pfet_01v8 W=0.7 L=0.15
Xn_776_n1 n_776 n_772 n_776_x vss sky130_fd_pr__nfet_01v8 W=0.84 L=0.15
Xn_776_n2 n_776_x x_neg5 vss vss sky130_fd_pr__nfet_01v8 W=0.84 L=0.15
Xxin_n_r5_n xin_n_r5 n_776 vss vss sky130_fd_pr__nfet_01v8 W=0.42 L=0.15
Xxin_n_r5_p xin_n_r5 n_776 vdd vdd sky130_fd_pr__pfet_01v8 W=0.7 L=0.15
Xn_777_p1 n_777 n_772 vdd vdd sky130_fd_pr__pfet_01v8 W=0.7 L=0.15
Xn_777_p2 n_777 lora_en vdd vdd sky130_fd_pr__pfet_01v8 W=0.7 L=0.15
Xn_777_n1 n_777 n_772 n_777_x vss sky130_fd_pr__nfet_01v8 W=0.84 L=0.15
Xn_777_n2 n_777_x lora_en vss vss sky130_fd_pr__nfet_01v8 W=0.84 L=0.15
Xxrd_en5_n xrd_en5 n_777 vss vss sky130_fd_pr__nfet_01v8 W=0.42 L=0.15
Xxrd_en5_p xrd_en5 n_777 vdd vdd sky130_fd_pr__pfet_01v8 W=0.7 L=0.15
Xn_778_p1 n_778 n_491 vdd vdd sky130_fd_pr__pfet_01v8 W=0.7 L=0.15
Xn_778_p2 n_778 x_mag24 vdd vdd sky130_fd_pr__pfet_01v8 W=0.7 L=0.15
Xn_778_n1 n_778 n_491 n_778_x vss sky130_fd_pr__nfet_01v8 W=0.84 L=0.15
Xn_778_n2 n_778_x x_mag24 vss vss sky130_fd_pr__nfet_01v8 W=0.84 L=0.15
Xn_779_n n_779 n_778 vss vss sky130_fd_pr__nfet_01v8 W=0.42 L=0.15
Xn_779_p n_779 n_778 vdd vdd sky130_fd_pr__pfet_01v8 W=0.7 L=0.15
Xn_780_p1 n_780 n_492 vdd vdd sky130_fd_pr__pfet_01v8 W=0.7 L=0.15
Xn_780_p2 n_780 x_mag25 vdd vdd sky130_fd_pr__pfet_01v8 W=0.7 L=0.15
Xn_780_n1 n_780 n_492 n_780_x vss sky130_fd_pr__nfet_01v8 W=0.84 L=0.15
Xn_780_n2 n_780_x x_mag25 vss vss sky130_fd_pr__nfet_01v8 W=0.84 L=0.15
Xn_781_p1 n_781 n_492 n_781_x vdd sky130_fd_pr__pfet_01v8 W=1.4 L=0.15
Xn_781_p2 n_781_x x_mag25 vdd vdd sky130_fd_pr__pfet_01v8 W=1.4 L=0.15
Xn_781_n1 n_781 n_492 vss vss sky130_fd_pr__nfet_01v8 W=0.42 L=0.15
Xn_781_n2 n_781 x_mag25 vss vss sky130_fd_pr__nfet_01v8 W=0.42 L=0.15
Xn_782_n n_782 n_781 vss vss sky130_fd_pr__nfet_01v8 W=0.42 L=0.15
Xn_782_p n_782 n_781 vdd vdd sky130_fd_pr__pfet_01v8 W=0.7 L=0.15
Xn_783_p1 n_783 n_779 vdd vdd sky130_fd_pr__pfet_01v8 W=0.7 L=0.15
Xn_783_p2 n_783 n_782 vdd vdd sky130_fd_pr__pfet_01v8 W=0.7 L=0.15
Xn_783_n1 n_783 n_779 n_783_x vss sky130_fd_pr__nfet_01v8 W=0.84 L=0.15
Xn_783_n2 n_783_x n_782 vss vss sky130_fd_pr__nfet_01v8 W=0.84 L=0.15
Xn_784_p1 n_784 n_780 vdd vdd sky130_fd_pr__pfet_01v8 W=0.7 L=0.15
Xn_784_p2 n_784 n_783 vdd vdd sky130_fd_pr__pfet_01v8 W=0.7 L=0.15
Xn_784_n1 n_784 n_780 n_784_x vss sky130_fd_pr__nfet_01v8 W=0.84 L=0.15
Xn_784_n2 n_784_x n_783 vss vss sky130_fd_pr__nfet_01v8 W=0.84 L=0.15
Xn_785_p1 n_785 n_493 vdd vdd sky130_fd_pr__pfet_01v8 W=0.7 L=0.15
Xn_785_p2 n_785 x_mag26 vdd vdd sky130_fd_pr__pfet_01v8 W=0.7 L=0.15
Xn_785_n1 n_785 n_493 n_785_x vss sky130_fd_pr__nfet_01v8 W=0.84 L=0.15
Xn_785_n2 n_785_x x_mag26 vss vss sky130_fd_pr__nfet_01v8 W=0.84 L=0.15
Xn_786_p1 n_786 n_493 n_786_x vdd sky130_fd_pr__pfet_01v8 W=1.4 L=0.15
Xn_786_p2 n_786_x x_mag26 vdd vdd sky130_fd_pr__pfet_01v8 W=1.4 L=0.15
Xn_786_n1 n_786 n_493 vss vss sky130_fd_pr__nfet_01v8 W=0.42 L=0.15
Xn_786_n2 n_786 x_mag26 vss vss sky130_fd_pr__nfet_01v8 W=0.42 L=0.15
Xn_787_n n_787 n_786 vss vss sky130_fd_pr__nfet_01v8 W=0.42 L=0.15
Xn_787_p n_787 n_786 vdd vdd sky130_fd_pr__pfet_01v8 W=0.7 L=0.15
Xn_788_p1 n_788 n_784 vdd vdd sky130_fd_pr__pfet_01v8 W=0.7 L=0.15
Xn_788_p2 n_788 n_787 vdd vdd sky130_fd_pr__pfet_01v8 W=0.7 L=0.15
Xn_788_n1 n_788 n_784 n_788_x vss sky130_fd_pr__nfet_01v8 W=0.84 L=0.15
Xn_788_n2 n_788_x n_787 vss vss sky130_fd_pr__nfet_01v8 W=0.84 L=0.15
Xn_789_p1 n_789 n_785 vdd vdd sky130_fd_pr__pfet_01v8 W=0.7 L=0.15
Xn_789_p2 n_789 n_788 vdd vdd sky130_fd_pr__pfet_01v8 W=0.7 L=0.15
Xn_789_n1 n_789 n_785 n_789_x vss sky130_fd_pr__nfet_01v8 W=0.84 L=0.15
Xn_789_n2 n_789_x n_788 vss vss sky130_fd_pr__nfet_01v8 W=0.84 L=0.15
Xn_790_p1 n_790 n_494 vdd vdd sky130_fd_pr__pfet_01v8 W=0.7 L=0.15
Xn_790_p2 n_790 x_mag27 vdd vdd sky130_fd_pr__pfet_01v8 W=0.7 L=0.15
Xn_790_n1 n_790 n_494 n_790_x vss sky130_fd_pr__nfet_01v8 W=0.84 L=0.15
Xn_790_n2 n_790_x x_mag27 vss vss sky130_fd_pr__nfet_01v8 W=0.84 L=0.15
Xn_791_p1 n_791 n_494 n_791_x vdd sky130_fd_pr__pfet_01v8 W=1.4 L=0.15
Xn_791_p2 n_791_x x_mag27 vdd vdd sky130_fd_pr__pfet_01v8 W=1.4 L=0.15
Xn_791_n1 n_791 n_494 vss vss sky130_fd_pr__nfet_01v8 W=0.42 L=0.15
Xn_791_n2 n_791 x_mag27 vss vss sky130_fd_pr__nfet_01v8 W=0.42 L=0.15
Xn_792_n n_792 n_791 vss vss sky130_fd_pr__nfet_01v8 W=0.42 L=0.15
Xn_792_p n_792 n_791 vdd vdd sky130_fd_pr__pfet_01v8 W=0.7 L=0.15
Xn_793_p1 n_793 n_789 vdd vdd sky130_fd_pr__pfet_01v8 W=0.7 L=0.15
Xn_793_p2 n_793 n_792 vdd vdd sky130_fd_pr__pfet_01v8 W=0.7 L=0.15
Xn_793_n1 n_793 n_789 n_793_x vss sky130_fd_pr__nfet_01v8 W=0.84 L=0.15
Xn_793_n2 n_793_x n_792 vss vss sky130_fd_pr__nfet_01v8 W=0.84 L=0.15
Xn_794_p1 n_794 n_790 vdd vdd sky130_fd_pr__pfet_01v8 W=0.7 L=0.15
Xn_794_p2 n_794 n_793 vdd vdd sky130_fd_pr__pfet_01v8 W=0.7 L=0.15
Xn_794_n1 n_794 n_790 n_794_x vss sky130_fd_pr__nfet_01v8 W=0.84 L=0.15
Xn_794_n2 n_794_x n_793 vss vss sky130_fd_pr__nfet_01v8 W=0.84 L=0.15
Xn_795_p1 n_795 n_307 vdd vdd sky130_fd_pr__pfet_01v8 W=0.7 L=0.15
Xn_795_p2 n_795 n_794 vdd vdd sky130_fd_pr__pfet_01v8 W=0.7 L=0.15
Xn_795_n1 n_795 n_307 n_795_x vss sky130_fd_pr__nfet_01v8 W=0.84 L=0.15
Xn_795_n2 n_795_x n_794 vss vss sky130_fd_pr__nfet_01v8 W=0.84 L=0.15
Xn_796_n n_796 n_795 vss vss sky130_fd_pr__nfet_01v8 W=0.42 L=0.15
Xn_796_p n_796 n_795 vdd vdd sky130_fd_pr__pfet_01v8 W=0.7 L=0.15
Xn_797_p1 n_797 n_344 vdd vdd sky130_fd_pr__pfet_01v8 W=0.7 L=0.15
Xn_797_p2 n_797 n_796 vdd vdd sky130_fd_pr__pfet_01v8 W=0.7 L=0.15
Xn_797_n1 n_797 n_344 n_797_x vss sky130_fd_pr__nfet_01v8 W=0.84 L=0.15
Xn_797_n2 n_797_x n_796 vss vss sky130_fd_pr__nfet_01v8 W=0.84 L=0.15
Xn_798_p1 n_798 n_495 vdd vdd sky130_fd_pr__pfet_01v8 W=0.7 L=0.15
Xn_798_p2 n_798 env6 vdd vdd sky130_fd_pr__pfet_01v8 W=0.7 L=0.15
Xn_798_n1 n_798 n_495 n_798_x vss sky130_fd_pr__nfet_01v8 W=0.84 L=0.15
Xn_798_n2 n_798_x env6 vss vss sky130_fd_pr__nfet_01v8 W=0.84 L=0.15
Xn_799_p1 n_799 n_797 vdd vdd sky130_fd_pr__pfet_01v8 W=0.7 L=0.15
Xn_799_p2 n_799 n_798 vdd vdd sky130_fd_pr__pfet_01v8 W=0.7 L=0.15
Xn_799_n1 n_799 n_797 n_799_x vss sky130_fd_pr__nfet_01v8 W=0.84 L=0.15
Xn_799_n2 n_799_x n_798 vss vss sky130_fd_pr__nfet_01v8 W=0.84 L=0.15
Xn_800_n n_800 n_799 vss vss sky130_fd_pr__nfet_01v8 W=0.42 L=0.15
Xn_800_p n_800 n_799 vdd vdd sky130_fd_pr__pfet_01v8 W=0.7 L=0.15
Xn_801_p1 n_801 n_799 n_801_x vdd sky130_fd_pr__pfet_01v8 W=1.4 L=0.15
Xn_801_p2 n_801_x n_106 vdd vdd sky130_fd_pr__pfet_01v8 W=1.4 L=0.15
Xn_801_n1 n_801 n_799 vss vss sky130_fd_pr__nfet_01v8 W=0.42 L=0.15
Xn_801_n2 n_801 n_106 vss vss sky130_fd_pr__nfet_01v8 W=0.42 L=0.15
Xn_802_p1 n_802 n_801 n_802_x vdd sky130_fd_pr__pfet_01v8 W=1.4 L=0.15
Xn_802_p2 n_802_x n_4 vdd vdd sky130_fd_pr__pfet_01v8 W=1.4 L=0.15
Xn_802_n1 n_802 n_801 vss vss sky130_fd_pr__nfet_01v8 W=0.42 L=0.15
Xn_802_n2 n_802 n_4 vss vss sky130_fd_pr__nfet_01v8 W=0.42 L=0.15
Xn_803_n n_803 n_802 vss vss sky130_fd_pr__nfet_01v8 W=0.42 L=0.15
Xn_803_p n_803 n_802 vdd vdd sky130_fd_pr__pfet_01v8 W=0.7 L=0.15
Xn_806_p1 n_806 n_800 n_806_x vdd sky130_fd_pr__pfet_01v8 W=1.4 L=0.15
Xn_806_p2 n_806_x n_106 vdd vdd sky130_fd_pr__pfet_01v8 W=1.4 L=0.15
Xn_806_n1 n_806 n_800 vss vss sky130_fd_pr__nfet_01v8 W=0.42 L=0.15
Xn_806_n2 n_806 n_106 vss vss sky130_fd_pr__nfet_01v8 W=0.42 L=0.15
Xn_805_p1 n_805 n_806 n_805_x vdd sky130_fd_pr__pfet_01v8 W=1.4 L=0.15
Xn_805_p2 n_805_x n_804 vdd vdd sky130_fd_pr__pfet_01v8 W=1.4 L=0.15
Xn_805_n1 n_805 n_806 vss vss sky130_fd_pr__nfet_01v8 W=0.42 L=0.15
Xn_805_n2 n_805 n_804 vss vss sky130_fd_pr__nfet_01v8 W=0.42 L=0.15
Xn_804_p1 n_804 n_803 n_804_x vdd sky130_fd_pr__pfet_01v8 W=1.4 L=0.15
Xn_804_p2 n_804_x n_805 vdd vdd sky130_fd_pr__pfet_01v8 W=1.4 L=0.15
Xn_804_n1 n_804 n_803 vss vss sky130_fd_pr__nfet_01v8 W=0.42 L=0.15
Xn_804_n2 n_804 n_805 vss vss sky130_fd_pr__nfet_01v8 W=0.42 L=0.15
Xn_807_p1 n_807 n_804 n_807_x vdd sky130_fd_pr__pfet_01v8 W=1.4 L=0.15
Xn_807_p2 n_807_x n_109 vdd vdd sky130_fd_pr__pfet_01v8 W=1.4 L=0.15
Xn_807_n1 n_807 n_804 vss vss sky130_fd_pr__nfet_01v8 W=0.42 L=0.15
Xn_807_n2 n_807 n_109 vss vss sky130_fd_pr__nfet_01v8 W=0.42 L=0.15
Xn_808_p1 n_808 n_807 n_808_x vdd sky130_fd_pr__pfet_01v8 W=1.4 L=0.15
Xn_808_p2 n_808_x n_4 vdd vdd sky130_fd_pr__pfet_01v8 W=1.4 L=0.15
Xn_808_n1 n_808 n_807 vss vss sky130_fd_pr__nfet_01v8 W=0.42 L=0.15
Xn_808_n2 n_808 n_4 vss vss sky130_fd_pr__nfet_01v8 W=0.42 L=0.15
Xn_809_n n_809 n_808 vss vss sky130_fd_pr__nfet_01v8 W=0.42 L=0.15
Xn_809_p n_809 n_808 vdd vdd sky130_fd_pr__pfet_01v8 W=0.7 L=0.15
Xn_811_p1 n_811 n_805 n_811_x vdd sky130_fd_pr__pfet_01v8 W=1.4 L=0.15
Xn_811_p2 n_811_x n_109 vdd vdd sky130_fd_pr__pfet_01v8 W=1.4 L=0.15
Xn_811_n1 n_811 n_805 vss vss sky130_fd_pr__nfet_01v8 W=0.42 L=0.15
Xn_811_n2 n_811 n_109 vss vss sky130_fd_pr__nfet_01v8 W=0.42 L=0.15
Xn_810_p1 n_810 n_811 n_810_x vdd sky130_fd_pr__pfet_01v8 W=1.4 L=0.15
Xn_810_p2 n_810_x env6 vdd vdd sky130_fd_pr__pfet_01v8 W=1.4 L=0.15
Xn_810_n1 n_810 n_811 vss vss sky130_fd_pr__nfet_01v8 W=0.42 L=0.15
Xn_810_n2 n_810 env6 vss vss sky130_fd_pr__nfet_01v8 W=0.42 L=0.15
Xenv6_p1 env6 n_809 env6_x vdd sky130_fd_pr__pfet_01v8 W=1.4 L=0.15
Xenv6_p2 env6_x n_810 vdd vdd sky130_fd_pr__pfet_01v8 W=1.4 L=0.15
Xenv6_n1 env6 n_809 vss vss sky130_fd_pr__nfet_01v8 W=0.42 L=0.15
Xenv6_n2 env6 n_810 vss vss sky130_fd_pr__nfet_01v8 W=0.42 L=0.15
Xn_812_n n_812 env6 vss vss sky130_fd_pr__nfet_01v8 W=0.42 L=0.15
Xn_812_p n_812 env6 vdd vdd sky130_fd_pr__pfet_01v8 W=0.7 L=0.15
Xn_813_p1 n_813 env6 vdd vdd sky130_fd_pr__pfet_01v8 W=0.7 L=0.15
Xn_813_p2 n_813 t_ck vdd vdd sky130_fd_pr__pfet_01v8 W=0.7 L=0.15
Xn_813_n1 n_813 env6 n_813_x vss sky130_fd_pr__nfet_01v8 W=0.84 L=0.15
Xn_813_n2 n_813_x t_ck vss vss sky130_fd_pr__nfet_01v8 W=0.84 L=0.15
Xn_814_n n_814 n_813 vss vss sky130_fd_pr__nfet_01v8 W=0.42 L=0.15
Xn_814_p n_814 n_813 vdd vdd sky130_fd_pr__pfet_01v8 W=0.7 L=0.15
Xn_815_p1 n_815 n_812 vdd vdd sky130_fd_pr__pfet_01v8 W=0.7 L=0.15
Xn_815_p2 n_815 t_ck vdd vdd sky130_fd_pr__pfet_01v8 W=0.7 L=0.15
Xn_815_n1 n_815 n_812 n_815_x vss sky130_fd_pr__nfet_01v8 W=0.84 L=0.15
Xn_815_n2 n_815_x t_ck vss vss sky130_fd_pr__nfet_01v8 W=0.84 L=0.15
Xn_816_n n_816 n_815 vss vss sky130_fd_pr__nfet_01v8 W=0.42 L=0.15
Xn_816_p n_816 n_815 vdd vdd sky130_fd_pr__pfet_01v8 W=0.7 L=0.15
Xn_817_p1 n_817 n_816 n_817_x vdd sky130_fd_pr__pfet_01v8 W=1.4 L=0.15
Xn_817_p2 n_817_x n_4 vdd vdd sky130_fd_pr__pfet_01v8 W=1.4 L=0.15
Xn_817_n1 n_817 n_816 vss vss sky130_fd_pr__nfet_01v8 W=0.42 L=0.15
Xn_817_n2 n_817 n_4 vss vss sky130_fd_pr__nfet_01v8 W=0.42 L=0.15
Xn_818_n n_818 n_817 vss vss sky130_fd_pr__nfet_01v8 W=0.42 L=0.15
Xn_818_p n_818 n_817 vdd vdd sky130_fd_pr__pfet_01v8 W=0.7 L=0.15
Xn_820_p1 n_820 n_814 n_820_x vdd sky130_fd_pr__pfet_01v8 W=1.4 L=0.15
Xn_820_p2 n_820_x n_819 vdd vdd sky130_fd_pr__pfet_01v8 W=1.4 L=0.15
Xn_820_n1 n_820 n_814 vss vss sky130_fd_pr__nfet_01v8 W=0.42 L=0.15
Xn_820_n2 n_820 n_819 vss vss sky130_fd_pr__nfet_01v8 W=0.42 L=0.15
Xn_819_p1 n_819 n_818 n_819_x vdd sky130_fd_pr__pfet_01v8 W=1.4 L=0.15
Xn_819_p2 n_819_x n_820 vdd vdd sky130_fd_pr__pfet_01v8 W=1.4 L=0.15
Xn_819_n1 n_819 n_818 vss vss sky130_fd_pr__nfet_01v8 W=0.42 L=0.15
Xn_819_n2 n_819 n_820 vss vss sky130_fd_pr__nfet_01v8 W=0.42 L=0.15
Xn_821_n n_821 x_neg6 vss vss sky130_fd_pr__nfet_01v8 W=0.42 L=0.15
Xn_821_p n_821 x_neg6 vdd vdd sky130_fd_pr__pfet_01v8 W=0.7 L=0.15
Xn_822_p1 n_822 n_819 vdd vdd sky130_fd_pr__pfet_01v8 W=0.7 L=0.15
Xn_822_p2 n_822 n_821 vdd vdd sky130_fd_pr__pfet_01v8 W=0.7 L=0.15
Xn_822_n1 n_822 n_819 n_822_x vss sky130_fd_pr__nfet_01v8 W=0.84 L=0.15
Xn_822_n2 n_822_x n_821 vss vss sky130_fd_pr__nfet_01v8 W=0.84 L=0.15
Xxin_p_r6_n xin_p_r6 n_822 vss vss sky130_fd_pr__nfet_01v8 W=0.42 L=0.15
Xxin_p_r6_p xin_p_r6 n_822 vdd vdd sky130_fd_pr__pfet_01v8 W=0.7 L=0.15
Xn_823_p1 n_823 n_819 vdd vdd sky130_fd_pr__pfet_01v8 W=0.7 L=0.15
Xn_823_p2 n_823 x_neg6 vdd vdd sky130_fd_pr__pfet_01v8 W=0.7 L=0.15
Xn_823_n1 n_823 n_819 n_823_x vss sky130_fd_pr__nfet_01v8 W=0.84 L=0.15
Xn_823_n2 n_823_x x_neg6 vss vss sky130_fd_pr__nfet_01v8 W=0.84 L=0.15
Xxin_n_r6_n xin_n_r6 n_823 vss vss sky130_fd_pr__nfet_01v8 W=0.42 L=0.15
Xxin_n_r6_p xin_n_r6 n_823 vdd vdd sky130_fd_pr__pfet_01v8 W=0.7 L=0.15
Xn_824_p1 n_824 n_819 vdd vdd sky130_fd_pr__pfet_01v8 W=0.7 L=0.15
Xn_824_p2 n_824 lora_en vdd vdd sky130_fd_pr__pfet_01v8 W=0.7 L=0.15
Xn_824_n1 n_824 n_819 n_824_x vss sky130_fd_pr__nfet_01v8 W=0.84 L=0.15
Xn_824_n2 n_824_x lora_en vss vss sky130_fd_pr__nfet_01v8 W=0.84 L=0.15
Xxrd_en6_n xrd_en6 n_824 vss vss sky130_fd_pr__nfet_01v8 W=0.42 L=0.15
Xxrd_en6_p xrd_en6 n_824 vdd vdd sky130_fd_pr__pfet_01v8 W=0.7 L=0.15
Xn_825_p1 n_825 n_491 vdd vdd sky130_fd_pr__pfet_01v8 W=0.7 L=0.15
Xn_825_p2 n_825 x_mag28 vdd vdd sky130_fd_pr__pfet_01v8 W=0.7 L=0.15
Xn_825_n1 n_825 n_491 n_825_x vss sky130_fd_pr__nfet_01v8 W=0.84 L=0.15
Xn_825_n2 n_825_x x_mag28 vss vss sky130_fd_pr__nfet_01v8 W=0.84 L=0.15
Xn_826_n n_826 n_825 vss vss sky130_fd_pr__nfet_01v8 W=0.42 L=0.15
Xn_826_p n_826 n_825 vdd vdd sky130_fd_pr__pfet_01v8 W=0.7 L=0.15
Xn_827_p1 n_827 n_492 vdd vdd sky130_fd_pr__pfet_01v8 W=0.7 L=0.15
Xn_827_p2 n_827 x_mag29 vdd vdd sky130_fd_pr__pfet_01v8 W=0.7 L=0.15
Xn_827_n1 n_827 n_492 n_827_x vss sky130_fd_pr__nfet_01v8 W=0.84 L=0.15
Xn_827_n2 n_827_x x_mag29 vss vss sky130_fd_pr__nfet_01v8 W=0.84 L=0.15
Xn_828_p1 n_828 n_492 n_828_x vdd sky130_fd_pr__pfet_01v8 W=1.4 L=0.15
Xn_828_p2 n_828_x x_mag29 vdd vdd sky130_fd_pr__pfet_01v8 W=1.4 L=0.15
Xn_828_n1 n_828 n_492 vss vss sky130_fd_pr__nfet_01v8 W=0.42 L=0.15
Xn_828_n2 n_828 x_mag29 vss vss sky130_fd_pr__nfet_01v8 W=0.42 L=0.15
Xn_829_n n_829 n_828 vss vss sky130_fd_pr__nfet_01v8 W=0.42 L=0.15
Xn_829_p n_829 n_828 vdd vdd sky130_fd_pr__pfet_01v8 W=0.7 L=0.15
Xn_830_p1 n_830 n_826 vdd vdd sky130_fd_pr__pfet_01v8 W=0.7 L=0.15
Xn_830_p2 n_830 n_829 vdd vdd sky130_fd_pr__pfet_01v8 W=0.7 L=0.15
Xn_830_n1 n_830 n_826 n_830_x vss sky130_fd_pr__nfet_01v8 W=0.84 L=0.15
Xn_830_n2 n_830_x n_829 vss vss sky130_fd_pr__nfet_01v8 W=0.84 L=0.15
Xn_831_p1 n_831 n_827 vdd vdd sky130_fd_pr__pfet_01v8 W=0.7 L=0.15
Xn_831_p2 n_831 n_830 vdd vdd sky130_fd_pr__pfet_01v8 W=0.7 L=0.15
Xn_831_n1 n_831 n_827 n_831_x vss sky130_fd_pr__nfet_01v8 W=0.84 L=0.15
Xn_831_n2 n_831_x n_830 vss vss sky130_fd_pr__nfet_01v8 W=0.84 L=0.15
Xn_832_p1 n_832 n_493 vdd vdd sky130_fd_pr__pfet_01v8 W=0.7 L=0.15
Xn_832_p2 n_832 x_mag30 vdd vdd sky130_fd_pr__pfet_01v8 W=0.7 L=0.15
Xn_832_n1 n_832 n_493 n_832_x vss sky130_fd_pr__nfet_01v8 W=0.84 L=0.15
Xn_832_n2 n_832_x x_mag30 vss vss sky130_fd_pr__nfet_01v8 W=0.84 L=0.15
Xn_833_p1 n_833 n_493 n_833_x vdd sky130_fd_pr__pfet_01v8 W=1.4 L=0.15
Xn_833_p2 n_833_x x_mag30 vdd vdd sky130_fd_pr__pfet_01v8 W=1.4 L=0.15
Xn_833_n1 n_833 n_493 vss vss sky130_fd_pr__nfet_01v8 W=0.42 L=0.15
Xn_833_n2 n_833 x_mag30 vss vss sky130_fd_pr__nfet_01v8 W=0.42 L=0.15
Xn_834_n n_834 n_833 vss vss sky130_fd_pr__nfet_01v8 W=0.42 L=0.15
Xn_834_p n_834 n_833 vdd vdd sky130_fd_pr__pfet_01v8 W=0.7 L=0.15
Xn_835_p1 n_835 n_831 vdd vdd sky130_fd_pr__pfet_01v8 W=0.7 L=0.15
Xn_835_p2 n_835 n_834 vdd vdd sky130_fd_pr__pfet_01v8 W=0.7 L=0.15
Xn_835_n1 n_835 n_831 n_835_x vss sky130_fd_pr__nfet_01v8 W=0.84 L=0.15
Xn_835_n2 n_835_x n_834 vss vss sky130_fd_pr__nfet_01v8 W=0.84 L=0.15
Xn_836_p1 n_836 n_832 vdd vdd sky130_fd_pr__pfet_01v8 W=0.7 L=0.15
Xn_836_p2 n_836 n_835 vdd vdd sky130_fd_pr__pfet_01v8 W=0.7 L=0.15
Xn_836_n1 n_836 n_832 n_836_x vss sky130_fd_pr__nfet_01v8 W=0.84 L=0.15
Xn_836_n2 n_836_x n_835 vss vss sky130_fd_pr__nfet_01v8 W=0.84 L=0.15
Xn_837_p1 n_837 n_494 vdd vdd sky130_fd_pr__pfet_01v8 W=0.7 L=0.15
Xn_837_p2 n_837 x_mag31 vdd vdd sky130_fd_pr__pfet_01v8 W=0.7 L=0.15
Xn_837_n1 n_837 n_494 n_837_x vss sky130_fd_pr__nfet_01v8 W=0.84 L=0.15
Xn_837_n2 n_837_x x_mag31 vss vss sky130_fd_pr__nfet_01v8 W=0.84 L=0.15
Xn_838_p1 n_838 n_494 n_838_x vdd sky130_fd_pr__pfet_01v8 W=1.4 L=0.15
Xn_838_p2 n_838_x x_mag31 vdd vdd sky130_fd_pr__pfet_01v8 W=1.4 L=0.15
Xn_838_n1 n_838 n_494 vss vss sky130_fd_pr__nfet_01v8 W=0.42 L=0.15
Xn_838_n2 n_838 x_mag31 vss vss sky130_fd_pr__nfet_01v8 W=0.42 L=0.15
Xn_839_n n_839 n_838 vss vss sky130_fd_pr__nfet_01v8 W=0.42 L=0.15
Xn_839_p n_839 n_838 vdd vdd sky130_fd_pr__pfet_01v8 W=0.7 L=0.15
Xn_840_p1 n_840 n_836 vdd vdd sky130_fd_pr__pfet_01v8 W=0.7 L=0.15
Xn_840_p2 n_840 n_839 vdd vdd sky130_fd_pr__pfet_01v8 W=0.7 L=0.15
Xn_840_n1 n_840 n_836 n_840_x vss sky130_fd_pr__nfet_01v8 W=0.84 L=0.15
Xn_840_n2 n_840_x n_839 vss vss sky130_fd_pr__nfet_01v8 W=0.84 L=0.15
Xn_841_p1 n_841 n_837 vdd vdd sky130_fd_pr__pfet_01v8 W=0.7 L=0.15
Xn_841_p2 n_841 n_840 vdd vdd sky130_fd_pr__pfet_01v8 W=0.7 L=0.15
Xn_841_n1 n_841 n_837 n_841_x vss sky130_fd_pr__nfet_01v8 W=0.84 L=0.15
Xn_841_n2 n_841_x n_840 vss vss sky130_fd_pr__nfet_01v8 W=0.84 L=0.15
Xn_842_p1 n_842 n_307 vdd vdd sky130_fd_pr__pfet_01v8 W=0.7 L=0.15
Xn_842_p2 n_842 n_841 vdd vdd sky130_fd_pr__pfet_01v8 W=0.7 L=0.15
Xn_842_n1 n_842 n_307 n_842_x vss sky130_fd_pr__nfet_01v8 W=0.84 L=0.15
Xn_842_n2 n_842_x n_841 vss vss sky130_fd_pr__nfet_01v8 W=0.84 L=0.15
Xn_843_n n_843 n_842 vss vss sky130_fd_pr__nfet_01v8 W=0.42 L=0.15
Xn_843_p n_843 n_842 vdd vdd sky130_fd_pr__pfet_01v8 W=0.7 L=0.15
Xn_844_p1 n_844 n_344 vdd vdd sky130_fd_pr__pfet_01v8 W=0.7 L=0.15
Xn_844_p2 n_844 n_843 vdd vdd sky130_fd_pr__pfet_01v8 W=0.7 L=0.15
Xn_844_n1 n_844 n_344 n_844_x vss sky130_fd_pr__nfet_01v8 W=0.84 L=0.15
Xn_844_n2 n_844_x n_843 vss vss sky130_fd_pr__nfet_01v8 W=0.84 L=0.15
Xn_845_p1 n_845 n_495 vdd vdd sky130_fd_pr__pfet_01v8 W=0.7 L=0.15
Xn_845_p2 n_845 env7 vdd vdd sky130_fd_pr__pfet_01v8 W=0.7 L=0.15
Xn_845_n1 n_845 n_495 n_845_x vss sky130_fd_pr__nfet_01v8 W=0.84 L=0.15
Xn_845_n2 n_845_x env7 vss vss sky130_fd_pr__nfet_01v8 W=0.84 L=0.15
Xn_846_p1 n_846 n_844 vdd vdd sky130_fd_pr__pfet_01v8 W=0.7 L=0.15
Xn_846_p2 n_846 n_845 vdd vdd sky130_fd_pr__pfet_01v8 W=0.7 L=0.15
Xn_846_n1 n_846 n_844 n_846_x vss sky130_fd_pr__nfet_01v8 W=0.84 L=0.15
Xn_846_n2 n_846_x n_845 vss vss sky130_fd_pr__nfet_01v8 W=0.84 L=0.15
Xn_847_n n_847 n_846 vss vss sky130_fd_pr__nfet_01v8 W=0.42 L=0.15
Xn_847_p n_847 n_846 vdd vdd sky130_fd_pr__pfet_01v8 W=0.7 L=0.15
Xn_848_p1 n_848 n_846 n_848_x vdd sky130_fd_pr__pfet_01v8 W=1.4 L=0.15
Xn_848_p2 n_848_x n_106 vdd vdd sky130_fd_pr__pfet_01v8 W=1.4 L=0.15
Xn_848_n1 n_848 n_846 vss vss sky130_fd_pr__nfet_01v8 W=0.42 L=0.15
Xn_848_n2 n_848 n_106 vss vss sky130_fd_pr__nfet_01v8 W=0.42 L=0.15
Xn_849_p1 n_849 n_848 n_849_x vdd sky130_fd_pr__pfet_01v8 W=1.4 L=0.15
Xn_849_p2 n_849_x n_4 vdd vdd sky130_fd_pr__pfet_01v8 W=1.4 L=0.15
Xn_849_n1 n_849 n_848 vss vss sky130_fd_pr__nfet_01v8 W=0.42 L=0.15
Xn_849_n2 n_849 n_4 vss vss sky130_fd_pr__nfet_01v8 W=0.42 L=0.15
Xn_850_n n_850 n_849 vss vss sky130_fd_pr__nfet_01v8 W=0.42 L=0.15
Xn_850_p n_850 n_849 vdd vdd sky130_fd_pr__pfet_01v8 W=0.7 L=0.15
Xn_853_p1 n_853 n_847 n_853_x vdd sky130_fd_pr__pfet_01v8 W=1.4 L=0.15
Xn_853_p2 n_853_x n_106 vdd vdd sky130_fd_pr__pfet_01v8 W=1.4 L=0.15
Xn_853_n1 n_853 n_847 vss vss sky130_fd_pr__nfet_01v8 W=0.42 L=0.15
Xn_853_n2 n_853 n_106 vss vss sky130_fd_pr__nfet_01v8 W=0.42 L=0.15
Xn_852_p1 n_852 n_853 n_852_x vdd sky130_fd_pr__pfet_01v8 W=1.4 L=0.15
Xn_852_p2 n_852_x n_851 vdd vdd sky130_fd_pr__pfet_01v8 W=1.4 L=0.15
Xn_852_n1 n_852 n_853 vss vss sky130_fd_pr__nfet_01v8 W=0.42 L=0.15
Xn_852_n2 n_852 n_851 vss vss sky130_fd_pr__nfet_01v8 W=0.42 L=0.15
Xn_851_p1 n_851 n_850 n_851_x vdd sky130_fd_pr__pfet_01v8 W=1.4 L=0.15
Xn_851_p2 n_851_x n_852 vdd vdd sky130_fd_pr__pfet_01v8 W=1.4 L=0.15
Xn_851_n1 n_851 n_850 vss vss sky130_fd_pr__nfet_01v8 W=0.42 L=0.15
Xn_851_n2 n_851 n_852 vss vss sky130_fd_pr__nfet_01v8 W=0.42 L=0.15
Xn_854_p1 n_854 n_851 n_854_x vdd sky130_fd_pr__pfet_01v8 W=1.4 L=0.15
Xn_854_p2 n_854_x n_109 vdd vdd sky130_fd_pr__pfet_01v8 W=1.4 L=0.15
Xn_854_n1 n_854 n_851 vss vss sky130_fd_pr__nfet_01v8 W=0.42 L=0.15
Xn_854_n2 n_854 n_109 vss vss sky130_fd_pr__nfet_01v8 W=0.42 L=0.15
Xn_855_p1 n_855 n_854 n_855_x vdd sky130_fd_pr__pfet_01v8 W=1.4 L=0.15
Xn_855_p2 n_855_x n_4 vdd vdd sky130_fd_pr__pfet_01v8 W=1.4 L=0.15
Xn_855_n1 n_855 n_854 vss vss sky130_fd_pr__nfet_01v8 W=0.42 L=0.15
Xn_855_n2 n_855 n_4 vss vss sky130_fd_pr__nfet_01v8 W=0.42 L=0.15
Xn_856_n n_856 n_855 vss vss sky130_fd_pr__nfet_01v8 W=0.42 L=0.15
Xn_856_p n_856 n_855 vdd vdd sky130_fd_pr__pfet_01v8 W=0.7 L=0.15
Xn_858_p1 n_858 n_852 n_858_x vdd sky130_fd_pr__pfet_01v8 W=1.4 L=0.15
Xn_858_p2 n_858_x n_109 vdd vdd sky130_fd_pr__pfet_01v8 W=1.4 L=0.15
Xn_858_n1 n_858 n_852 vss vss sky130_fd_pr__nfet_01v8 W=0.42 L=0.15
Xn_858_n2 n_858 n_109 vss vss sky130_fd_pr__nfet_01v8 W=0.42 L=0.15
Xn_857_p1 n_857 n_858 n_857_x vdd sky130_fd_pr__pfet_01v8 W=1.4 L=0.15
Xn_857_p2 n_857_x env7 vdd vdd sky130_fd_pr__pfet_01v8 W=1.4 L=0.15
Xn_857_n1 n_857 n_858 vss vss sky130_fd_pr__nfet_01v8 W=0.42 L=0.15
Xn_857_n2 n_857 env7 vss vss sky130_fd_pr__nfet_01v8 W=0.42 L=0.15
Xenv7_p1 env7 n_856 env7_x vdd sky130_fd_pr__pfet_01v8 W=1.4 L=0.15
Xenv7_p2 env7_x n_857 vdd vdd sky130_fd_pr__pfet_01v8 W=1.4 L=0.15
Xenv7_n1 env7 n_856 vss vss sky130_fd_pr__nfet_01v8 W=0.42 L=0.15
Xenv7_n2 env7 n_857 vss vss sky130_fd_pr__nfet_01v8 W=0.42 L=0.15
Xn_859_n n_859 env7 vss vss sky130_fd_pr__nfet_01v8 W=0.42 L=0.15
Xn_859_p n_859 env7 vdd vdd sky130_fd_pr__pfet_01v8 W=0.7 L=0.15
Xn_860_p1 n_860 env7 vdd vdd sky130_fd_pr__pfet_01v8 W=0.7 L=0.15
Xn_860_p2 n_860 t_ck vdd vdd sky130_fd_pr__pfet_01v8 W=0.7 L=0.15
Xn_860_n1 n_860 env7 n_860_x vss sky130_fd_pr__nfet_01v8 W=0.84 L=0.15
Xn_860_n2 n_860_x t_ck vss vss sky130_fd_pr__nfet_01v8 W=0.84 L=0.15
Xn_861_n n_861 n_860 vss vss sky130_fd_pr__nfet_01v8 W=0.42 L=0.15
Xn_861_p n_861 n_860 vdd vdd sky130_fd_pr__pfet_01v8 W=0.7 L=0.15
Xn_862_p1 n_862 n_859 vdd vdd sky130_fd_pr__pfet_01v8 W=0.7 L=0.15
Xn_862_p2 n_862 t_ck vdd vdd sky130_fd_pr__pfet_01v8 W=0.7 L=0.15
Xn_862_n1 n_862 n_859 n_862_x vss sky130_fd_pr__nfet_01v8 W=0.84 L=0.15
Xn_862_n2 n_862_x t_ck vss vss sky130_fd_pr__nfet_01v8 W=0.84 L=0.15
Xn_863_n n_863 n_862 vss vss sky130_fd_pr__nfet_01v8 W=0.42 L=0.15
Xn_863_p n_863 n_862 vdd vdd sky130_fd_pr__pfet_01v8 W=0.7 L=0.15
Xn_864_p1 n_864 n_863 n_864_x vdd sky130_fd_pr__pfet_01v8 W=1.4 L=0.15
Xn_864_p2 n_864_x n_4 vdd vdd sky130_fd_pr__pfet_01v8 W=1.4 L=0.15
Xn_864_n1 n_864 n_863 vss vss sky130_fd_pr__nfet_01v8 W=0.42 L=0.15
Xn_864_n2 n_864 n_4 vss vss sky130_fd_pr__nfet_01v8 W=0.42 L=0.15
Xn_865_n n_865 n_864 vss vss sky130_fd_pr__nfet_01v8 W=0.42 L=0.15
Xn_865_p n_865 n_864 vdd vdd sky130_fd_pr__pfet_01v8 W=0.7 L=0.15
Xn_867_p1 n_867 n_861 n_867_x vdd sky130_fd_pr__pfet_01v8 W=1.4 L=0.15
Xn_867_p2 n_867_x n_866 vdd vdd sky130_fd_pr__pfet_01v8 W=1.4 L=0.15
Xn_867_n1 n_867 n_861 vss vss sky130_fd_pr__nfet_01v8 W=0.42 L=0.15
Xn_867_n2 n_867 n_866 vss vss sky130_fd_pr__nfet_01v8 W=0.42 L=0.15
Xn_866_p1 n_866 n_865 n_866_x vdd sky130_fd_pr__pfet_01v8 W=1.4 L=0.15
Xn_866_p2 n_866_x n_867 vdd vdd sky130_fd_pr__pfet_01v8 W=1.4 L=0.15
Xn_866_n1 n_866 n_865 vss vss sky130_fd_pr__nfet_01v8 W=0.42 L=0.15
Xn_866_n2 n_866 n_867 vss vss sky130_fd_pr__nfet_01v8 W=0.42 L=0.15
Xn_868_n n_868 x_neg7 vss vss sky130_fd_pr__nfet_01v8 W=0.42 L=0.15
Xn_868_p n_868 x_neg7 vdd vdd sky130_fd_pr__pfet_01v8 W=0.7 L=0.15
Xn_869_p1 n_869 n_866 vdd vdd sky130_fd_pr__pfet_01v8 W=0.7 L=0.15
Xn_869_p2 n_869 n_868 vdd vdd sky130_fd_pr__pfet_01v8 W=0.7 L=0.15
Xn_869_n1 n_869 n_866 n_869_x vss sky130_fd_pr__nfet_01v8 W=0.84 L=0.15
Xn_869_n2 n_869_x n_868 vss vss sky130_fd_pr__nfet_01v8 W=0.84 L=0.15
Xxin_p_r7_n xin_p_r7 n_869 vss vss sky130_fd_pr__nfet_01v8 W=0.42 L=0.15
Xxin_p_r7_p xin_p_r7 n_869 vdd vdd sky130_fd_pr__pfet_01v8 W=0.7 L=0.15
Xn_870_p1 n_870 n_866 vdd vdd sky130_fd_pr__pfet_01v8 W=0.7 L=0.15
Xn_870_p2 n_870 x_neg7 vdd vdd sky130_fd_pr__pfet_01v8 W=0.7 L=0.15
Xn_870_n1 n_870 n_866 n_870_x vss sky130_fd_pr__nfet_01v8 W=0.84 L=0.15
Xn_870_n2 n_870_x x_neg7 vss vss sky130_fd_pr__nfet_01v8 W=0.84 L=0.15
Xxin_n_r7_n xin_n_r7 n_870 vss vss sky130_fd_pr__nfet_01v8 W=0.42 L=0.15
Xxin_n_r7_p xin_n_r7 n_870 vdd vdd sky130_fd_pr__pfet_01v8 W=0.7 L=0.15
Xn_871_p1 n_871 n_866 vdd vdd sky130_fd_pr__pfet_01v8 W=0.7 L=0.15
Xn_871_p2 n_871 lora_en vdd vdd sky130_fd_pr__pfet_01v8 W=0.7 L=0.15
Xn_871_n1 n_871 n_866 n_871_x vss sky130_fd_pr__nfet_01v8 W=0.84 L=0.15
Xn_871_n2 n_871_x lora_en vss vss sky130_fd_pr__nfet_01v8 W=0.84 L=0.15
Xxrd_en7_n xrd_en7 n_871 vss vss sky130_fd_pr__nfet_01v8 W=0.42 L=0.15
Xxrd_en7_p xrd_en7 n_871 vdd vdd sky130_fd_pr__pfet_01v8 W=0.7 L=0.15
Xn_872_p1 n_872 n_491 vdd vdd sky130_fd_pr__pfet_01v8 W=0.7 L=0.15
Xn_872_p2 n_872 x_mag32 vdd vdd sky130_fd_pr__pfet_01v8 W=0.7 L=0.15
Xn_872_n1 n_872 n_491 n_872_x vss sky130_fd_pr__nfet_01v8 W=0.84 L=0.15
Xn_872_n2 n_872_x x_mag32 vss vss sky130_fd_pr__nfet_01v8 W=0.84 L=0.15
Xn_873_n n_873 n_872 vss vss sky130_fd_pr__nfet_01v8 W=0.42 L=0.15
Xn_873_p n_873 n_872 vdd vdd sky130_fd_pr__pfet_01v8 W=0.7 L=0.15
Xn_874_p1 n_874 n_492 vdd vdd sky130_fd_pr__pfet_01v8 W=0.7 L=0.15
Xn_874_p2 n_874 x_mag33 vdd vdd sky130_fd_pr__pfet_01v8 W=0.7 L=0.15
Xn_874_n1 n_874 n_492 n_874_x vss sky130_fd_pr__nfet_01v8 W=0.84 L=0.15
Xn_874_n2 n_874_x x_mag33 vss vss sky130_fd_pr__nfet_01v8 W=0.84 L=0.15
Xn_875_p1 n_875 n_492 n_875_x vdd sky130_fd_pr__pfet_01v8 W=1.4 L=0.15
Xn_875_p2 n_875_x x_mag33 vdd vdd sky130_fd_pr__pfet_01v8 W=1.4 L=0.15
Xn_875_n1 n_875 n_492 vss vss sky130_fd_pr__nfet_01v8 W=0.42 L=0.15
Xn_875_n2 n_875 x_mag33 vss vss sky130_fd_pr__nfet_01v8 W=0.42 L=0.15
Xn_876_n n_876 n_875 vss vss sky130_fd_pr__nfet_01v8 W=0.42 L=0.15
Xn_876_p n_876 n_875 vdd vdd sky130_fd_pr__pfet_01v8 W=0.7 L=0.15
Xn_877_p1 n_877 n_873 vdd vdd sky130_fd_pr__pfet_01v8 W=0.7 L=0.15
Xn_877_p2 n_877 n_876 vdd vdd sky130_fd_pr__pfet_01v8 W=0.7 L=0.15
Xn_877_n1 n_877 n_873 n_877_x vss sky130_fd_pr__nfet_01v8 W=0.84 L=0.15
Xn_877_n2 n_877_x n_876 vss vss sky130_fd_pr__nfet_01v8 W=0.84 L=0.15
Xn_878_p1 n_878 n_874 vdd vdd sky130_fd_pr__pfet_01v8 W=0.7 L=0.15
Xn_878_p2 n_878 n_877 vdd vdd sky130_fd_pr__pfet_01v8 W=0.7 L=0.15
Xn_878_n1 n_878 n_874 n_878_x vss sky130_fd_pr__nfet_01v8 W=0.84 L=0.15
Xn_878_n2 n_878_x n_877 vss vss sky130_fd_pr__nfet_01v8 W=0.84 L=0.15
Xn_879_p1 n_879 n_493 vdd vdd sky130_fd_pr__pfet_01v8 W=0.7 L=0.15
Xn_879_p2 n_879 x_mag34 vdd vdd sky130_fd_pr__pfet_01v8 W=0.7 L=0.15
Xn_879_n1 n_879 n_493 n_879_x vss sky130_fd_pr__nfet_01v8 W=0.84 L=0.15
Xn_879_n2 n_879_x x_mag34 vss vss sky130_fd_pr__nfet_01v8 W=0.84 L=0.15
Xn_880_p1 n_880 n_493 n_880_x vdd sky130_fd_pr__pfet_01v8 W=1.4 L=0.15
Xn_880_p2 n_880_x x_mag34 vdd vdd sky130_fd_pr__pfet_01v8 W=1.4 L=0.15
Xn_880_n1 n_880 n_493 vss vss sky130_fd_pr__nfet_01v8 W=0.42 L=0.15
Xn_880_n2 n_880 x_mag34 vss vss sky130_fd_pr__nfet_01v8 W=0.42 L=0.15
Xn_881_n n_881 n_880 vss vss sky130_fd_pr__nfet_01v8 W=0.42 L=0.15
Xn_881_p n_881 n_880 vdd vdd sky130_fd_pr__pfet_01v8 W=0.7 L=0.15
Xn_882_p1 n_882 n_878 vdd vdd sky130_fd_pr__pfet_01v8 W=0.7 L=0.15
Xn_882_p2 n_882 n_881 vdd vdd sky130_fd_pr__pfet_01v8 W=0.7 L=0.15
Xn_882_n1 n_882 n_878 n_882_x vss sky130_fd_pr__nfet_01v8 W=0.84 L=0.15
Xn_882_n2 n_882_x n_881 vss vss sky130_fd_pr__nfet_01v8 W=0.84 L=0.15
Xn_883_p1 n_883 n_879 vdd vdd sky130_fd_pr__pfet_01v8 W=0.7 L=0.15
Xn_883_p2 n_883 n_882 vdd vdd sky130_fd_pr__pfet_01v8 W=0.7 L=0.15
Xn_883_n1 n_883 n_879 n_883_x vss sky130_fd_pr__nfet_01v8 W=0.84 L=0.15
Xn_883_n2 n_883_x n_882 vss vss sky130_fd_pr__nfet_01v8 W=0.84 L=0.15
Xn_884_p1 n_884 n_494 vdd vdd sky130_fd_pr__pfet_01v8 W=0.7 L=0.15
Xn_884_p2 n_884 x_mag35 vdd vdd sky130_fd_pr__pfet_01v8 W=0.7 L=0.15
Xn_884_n1 n_884 n_494 n_884_x vss sky130_fd_pr__nfet_01v8 W=0.84 L=0.15
Xn_884_n2 n_884_x x_mag35 vss vss sky130_fd_pr__nfet_01v8 W=0.84 L=0.15
Xn_885_p1 n_885 n_494 n_885_x vdd sky130_fd_pr__pfet_01v8 W=1.4 L=0.15
Xn_885_p2 n_885_x x_mag35 vdd vdd sky130_fd_pr__pfet_01v8 W=1.4 L=0.15
Xn_885_n1 n_885 n_494 vss vss sky130_fd_pr__nfet_01v8 W=0.42 L=0.15
Xn_885_n2 n_885 x_mag35 vss vss sky130_fd_pr__nfet_01v8 W=0.42 L=0.15
Xn_886_n n_886 n_885 vss vss sky130_fd_pr__nfet_01v8 W=0.42 L=0.15
Xn_886_p n_886 n_885 vdd vdd sky130_fd_pr__pfet_01v8 W=0.7 L=0.15
Xn_887_p1 n_887 n_883 vdd vdd sky130_fd_pr__pfet_01v8 W=0.7 L=0.15
Xn_887_p2 n_887 n_886 vdd vdd sky130_fd_pr__pfet_01v8 W=0.7 L=0.15
Xn_887_n1 n_887 n_883 n_887_x vss sky130_fd_pr__nfet_01v8 W=0.84 L=0.15
Xn_887_n2 n_887_x n_886 vss vss sky130_fd_pr__nfet_01v8 W=0.84 L=0.15
Xn_888_p1 n_888 n_884 vdd vdd sky130_fd_pr__pfet_01v8 W=0.7 L=0.15
Xn_888_p2 n_888 n_887 vdd vdd sky130_fd_pr__pfet_01v8 W=0.7 L=0.15
Xn_888_n1 n_888 n_884 n_888_x vss sky130_fd_pr__nfet_01v8 W=0.84 L=0.15
Xn_888_n2 n_888_x n_887 vss vss sky130_fd_pr__nfet_01v8 W=0.84 L=0.15
Xn_889_p1 n_889 n_307 vdd vdd sky130_fd_pr__pfet_01v8 W=0.7 L=0.15
Xn_889_p2 n_889 n_888 vdd vdd sky130_fd_pr__pfet_01v8 W=0.7 L=0.15
Xn_889_n1 n_889 n_307 n_889_x vss sky130_fd_pr__nfet_01v8 W=0.84 L=0.15
Xn_889_n2 n_889_x n_888 vss vss sky130_fd_pr__nfet_01v8 W=0.84 L=0.15
Xn_890_n n_890 n_889 vss vss sky130_fd_pr__nfet_01v8 W=0.42 L=0.15
Xn_890_p n_890 n_889 vdd vdd sky130_fd_pr__pfet_01v8 W=0.7 L=0.15
Xn_891_p1 n_891 n_344 vdd vdd sky130_fd_pr__pfet_01v8 W=0.7 L=0.15
Xn_891_p2 n_891 n_890 vdd vdd sky130_fd_pr__pfet_01v8 W=0.7 L=0.15
Xn_891_n1 n_891 n_344 n_891_x vss sky130_fd_pr__nfet_01v8 W=0.84 L=0.15
Xn_891_n2 n_891_x n_890 vss vss sky130_fd_pr__nfet_01v8 W=0.84 L=0.15
Xn_892_p1 n_892 n_495 vdd vdd sky130_fd_pr__pfet_01v8 W=0.7 L=0.15
Xn_892_p2 n_892 env8 vdd vdd sky130_fd_pr__pfet_01v8 W=0.7 L=0.15
Xn_892_n1 n_892 n_495 n_892_x vss sky130_fd_pr__nfet_01v8 W=0.84 L=0.15
Xn_892_n2 n_892_x env8 vss vss sky130_fd_pr__nfet_01v8 W=0.84 L=0.15
Xn_893_p1 n_893 n_891 vdd vdd sky130_fd_pr__pfet_01v8 W=0.7 L=0.15
Xn_893_p2 n_893 n_892 vdd vdd sky130_fd_pr__pfet_01v8 W=0.7 L=0.15
Xn_893_n1 n_893 n_891 n_893_x vss sky130_fd_pr__nfet_01v8 W=0.84 L=0.15
Xn_893_n2 n_893_x n_892 vss vss sky130_fd_pr__nfet_01v8 W=0.84 L=0.15
Xn_894_n n_894 n_893 vss vss sky130_fd_pr__nfet_01v8 W=0.42 L=0.15
Xn_894_p n_894 n_893 vdd vdd sky130_fd_pr__pfet_01v8 W=0.7 L=0.15
Xn_895_p1 n_895 n_893 n_895_x vdd sky130_fd_pr__pfet_01v8 W=1.4 L=0.15
Xn_895_p2 n_895_x n_106 vdd vdd sky130_fd_pr__pfet_01v8 W=1.4 L=0.15
Xn_895_n1 n_895 n_893 vss vss sky130_fd_pr__nfet_01v8 W=0.42 L=0.15
Xn_895_n2 n_895 n_106 vss vss sky130_fd_pr__nfet_01v8 W=0.42 L=0.15
Xn_896_p1 n_896 n_895 n_896_x vdd sky130_fd_pr__pfet_01v8 W=1.4 L=0.15
Xn_896_p2 n_896_x n_4 vdd vdd sky130_fd_pr__pfet_01v8 W=1.4 L=0.15
Xn_896_n1 n_896 n_895 vss vss sky130_fd_pr__nfet_01v8 W=0.42 L=0.15
Xn_896_n2 n_896 n_4 vss vss sky130_fd_pr__nfet_01v8 W=0.42 L=0.15
Xn_897_n n_897 n_896 vss vss sky130_fd_pr__nfet_01v8 W=0.42 L=0.15
Xn_897_p n_897 n_896 vdd vdd sky130_fd_pr__pfet_01v8 W=0.7 L=0.15
Xn_900_p1 n_900 n_894 n_900_x vdd sky130_fd_pr__pfet_01v8 W=1.4 L=0.15
Xn_900_p2 n_900_x n_106 vdd vdd sky130_fd_pr__pfet_01v8 W=1.4 L=0.15
Xn_900_n1 n_900 n_894 vss vss sky130_fd_pr__nfet_01v8 W=0.42 L=0.15
Xn_900_n2 n_900 n_106 vss vss sky130_fd_pr__nfet_01v8 W=0.42 L=0.15
Xn_899_p1 n_899 n_900 n_899_x vdd sky130_fd_pr__pfet_01v8 W=1.4 L=0.15
Xn_899_p2 n_899_x n_898 vdd vdd sky130_fd_pr__pfet_01v8 W=1.4 L=0.15
Xn_899_n1 n_899 n_900 vss vss sky130_fd_pr__nfet_01v8 W=0.42 L=0.15
Xn_899_n2 n_899 n_898 vss vss sky130_fd_pr__nfet_01v8 W=0.42 L=0.15
Xn_898_p1 n_898 n_897 n_898_x vdd sky130_fd_pr__pfet_01v8 W=1.4 L=0.15
Xn_898_p2 n_898_x n_899 vdd vdd sky130_fd_pr__pfet_01v8 W=1.4 L=0.15
Xn_898_n1 n_898 n_897 vss vss sky130_fd_pr__nfet_01v8 W=0.42 L=0.15
Xn_898_n2 n_898 n_899 vss vss sky130_fd_pr__nfet_01v8 W=0.42 L=0.15
Xn_901_p1 n_901 n_898 n_901_x vdd sky130_fd_pr__pfet_01v8 W=1.4 L=0.15
Xn_901_p2 n_901_x n_109 vdd vdd sky130_fd_pr__pfet_01v8 W=1.4 L=0.15
Xn_901_n1 n_901 n_898 vss vss sky130_fd_pr__nfet_01v8 W=0.42 L=0.15
Xn_901_n2 n_901 n_109 vss vss sky130_fd_pr__nfet_01v8 W=0.42 L=0.15
Xn_902_p1 n_902 n_901 n_902_x vdd sky130_fd_pr__pfet_01v8 W=1.4 L=0.15
Xn_902_p2 n_902_x n_4 vdd vdd sky130_fd_pr__pfet_01v8 W=1.4 L=0.15
Xn_902_n1 n_902 n_901 vss vss sky130_fd_pr__nfet_01v8 W=0.42 L=0.15
Xn_902_n2 n_902 n_4 vss vss sky130_fd_pr__nfet_01v8 W=0.42 L=0.15
Xn_903_n n_903 n_902 vss vss sky130_fd_pr__nfet_01v8 W=0.42 L=0.15
Xn_903_p n_903 n_902 vdd vdd sky130_fd_pr__pfet_01v8 W=0.7 L=0.15
Xn_905_p1 n_905 n_899 n_905_x vdd sky130_fd_pr__pfet_01v8 W=1.4 L=0.15
Xn_905_p2 n_905_x n_109 vdd vdd sky130_fd_pr__pfet_01v8 W=1.4 L=0.15
Xn_905_n1 n_905 n_899 vss vss sky130_fd_pr__nfet_01v8 W=0.42 L=0.15
Xn_905_n2 n_905 n_109 vss vss sky130_fd_pr__nfet_01v8 W=0.42 L=0.15
Xn_904_p1 n_904 n_905 n_904_x vdd sky130_fd_pr__pfet_01v8 W=1.4 L=0.15
Xn_904_p2 n_904_x env8 vdd vdd sky130_fd_pr__pfet_01v8 W=1.4 L=0.15
Xn_904_n1 n_904 n_905 vss vss sky130_fd_pr__nfet_01v8 W=0.42 L=0.15
Xn_904_n2 n_904 env8 vss vss sky130_fd_pr__nfet_01v8 W=0.42 L=0.15
Xenv8_p1 env8 n_903 env8_x vdd sky130_fd_pr__pfet_01v8 W=1.4 L=0.15
Xenv8_p2 env8_x n_904 vdd vdd sky130_fd_pr__pfet_01v8 W=1.4 L=0.15
Xenv8_n1 env8 n_903 vss vss sky130_fd_pr__nfet_01v8 W=0.42 L=0.15
Xenv8_n2 env8 n_904 vss vss sky130_fd_pr__nfet_01v8 W=0.42 L=0.15
Xn_906_n n_906 env8 vss vss sky130_fd_pr__nfet_01v8 W=0.42 L=0.15
Xn_906_p n_906 env8 vdd vdd sky130_fd_pr__pfet_01v8 W=0.7 L=0.15
Xn_907_p1 n_907 env8 vdd vdd sky130_fd_pr__pfet_01v8 W=0.7 L=0.15
Xn_907_p2 n_907 t_ck vdd vdd sky130_fd_pr__pfet_01v8 W=0.7 L=0.15
Xn_907_n1 n_907 env8 n_907_x vss sky130_fd_pr__nfet_01v8 W=0.84 L=0.15
Xn_907_n2 n_907_x t_ck vss vss sky130_fd_pr__nfet_01v8 W=0.84 L=0.15
Xn_908_n n_908 n_907 vss vss sky130_fd_pr__nfet_01v8 W=0.42 L=0.15
Xn_908_p n_908 n_907 vdd vdd sky130_fd_pr__pfet_01v8 W=0.7 L=0.15
Xn_909_p1 n_909 n_906 vdd vdd sky130_fd_pr__pfet_01v8 W=0.7 L=0.15
Xn_909_p2 n_909 t_ck vdd vdd sky130_fd_pr__pfet_01v8 W=0.7 L=0.15
Xn_909_n1 n_909 n_906 n_909_x vss sky130_fd_pr__nfet_01v8 W=0.84 L=0.15
Xn_909_n2 n_909_x t_ck vss vss sky130_fd_pr__nfet_01v8 W=0.84 L=0.15
Xn_910_n n_910 n_909 vss vss sky130_fd_pr__nfet_01v8 W=0.42 L=0.15
Xn_910_p n_910 n_909 vdd vdd sky130_fd_pr__pfet_01v8 W=0.7 L=0.15
Xn_911_p1 n_911 n_910 n_911_x vdd sky130_fd_pr__pfet_01v8 W=1.4 L=0.15
Xn_911_p2 n_911_x n_4 vdd vdd sky130_fd_pr__pfet_01v8 W=1.4 L=0.15
Xn_911_n1 n_911 n_910 vss vss sky130_fd_pr__nfet_01v8 W=0.42 L=0.15
Xn_911_n2 n_911 n_4 vss vss sky130_fd_pr__nfet_01v8 W=0.42 L=0.15
Xn_912_n n_912 n_911 vss vss sky130_fd_pr__nfet_01v8 W=0.42 L=0.15
Xn_912_p n_912 n_911 vdd vdd sky130_fd_pr__pfet_01v8 W=0.7 L=0.15
Xn_914_p1 n_914 n_908 n_914_x vdd sky130_fd_pr__pfet_01v8 W=1.4 L=0.15
Xn_914_p2 n_914_x n_913 vdd vdd sky130_fd_pr__pfet_01v8 W=1.4 L=0.15
Xn_914_n1 n_914 n_908 vss vss sky130_fd_pr__nfet_01v8 W=0.42 L=0.15
Xn_914_n2 n_914 n_913 vss vss sky130_fd_pr__nfet_01v8 W=0.42 L=0.15
Xn_913_p1 n_913 n_912 n_913_x vdd sky130_fd_pr__pfet_01v8 W=1.4 L=0.15
Xn_913_p2 n_913_x n_914 vdd vdd sky130_fd_pr__pfet_01v8 W=1.4 L=0.15
Xn_913_n1 n_913 n_912 vss vss sky130_fd_pr__nfet_01v8 W=0.42 L=0.15
Xn_913_n2 n_913 n_914 vss vss sky130_fd_pr__nfet_01v8 W=0.42 L=0.15
Xn_915_n n_915 x_neg8 vss vss sky130_fd_pr__nfet_01v8 W=0.42 L=0.15
Xn_915_p n_915 x_neg8 vdd vdd sky130_fd_pr__pfet_01v8 W=0.7 L=0.15
Xn_916_p1 n_916 n_913 vdd vdd sky130_fd_pr__pfet_01v8 W=0.7 L=0.15
Xn_916_p2 n_916 n_915 vdd vdd sky130_fd_pr__pfet_01v8 W=0.7 L=0.15
Xn_916_n1 n_916 n_913 n_916_x vss sky130_fd_pr__nfet_01v8 W=0.84 L=0.15
Xn_916_n2 n_916_x n_915 vss vss sky130_fd_pr__nfet_01v8 W=0.84 L=0.15
Xxin_p_r8_n xin_p_r8 n_916 vss vss sky130_fd_pr__nfet_01v8 W=0.42 L=0.15
Xxin_p_r8_p xin_p_r8 n_916 vdd vdd sky130_fd_pr__pfet_01v8 W=0.7 L=0.15
Xn_917_p1 n_917 n_913 vdd vdd sky130_fd_pr__pfet_01v8 W=0.7 L=0.15
Xn_917_p2 n_917 x_neg8 vdd vdd sky130_fd_pr__pfet_01v8 W=0.7 L=0.15
Xn_917_n1 n_917 n_913 n_917_x vss sky130_fd_pr__nfet_01v8 W=0.84 L=0.15
Xn_917_n2 n_917_x x_neg8 vss vss sky130_fd_pr__nfet_01v8 W=0.84 L=0.15
Xxin_n_r8_n xin_n_r8 n_917 vss vss sky130_fd_pr__nfet_01v8 W=0.42 L=0.15
Xxin_n_r8_p xin_n_r8 n_917 vdd vdd sky130_fd_pr__pfet_01v8 W=0.7 L=0.15
Xn_918_p1 n_918 n_913 vdd vdd sky130_fd_pr__pfet_01v8 W=0.7 L=0.15
Xn_918_p2 n_918 lora_en vdd vdd sky130_fd_pr__pfet_01v8 W=0.7 L=0.15
Xn_918_n1 n_918 n_913 n_918_x vss sky130_fd_pr__nfet_01v8 W=0.84 L=0.15
Xn_918_n2 n_918_x lora_en vss vss sky130_fd_pr__nfet_01v8 W=0.84 L=0.15
Xxrd_en8_n xrd_en8 n_918 vss vss sky130_fd_pr__nfet_01v8 W=0.42 L=0.15
Xxrd_en8_p xrd_en8 n_918 vdd vdd sky130_fd_pr__pfet_01v8 W=0.7 L=0.15
Xn_919_p1 n_919 n_491 vdd vdd sky130_fd_pr__pfet_01v8 W=0.7 L=0.15
Xn_919_p2 n_919 x_mag36 vdd vdd sky130_fd_pr__pfet_01v8 W=0.7 L=0.15
Xn_919_n1 n_919 n_491 n_919_x vss sky130_fd_pr__nfet_01v8 W=0.84 L=0.15
Xn_919_n2 n_919_x x_mag36 vss vss sky130_fd_pr__nfet_01v8 W=0.84 L=0.15
Xn_920_n n_920 n_919 vss vss sky130_fd_pr__nfet_01v8 W=0.42 L=0.15
Xn_920_p n_920 n_919 vdd vdd sky130_fd_pr__pfet_01v8 W=0.7 L=0.15
Xn_921_p1 n_921 n_492 vdd vdd sky130_fd_pr__pfet_01v8 W=0.7 L=0.15
Xn_921_p2 n_921 x_mag37 vdd vdd sky130_fd_pr__pfet_01v8 W=0.7 L=0.15
Xn_921_n1 n_921 n_492 n_921_x vss sky130_fd_pr__nfet_01v8 W=0.84 L=0.15
Xn_921_n2 n_921_x x_mag37 vss vss sky130_fd_pr__nfet_01v8 W=0.84 L=0.15
Xn_922_p1 n_922 n_492 n_922_x vdd sky130_fd_pr__pfet_01v8 W=1.4 L=0.15
Xn_922_p2 n_922_x x_mag37 vdd vdd sky130_fd_pr__pfet_01v8 W=1.4 L=0.15
Xn_922_n1 n_922 n_492 vss vss sky130_fd_pr__nfet_01v8 W=0.42 L=0.15
Xn_922_n2 n_922 x_mag37 vss vss sky130_fd_pr__nfet_01v8 W=0.42 L=0.15
Xn_923_n n_923 n_922 vss vss sky130_fd_pr__nfet_01v8 W=0.42 L=0.15
Xn_923_p n_923 n_922 vdd vdd sky130_fd_pr__pfet_01v8 W=0.7 L=0.15
Xn_924_p1 n_924 n_920 vdd vdd sky130_fd_pr__pfet_01v8 W=0.7 L=0.15
Xn_924_p2 n_924 n_923 vdd vdd sky130_fd_pr__pfet_01v8 W=0.7 L=0.15
Xn_924_n1 n_924 n_920 n_924_x vss sky130_fd_pr__nfet_01v8 W=0.84 L=0.15
Xn_924_n2 n_924_x n_923 vss vss sky130_fd_pr__nfet_01v8 W=0.84 L=0.15
Xn_925_p1 n_925 n_921 vdd vdd sky130_fd_pr__pfet_01v8 W=0.7 L=0.15
Xn_925_p2 n_925 n_924 vdd vdd sky130_fd_pr__pfet_01v8 W=0.7 L=0.15
Xn_925_n1 n_925 n_921 n_925_x vss sky130_fd_pr__nfet_01v8 W=0.84 L=0.15
Xn_925_n2 n_925_x n_924 vss vss sky130_fd_pr__nfet_01v8 W=0.84 L=0.15
Xn_926_p1 n_926 n_493 vdd vdd sky130_fd_pr__pfet_01v8 W=0.7 L=0.15
Xn_926_p2 n_926 x_mag38 vdd vdd sky130_fd_pr__pfet_01v8 W=0.7 L=0.15
Xn_926_n1 n_926 n_493 n_926_x vss sky130_fd_pr__nfet_01v8 W=0.84 L=0.15
Xn_926_n2 n_926_x x_mag38 vss vss sky130_fd_pr__nfet_01v8 W=0.84 L=0.15
Xn_927_p1 n_927 n_493 n_927_x vdd sky130_fd_pr__pfet_01v8 W=1.4 L=0.15
Xn_927_p2 n_927_x x_mag38 vdd vdd sky130_fd_pr__pfet_01v8 W=1.4 L=0.15
Xn_927_n1 n_927 n_493 vss vss sky130_fd_pr__nfet_01v8 W=0.42 L=0.15
Xn_927_n2 n_927 x_mag38 vss vss sky130_fd_pr__nfet_01v8 W=0.42 L=0.15
Xn_928_n n_928 n_927 vss vss sky130_fd_pr__nfet_01v8 W=0.42 L=0.15
Xn_928_p n_928 n_927 vdd vdd sky130_fd_pr__pfet_01v8 W=0.7 L=0.15
Xn_929_p1 n_929 n_925 vdd vdd sky130_fd_pr__pfet_01v8 W=0.7 L=0.15
Xn_929_p2 n_929 n_928 vdd vdd sky130_fd_pr__pfet_01v8 W=0.7 L=0.15
Xn_929_n1 n_929 n_925 n_929_x vss sky130_fd_pr__nfet_01v8 W=0.84 L=0.15
Xn_929_n2 n_929_x n_928 vss vss sky130_fd_pr__nfet_01v8 W=0.84 L=0.15
Xn_930_p1 n_930 n_926 vdd vdd sky130_fd_pr__pfet_01v8 W=0.7 L=0.15
Xn_930_p2 n_930 n_929 vdd vdd sky130_fd_pr__pfet_01v8 W=0.7 L=0.15
Xn_930_n1 n_930 n_926 n_930_x vss sky130_fd_pr__nfet_01v8 W=0.84 L=0.15
Xn_930_n2 n_930_x n_929 vss vss sky130_fd_pr__nfet_01v8 W=0.84 L=0.15
Xn_931_p1 n_931 n_494 vdd vdd sky130_fd_pr__pfet_01v8 W=0.7 L=0.15
Xn_931_p2 n_931 x_mag39 vdd vdd sky130_fd_pr__pfet_01v8 W=0.7 L=0.15
Xn_931_n1 n_931 n_494 n_931_x vss sky130_fd_pr__nfet_01v8 W=0.84 L=0.15
Xn_931_n2 n_931_x x_mag39 vss vss sky130_fd_pr__nfet_01v8 W=0.84 L=0.15
Xn_932_p1 n_932 n_494 n_932_x vdd sky130_fd_pr__pfet_01v8 W=1.4 L=0.15
Xn_932_p2 n_932_x x_mag39 vdd vdd sky130_fd_pr__pfet_01v8 W=1.4 L=0.15
Xn_932_n1 n_932 n_494 vss vss sky130_fd_pr__nfet_01v8 W=0.42 L=0.15
Xn_932_n2 n_932 x_mag39 vss vss sky130_fd_pr__nfet_01v8 W=0.42 L=0.15
Xn_933_n n_933 n_932 vss vss sky130_fd_pr__nfet_01v8 W=0.42 L=0.15
Xn_933_p n_933 n_932 vdd vdd sky130_fd_pr__pfet_01v8 W=0.7 L=0.15
Xn_934_p1 n_934 n_930 vdd vdd sky130_fd_pr__pfet_01v8 W=0.7 L=0.15
Xn_934_p2 n_934 n_933 vdd vdd sky130_fd_pr__pfet_01v8 W=0.7 L=0.15
Xn_934_n1 n_934 n_930 n_934_x vss sky130_fd_pr__nfet_01v8 W=0.84 L=0.15
Xn_934_n2 n_934_x n_933 vss vss sky130_fd_pr__nfet_01v8 W=0.84 L=0.15
Xn_935_p1 n_935 n_931 vdd vdd sky130_fd_pr__pfet_01v8 W=0.7 L=0.15
Xn_935_p2 n_935 n_934 vdd vdd sky130_fd_pr__pfet_01v8 W=0.7 L=0.15
Xn_935_n1 n_935 n_931 n_935_x vss sky130_fd_pr__nfet_01v8 W=0.84 L=0.15
Xn_935_n2 n_935_x n_934 vss vss sky130_fd_pr__nfet_01v8 W=0.84 L=0.15
Xn_936_p1 n_936 n_307 vdd vdd sky130_fd_pr__pfet_01v8 W=0.7 L=0.15
Xn_936_p2 n_936 n_935 vdd vdd sky130_fd_pr__pfet_01v8 W=0.7 L=0.15
Xn_936_n1 n_936 n_307 n_936_x vss sky130_fd_pr__nfet_01v8 W=0.84 L=0.15
Xn_936_n2 n_936_x n_935 vss vss sky130_fd_pr__nfet_01v8 W=0.84 L=0.15
Xn_937_n n_937 n_936 vss vss sky130_fd_pr__nfet_01v8 W=0.42 L=0.15
Xn_937_p n_937 n_936 vdd vdd sky130_fd_pr__pfet_01v8 W=0.7 L=0.15
Xn_938_p1 n_938 n_344 vdd vdd sky130_fd_pr__pfet_01v8 W=0.7 L=0.15
Xn_938_p2 n_938 n_937 vdd vdd sky130_fd_pr__pfet_01v8 W=0.7 L=0.15
Xn_938_n1 n_938 n_344 n_938_x vss sky130_fd_pr__nfet_01v8 W=0.84 L=0.15
Xn_938_n2 n_938_x n_937 vss vss sky130_fd_pr__nfet_01v8 W=0.84 L=0.15
Xn_939_p1 n_939 n_495 vdd vdd sky130_fd_pr__pfet_01v8 W=0.7 L=0.15
Xn_939_p2 n_939 env9 vdd vdd sky130_fd_pr__pfet_01v8 W=0.7 L=0.15
Xn_939_n1 n_939 n_495 n_939_x vss sky130_fd_pr__nfet_01v8 W=0.84 L=0.15
Xn_939_n2 n_939_x env9 vss vss sky130_fd_pr__nfet_01v8 W=0.84 L=0.15
Xn_940_p1 n_940 n_938 vdd vdd sky130_fd_pr__pfet_01v8 W=0.7 L=0.15
Xn_940_p2 n_940 n_939 vdd vdd sky130_fd_pr__pfet_01v8 W=0.7 L=0.15
Xn_940_n1 n_940 n_938 n_940_x vss sky130_fd_pr__nfet_01v8 W=0.84 L=0.15
Xn_940_n2 n_940_x n_939 vss vss sky130_fd_pr__nfet_01v8 W=0.84 L=0.15
Xn_941_n n_941 n_940 vss vss sky130_fd_pr__nfet_01v8 W=0.42 L=0.15
Xn_941_p n_941 n_940 vdd vdd sky130_fd_pr__pfet_01v8 W=0.7 L=0.15
Xn_942_p1 n_942 n_940 n_942_x vdd sky130_fd_pr__pfet_01v8 W=1.4 L=0.15
Xn_942_p2 n_942_x n_106 vdd vdd sky130_fd_pr__pfet_01v8 W=1.4 L=0.15
Xn_942_n1 n_942 n_940 vss vss sky130_fd_pr__nfet_01v8 W=0.42 L=0.15
Xn_942_n2 n_942 n_106 vss vss sky130_fd_pr__nfet_01v8 W=0.42 L=0.15
Xn_943_p1 n_943 n_942 n_943_x vdd sky130_fd_pr__pfet_01v8 W=1.4 L=0.15
Xn_943_p2 n_943_x n_4 vdd vdd sky130_fd_pr__pfet_01v8 W=1.4 L=0.15
Xn_943_n1 n_943 n_942 vss vss sky130_fd_pr__nfet_01v8 W=0.42 L=0.15
Xn_943_n2 n_943 n_4 vss vss sky130_fd_pr__nfet_01v8 W=0.42 L=0.15
Xn_944_n n_944 n_943 vss vss sky130_fd_pr__nfet_01v8 W=0.42 L=0.15
Xn_944_p n_944 n_943 vdd vdd sky130_fd_pr__pfet_01v8 W=0.7 L=0.15
Xn_947_p1 n_947 n_941 n_947_x vdd sky130_fd_pr__pfet_01v8 W=1.4 L=0.15
Xn_947_p2 n_947_x n_106 vdd vdd sky130_fd_pr__pfet_01v8 W=1.4 L=0.15
Xn_947_n1 n_947 n_941 vss vss sky130_fd_pr__nfet_01v8 W=0.42 L=0.15
Xn_947_n2 n_947 n_106 vss vss sky130_fd_pr__nfet_01v8 W=0.42 L=0.15
Xn_946_p1 n_946 n_947 n_946_x vdd sky130_fd_pr__pfet_01v8 W=1.4 L=0.15
Xn_946_p2 n_946_x n_945 vdd vdd sky130_fd_pr__pfet_01v8 W=1.4 L=0.15
Xn_946_n1 n_946 n_947 vss vss sky130_fd_pr__nfet_01v8 W=0.42 L=0.15
Xn_946_n2 n_946 n_945 vss vss sky130_fd_pr__nfet_01v8 W=0.42 L=0.15
Xn_945_p1 n_945 n_944 n_945_x vdd sky130_fd_pr__pfet_01v8 W=1.4 L=0.15
Xn_945_p2 n_945_x n_946 vdd vdd sky130_fd_pr__pfet_01v8 W=1.4 L=0.15
Xn_945_n1 n_945 n_944 vss vss sky130_fd_pr__nfet_01v8 W=0.42 L=0.15
Xn_945_n2 n_945 n_946 vss vss sky130_fd_pr__nfet_01v8 W=0.42 L=0.15
Xn_948_p1 n_948 n_945 n_948_x vdd sky130_fd_pr__pfet_01v8 W=1.4 L=0.15
Xn_948_p2 n_948_x n_109 vdd vdd sky130_fd_pr__pfet_01v8 W=1.4 L=0.15
Xn_948_n1 n_948 n_945 vss vss sky130_fd_pr__nfet_01v8 W=0.42 L=0.15
Xn_948_n2 n_948 n_109 vss vss sky130_fd_pr__nfet_01v8 W=0.42 L=0.15
Xn_949_p1 n_949 n_948 n_949_x vdd sky130_fd_pr__pfet_01v8 W=1.4 L=0.15
Xn_949_p2 n_949_x n_4 vdd vdd sky130_fd_pr__pfet_01v8 W=1.4 L=0.15
Xn_949_n1 n_949 n_948 vss vss sky130_fd_pr__nfet_01v8 W=0.42 L=0.15
Xn_949_n2 n_949 n_4 vss vss sky130_fd_pr__nfet_01v8 W=0.42 L=0.15
Xn_950_n n_950 n_949 vss vss sky130_fd_pr__nfet_01v8 W=0.42 L=0.15
Xn_950_p n_950 n_949 vdd vdd sky130_fd_pr__pfet_01v8 W=0.7 L=0.15
Xn_952_p1 n_952 n_946 n_952_x vdd sky130_fd_pr__pfet_01v8 W=1.4 L=0.15
Xn_952_p2 n_952_x n_109 vdd vdd sky130_fd_pr__pfet_01v8 W=1.4 L=0.15
Xn_952_n1 n_952 n_946 vss vss sky130_fd_pr__nfet_01v8 W=0.42 L=0.15
Xn_952_n2 n_952 n_109 vss vss sky130_fd_pr__nfet_01v8 W=0.42 L=0.15
Xn_951_p1 n_951 n_952 n_951_x vdd sky130_fd_pr__pfet_01v8 W=1.4 L=0.15
Xn_951_p2 n_951_x env9 vdd vdd sky130_fd_pr__pfet_01v8 W=1.4 L=0.15
Xn_951_n1 n_951 n_952 vss vss sky130_fd_pr__nfet_01v8 W=0.42 L=0.15
Xn_951_n2 n_951 env9 vss vss sky130_fd_pr__nfet_01v8 W=0.42 L=0.15
Xenv9_p1 env9 n_950 env9_x vdd sky130_fd_pr__pfet_01v8 W=1.4 L=0.15
Xenv9_p2 env9_x n_951 vdd vdd sky130_fd_pr__pfet_01v8 W=1.4 L=0.15
Xenv9_n1 env9 n_950 vss vss sky130_fd_pr__nfet_01v8 W=0.42 L=0.15
Xenv9_n2 env9 n_951 vss vss sky130_fd_pr__nfet_01v8 W=0.42 L=0.15
Xn_953_n n_953 env9 vss vss sky130_fd_pr__nfet_01v8 W=0.42 L=0.15
Xn_953_p n_953 env9 vdd vdd sky130_fd_pr__pfet_01v8 W=0.7 L=0.15
Xn_954_p1 n_954 env9 vdd vdd sky130_fd_pr__pfet_01v8 W=0.7 L=0.15
Xn_954_p2 n_954 t_ck vdd vdd sky130_fd_pr__pfet_01v8 W=0.7 L=0.15
Xn_954_n1 n_954 env9 n_954_x vss sky130_fd_pr__nfet_01v8 W=0.84 L=0.15
Xn_954_n2 n_954_x t_ck vss vss sky130_fd_pr__nfet_01v8 W=0.84 L=0.15
Xn_955_n n_955 n_954 vss vss sky130_fd_pr__nfet_01v8 W=0.42 L=0.15
Xn_955_p n_955 n_954 vdd vdd sky130_fd_pr__pfet_01v8 W=0.7 L=0.15
Xn_956_p1 n_956 n_953 vdd vdd sky130_fd_pr__pfet_01v8 W=0.7 L=0.15
Xn_956_p2 n_956 t_ck vdd vdd sky130_fd_pr__pfet_01v8 W=0.7 L=0.15
Xn_956_n1 n_956 n_953 n_956_x vss sky130_fd_pr__nfet_01v8 W=0.84 L=0.15
Xn_956_n2 n_956_x t_ck vss vss sky130_fd_pr__nfet_01v8 W=0.84 L=0.15
Xn_957_n n_957 n_956 vss vss sky130_fd_pr__nfet_01v8 W=0.42 L=0.15
Xn_957_p n_957 n_956 vdd vdd sky130_fd_pr__pfet_01v8 W=0.7 L=0.15
Xn_958_p1 n_958 n_957 n_958_x vdd sky130_fd_pr__pfet_01v8 W=1.4 L=0.15
Xn_958_p2 n_958_x n_4 vdd vdd sky130_fd_pr__pfet_01v8 W=1.4 L=0.15
Xn_958_n1 n_958 n_957 vss vss sky130_fd_pr__nfet_01v8 W=0.42 L=0.15
Xn_958_n2 n_958 n_4 vss vss sky130_fd_pr__nfet_01v8 W=0.42 L=0.15
Xn_959_n n_959 n_958 vss vss sky130_fd_pr__nfet_01v8 W=0.42 L=0.15
Xn_959_p n_959 n_958 vdd vdd sky130_fd_pr__pfet_01v8 W=0.7 L=0.15
Xn_961_p1 n_961 n_955 n_961_x vdd sky130_fd_pr__pfet_01v8 W=1.4 L=0.15
Xn_961_p2 n_961_x n_960 vdd vdd sky130_fd_pr__pfet_01v8 W=1.4 L=0.15
Xn_961_n1 n_961 n_955 vss vss sky130_fd_pr__nfet_01v8 W=0.42 L=0.15
Xn_961_n2 n_961 n_960 vss vss sky130_fd_pr__nfet_01v8 W=0.42 L=0.15
Xn_960_p1 n_960 n_959 n_960_x vdd sky130_fd_pr__pfet_01v8 W=1.4 L=0.15
Xn_960_p2 n_960_x n_961 vdd vdd sky130_fd_pr__pfet_01v8 W=1.4 L=0.15
Xn_960_n1 n_960 n_959 vss vss sky130_fd_pr__nfet_01v8 W=0.42 L=0.15
Xn_960_n2 n_960 n_961 vss vss sky130_fd_pr__nfet_01v8 W=0.42 L=0.15
Xn_962_n n_962 x_neg9 vss vss sky130_fd_pr__nfet_01v8 W=0.42 L=0.15
Xn_962_p n_962 x_neg9 vdd vdd sky130_fd_pr__pfet_01v8 W=0.7 L=0.15
Xn_963_p1 n_963 n_960 vdd vdd sky130_fd_pr__pfet_01v8 W=0.7 L=0.15
Xn_963_p2 n_963 n_962 vdd vdd sky130_fd_pr__pfet_01v8 W=0.7 L=0.15
Xn_963_n1 n_963 n_960 n_963_x vss sky130_fd_pr__nfet_01v8 W=0.84 L=0.15
Xn_963_n2 n_963_x n_962 vss vss sky130_fd_pr__nfet_01v8 W=0.84 L=0.15
Xxin_p_r9_n xin_p_r9 n_963 vss vss sky130_fd_pr__nfet_01v8 W=0.42 L=0.15
Xxin_p_r9_p xin_p_r9 n_963 vdd vdd sky130_fd_pr__pfet_01v8 W=0.7 L=0.15
Xn_964_p1 n_964 n_960 vdd vdd sky130_fd_pr__pfet_01v8 W=0.7 L=0.15
Xn_964_p2 n_964 x_neg9 vdd vdd sky130_fd_pr__pfet_01v8 W=0.7 L=0.15
Xn_964_n1 n_964 n_960 n_964_x vss sky130_fd_pr__nfet_01v8 W=0.84 L=0.15
Xn_964_n2 n_964_x x_neg9 vss vss sky130_fd_pr__nfet_01v8 W=0.84 L=0.15
Xxin_n_r9_n xin_n_r9 n_964 vss vss sky130_fd_pr__nfet_01v8 W=0.42 L=0.15
Xxin_n_r9_p xin_n_r9 n_964 vdd vdd sky130_fd_pr__pfet_01v8 W=0.7 L=0.15
Xn_965_p1 n_965 n_960 vdd vdd sky130_fd_pr__pfet_01v8 W=0.7 L=0.15
Xn_965_p2 n_965 lora_en vdd vdd sky130_fd_pr__pfet_01v8 W=0.7 L=0.15
Xn_965_n1 n_965 n_960 n_965_x vss sky130_fd_pr__nfet_01v8 W=0.84 L=0.15
Xn_965_n2 n_965_x lora_en vss vss sky130_fd_pr__nfet_01v8 W=0.84 L=0.15
Xxrd_en9_n xrd_en9 n_965 vss vss sky130_fd_pr__nfet_01v8 W=0.42 L=0.15
Xxrd_en9_p xrd_en9 n_965 vdd vdd sky130_fd_pr__pfet_01v8 W=0.7 L=0.15
Xn_966_p1 n_966 n_491 vdd vdd sky130_fd_pr__pfet_01v8 W=0.7 L=0.15
Xn_966_p2 n_966 x_mag40 vdd vdd sky130_fd_pr__pfet_01v8 W=0.7 L=0.15
Xn_966_n1 n_966 n_491 n_966_x vss sky130_fd_pr__nfet_01v8 W=0.84 L=0.15
Xn_966_n2 n_966_x x_mag40 vss vss sky130_fd_pr__nfet_01v8 W=0.84 L=0.15
Xn_967_n n_967 n_966 vss vss sky130_fd_pr__nfet_01v8 W=0.42 L=0.15
Xn_967_p n_967 n_966 vdd vdd sky130_fd_pr__pfet_01v8 W=0.7 L=0.15
Xn_968_p1 n_968 n_492 vdd vdd sky130_fd_pr__pfet_01v8 W=0.7 L=0.15
Xn_968_p2 n_968 x_mag41 vdd vdd sky130_fd_pr__pfet_01v8 W=0.7 L=0.15
Xn_968_n1 n_968 n_492 n_968_x vss sky130_fd_pr__nfet_01v8 W=0.84 L=0.15
Xn_968_n2 n_968_x x_mag41 vss vss sky130_fd_pr__nfet_01v8 W=0.84 L=0.15
Xn_969_p1 n_969 n_492 n_969_x vdd sky130_fd_pr__pfet_01v8 W=1.4 L=0.15
Xn_969_p2 n_969_x x_mag41 vdd vdd sky130_fd_pr__pfet_01v8 W=1.4 L=0.15
Xn_969_n1 n_969 n_492 vss vss sky130_fd_pr__nfet_01v8 W=0.42 L=0.15
Xn_969_n2 n_969 x_mag41 vss vss sky130_fd_pr__nfet_01v8 W=0.42 L=0.15
Xn_970_n n_970 n_969 vss vss sky130_fd_pr__nfet_01v8 W=0.42 L=0.15
Xn_970_p n_970 n_969 vdd vdd sky130_fd_pr__pfet_01v8 W=0.7 L=0.15
Xn_971_p1 n_971 n_967 vdd vdd sky130_fd_pr__pfet_01v8 W=0.7 L=0.15
Xn_971_p2 n_971 n_970 vdd vdd sky130_fd_pr__pfet_01v8 W=0.7 L=0.15
Xn_971_n1 n_971 n_967 n_971_x vss sky130_fd_pr__nfet_01v8 W=0.84 L=0.15
Xn_971_n2 n_971_x n_970 vss vss sky130_fd_pr__nfet_01v8 W=0.84 L=0.15
Xn_972_p1 n_972 n_968 vdd vdd sky130_fd_pr__pfet_01v8 W=0.7 L=0.15
Xn_972_p2 n_972 n_971 vdd vdd sky130_fd_pr__pfet_01v8 W=0.7 L=0.15
Xn_972_n1 n_972 n_968 n_972_x vss sky130_fd_pr__nfet_01v8 W=0.84 L=0.15
Xn_972_n2 n_972_x n_971 vss vss sky130_fd_pr__nfet_01v8 W=0.84 L=0.15
Xn_973_p1 n_973 n_493 vdd vdd sky130_fd_pr__pfet_01v8 W=0.7 L=0.15
Xn_973_p2 n_973 x_mag42 vdd vdd sky130_fd_pr__pfet_01v8 W=0.7 L=0.15
Xn_973_n1 n_973 n_493 n_973_x vss sky130_fd_pr__nfet_01v8 W=0.84 L=0.15
Xn_973_n2 n_973_x x_mag42 vss vss sky130_fd_pr__nfet_01v8 W=0.84 L=0.15
Xn_974_p1 n_974 n_493 n_974_x vdd sky130_fd_pr__pfet_01v8 W=1.4 L=0.15
Xn_974_p2 n_974_x x_mag42 vdd vdd sky130_fd_pr__pfet_01v8 W=1.4 L=0.15
Xn_974_n1 n_974 n_493 vss vss sky130_fd_pr__nfet_01v8 W=0.42 L=0.15
Xn_974_n2 n_974 x_mag42 vss vss sky130_fd_pr__nfet_01v8 W=0.42 L=0.15
Xn_975_n n_975 n_974 vss vss sky130_fd_pr__nfet_01v8 W=0.42 L=0.15
Xn_975_p n_975 n_974 vdd vdd sky130_fd_pr__pfet_01v8 W=0.7 L=0.15
Xn_976_p1 n_976 n_972 vdd vdd sky130_fd_pr__pfet_01v8 W=0.7 L=0.15
Xn_976_p2 n_976 n_975 vdd vdd sky130_fd_pr__pfet_01v8 W=0.7 L=0.15
Xn_976_n1 n_976 n_972 n_976_x vss sky130_fd_pr__nfet_01v8 W=0.84 L=0.15
Xn_976_n2 n_976_x n_975 vss vss sky130_fd_pr__nfet_01v8 W=0.84 L=0.15
Xn_977_p1 n_977 n_973 vdd vdd sky130_fd_pr__pfet_01v8 W=0.7 L=0.15
Xn_977_p2 n_977 n_976 vdd vdd sky130_fd_pr__pfet_01v8 W=0.7 L=0.15
Xn_977_n1 n_977 n_973 n_977_x vss sky130_fd_pr__nfet_01v8 W=0.84 L=0.15
Xn_977_n2 n_977_x n_976 vss vss sky130_fd_pr__nfet_01v8 W=0.84 L=0.15
Xn_978_p1 n_978 n_494 vdd vdd sky130_fd_pr__pfet_01v8 W=0.7 L=0.15
Xn_978_p2 n_978 x_mag43 vdd vdd sky130_fd_pr__pfet_01v8 W=0.7 L=0.15
Xn_978_n1 n_978 n_494 n_978_x vss sky130_fd_pr__nfet_01v8 W=0.84 L=0.15
Xn_978_n2 n_978_x x_mag43 vss vss sky130_fd_pr__nfet_01v8 W=0.84 L=0.15
Xn_979_p1 n_979 n_494 n_979_x vdd sky130_fd_pr__pfet_01v8 W=1.4 L=0.15
Xn_979_p2 n_979_x x_mag43 vdd vdd sky130_fd_pr__pfet_01v8 W=1.4 L=0.15
Xn_979_n1 n_979 n_494 vss vss sky130_fd_pr__nfet_01v8 W=0.42 L=0.15
Xn_979_n2 n_979 x_mag43 vss vss sky130_fd_pr__nfet_01v8 W=0.42 L=0.15
Xn_980_n n_980 n_979 vss vss sky130_fd_pr__nfet_01v8 W=0.42 L=0.15
Xn_980_p n_980 n_979 vdd vdd sky130_fd_pr__pfet_01v8 W=0.7 L=0.15
Xn_981_p1 n_981 n_977 vdd vdd sky130_fd_pr__pfet_01v8 W=0.7 L=0.15
Xn_981_p2 n_981 n_980 vdd vdd sky130_fd_pr__pfet_01v8 W=0.7 L=0.15
Xn_981_n1 n_981 n_977 n_981_x vss sky130_fd_pr__nfet_01v8 W=0.84 L=0.15
Xn_981_n2 n_981_x n_980 vss vss sky130_fd_pr__nfet_01v8 W=0.84 L=0.15
Xn_982_p1 n_982 n_978 vdd vdd sky130_fd_pr__pfet_01v8 W=0.7 L=0.15
Xn_982_p2 n_982 n_981 vdd vdd sky130_fd_pr__pfet_01v8 W=0.7 L=0.15
Xn_982_n1 n_982 n_978 n_982_x vss sky130_fd_pr__nfet_01v8 W=0.84 L=0.15
Xn_982_n2 n_982_x n_981 vss vss sky130_fd_pr__nfet_01v8 W=0.84 L=0.15
Xn_983_p1 n_983 n_307 vdd vdd sky130_fd_pr__pfet_01v8 W=0.7 L=0.15
Xn_983_p2 n_983 n_982 vdd vdd sky130_fd_pr__pfet_01v8 W=0.7 L=0.15
Xn_983_n1 n_983 n_307 n_983_x vss sky130_fd_pr__nfet_01v8 W=0.84 L=0.15
Xn_983_n2 n_983_x n_982 vss vss sky130_fd_pr__nfet_01v8 W=0.84 L=0.15
Xn_984_n n_984 n_983 vss vss sky130_fd_pr__nfet_01v8 W=0.42 L=0.15
Xn_984_p n_984 n_983 vdd vdd sky130_fd_pr__pfet_01v8 W=0.7 L=0.15
Xn_985_p1 n_985 n_344 vdd vdd sky130_fd_pr__pfet_01v8 W=0.7 L=0.15
Xn_985_p2 n_985 n_984 vdd vdd sky130_fd_pr__pfet_01v8 W=0.7 L=0.15
Xn_985_n1 n_985 n_344 n_985_x vss sky130_fd_pr__nfet_01v8 W=0.84 L=0.15
Xn_985_n2 n_985_x n_984 vss vss sky130_fd_pr__nfet_01v8 W=0.84 L=0.15
Xn_986_p1 n_986 n_495 vdd vdd sky130_fd_pr__pfet_01v8 W=0.7 L=0.15
Xn_986_p2 n_986 env10 vdd vdd sky130_fd_pr__pfet_01v8 W=0.7 L=0.15
Xn_986_n1 n_986 n_495 n_986_x vss sky130_fd_pr__nfet_01v8 W=0.84 L=0.15
Xn_986_n2 n_986_x env10 vss vss sky130_fd_pr__nfet_01v8 W=0.84 L=0.15
Xn_987_p1 n_987 n_985 vdd vdd sky130_fd_pr__pfet_01v8 W=0.7 L=0.15
Xn_987_p2 n_987 n_986 vdd vdd sky130_fd_pr__pfet_01v8 W=0.7 L=0.15
Xn_987_n1 n_987 n_985 n_987_x vss sky130_fd_pr__nfet_01v8 W=0.84 L=0.15
Xn_987_n2 n_987_x n_986 vss vss sky130_fd_pr__nfet_01v8 W=0.84 L=0.15
Xn_988_n n_988 n_987 vss vss sky130_fd_pr__nfet_01v8 W=0.42 L=0.15
Xn_988_p n_988 n_987 vdd vdd sky130_fd_pr__pfet_01v8 W=0.7 L=0.15
Xn_989_p1 n_989 n_987 n_989_x vdd sky130_fd_pr__pfet_01v8 W=1.4 L=0.15
Xn_989_p2 n_989_x n_106 vdd vdd sky130_fd_pr__pfet_01v8 W=1.4 L=0.15
Xn_989_n1 n_989 n_987 vss vss sky130_fd_pr__nfet_01v8 W=0.42 L=0.15
Xn_989_n2 n_989 n_106 vss vss sky130_fd_pr__nfet_01v8 W=0.42 L=0.15
Xn_990_p1 n_990 n_989 n_990_x vdd sky130_fd_pr__pfet_01v8 W=1.4 L=0.15
Xn_990_p2 n_990_x n_4 vdd vdd sky130_fd_pr__pfet_01v8 W=1.4 L=0.15
Xn_990_n1 n_990 n_989 vss vss sky130_fd_pr__nfet_01v8 W=0.42 L=0.15
Xn_990_n2 n_990 n_4 vss vss sky130_fd_pr__nfet_01v8 W=0.42 L=0.15
Xn_991_n n_991 n_990 vss vss sky130_fd_pr__nfet_01v8 W=0.42 L=0.15
Xn_991_p n_991 n_990 vdd vdd sky130_fd_pr__pfet_01v8 W=0.7 L=0.15
Xn_994_p1 n_994 n_988 n_994_x vdd sky130_fd_pr__pfet_01v8 W=1.4 L=0.15
Xn_994_p2 n_994_x n_106 vdd vdd sky130_fd_pr__pfet_01v8 W=1.4 L=0.15
Xn_994_n1 n_994 n_988 vss vss sky130_fd_pr__nfet_01v8 W=0.42 L=0.15
Xn_994_n2 n_994 n_106 vss vss sky130_fd_pr__nfet_01v8 W=0.42 L=0.15
Xn_993_p1 n_993 n_994 n_993_x vdd sky130_fd_pr__pfet_01v8 W=1.4 L=0.15
Xn_993_p2 n_993_x n_992 vdd vdd sky130_fd_pr__pfet_01v8 W=1.4 L=0.15
Xn_993_n1 n_993 n_994 vss vss sky130_fd_pr__nfet_01v8 W=0.42 L=0.15
Xn_993_n2 n_993 n_992 vss vss sky130_fd_pr__nfet_01v8 W=0.42 L=0.15
Xn_992_p1 n_992 n_991 n_992_x vdd sky130_fd_pr__pfet_01v8 W=1.4 L=0.15
Xn_992_p2 n_992_x n_993 vdd vdd sky130_fd_pr__pfet_01v8 W=1.4 L=0.15
Xn_992_n1 n_992 n_991 vss vss sky130_fd_pr__nfet_01v8 W=0.42 L=0.15
Xn_992_n2 n_992 n_993 vss vss sky130_fd_pr__nfet_01v8 W=0.42 L=0.15
Xn_995_p1 n_995 n_992 n_995_x vdd sky130_fd_pr__pfet_01v8 W=1.4 L=0.15
Xn_995_p2 n_995_x n_109 vdd vdd sky130_fd_pr__pfet_01v8 W=1.4 L=0.15
Xn_995_n1 n_995 n_992 vss vss sky130_fd_pr__nfet_01v8 W=0.42 L=0.15
Xn_995_n2 n_995 n_109 vss vss sky130_fd_pr__nfet_01v8 W=0.42 L=0.15
Xn_996_p1 n_996 n_995 n_996_x vdd sky130_fd_pr__pfet_01v8 W=1.4 L=0.15
Xn_996_p2 n_996_x n_4 vdd vdd sky130_fd_pr__pfet_01v8 W=1.4 L=0.15
Xn_996_n1 n_996 n_995 vss vss sky130_fd_pr__nfet_01v8 W=0.42 L=0.15
Xn_996_n2 n_996 n_4 vss vss sky130_fd_pr__nfet_01v8 W=0.42 L=0.15
Xn_997_n n_997 n_996 vss vss sky130_fd_pr__nfet_01v8 W=0.42 L=0.15
Xn_997_p n_997 n_996 vdd vdd sky130_fd_pr__pfet_01v8 W=0.7 L=0.15
Xn_999_p1 n_999 n_993 n_999_x vdd sky130_fd_pr__pfet_01v8 W=1.4 L=0.15
Xn_999_p2 n_999_x n_109 vdd vdd sky130_fd_pr__pfet_01v8 W=1.4 L=0.15
Xn_999_n1 n_999 n_993 vss vss sky130_fd_pr__nfet_01v8 W=0.42 L=0.15
Xn_999_n2 n_999 n_109 vss vss sky130_fd_pr__nfet_01v8 W=0.42 L=0.15
Xn_998_p1 n_998 n_999 n_998_x vdd sky130_fd_pr__pfet_01v8 W=1.4 L=0.15
Xn_998_p2 n_998_x env10 vdd vdd sky130_fd_pr__pfet_01v8 W=1.4 L=0.15
Xn_998_n1 n_998 n_999 vss vss sky130_fd_pr__nfet_01v8 W=0.42 L=0.15
Xn_998_n2 n_998 env10 vss vss sky130_fd_pr__nfet_01v8 W=0.42 L=0.15
Xenv10_p1 env10 n_997 env10_x vdd sky130_fd_pr__pfet_01v8 W=1.4 L=0.15
Xenv10_p2 env10_x n_998 vdd vdd sky130_fd_pr__pfet_01v8 W=1.4 L=0.15
Xenv10_n1 env10 n_997 vss vss sky130_fd_pr__nfet_01v8 W=0.42 L=0.15
Xenv10_n2 env10 n_998 vss vss sky130_fd_pr__nfet_01v8 W=0.42 L=0.15
Xn_1000_n n_1000 env10 vss vss sky130_fd_pr__nfet_01v8 W=0.42 L=0.15
Xn_1000_p n_1000 env10 vdd vdd sky130_fd_pr__pfet_01v8 W=0.7 L=0.15
Xn_1001_p1 n_1001 env10 vdd vdd sky130_fd_pr__pfet_01v8 W=0.7 L=0.15
Xn_1001_p2 n_1001 t_ck vdd vdd sky130_fd_pr__pfet_01v8 W=0.7 L=0.15
Xn_1001_n1 n_1001 env10 n_1001_x vss sky130_fd_pr__nfet_01v8 W=0.84 L=0.15
Xn_1001_n2 n_1001_x t_ck vss vss sky130_fd_pr__nfet_01v8 W=0.84 L=0.15
Xn_1002_n n_1002 n_1001 vss vss sky130_fd_pr__nfet_01v8 W=0.42 L=0.15
Xn_1002_p n_1002 n_1001 vdd vdd sky130_fd_pr__pfet_01v8 W=0.7 L=0.15
Xn_1003_p1 n_1003 n_1000 vdd vdd sky130_fd_pr__pfet_01v8 W=0.7 L=0.15
Xn_1003_p2 n_1003 t_ck vdd vdd sky130_fd_pr__pfet_01v8 W=0.7 L=0.15
Xn_1003_n1 n_1003 n_1000 n_1003_x vss sky130_fd_pr__nfet_01v8 W=0.84 L=0.15
Xn_1003_n2 n_1003_x t_ck vss vss sky130_fd_pr__nfet_01v8 W=0.84 L=0.15
Xn_1004_n n_1004 n_1003 vss vss sky130_fd_pr__nfet_01v8 W=0.42 L=0.15
Xn_1004_p n_1004 n_1003 vdd vdd sky130_fd_pr__pfet_01v8 W=0.7 L=0.15
Xn_1005_p1 n_1005 n_1004 n_1005_x vdd sky130_fd_pr__pfet_01v8 W=1.4 L=0.15
Xn_1005_p2 n_1005_x n_4 vdd vdd sky130_fd_pr__pfet_01v8 W=1.4 L=0.15
Xn_1005_n1 n_1005 n_1004 vss vss sky130_fd_pr__nfet_01v8 W=0.42 L=0.15
Xn_1005_n2 n_1005 n_4 vss vss sky130_fd_pr__nfet_01v8 W=0.42 L=0.15
Xn_1006_n n_1006 n_1005 vss vss sky130_fd_pr__nfet_01v8 W=0.42 L=0.15
Xn_1006_p n_1006 n_1005 vdd vdd sky130_fd_pr__pfet_01v8 W=0.7 L=0.15
Xn_1008_p1 n_1008 n_1002 n_1008_x vdd sky130_fd_pr__pfet_01v8 W=1.4 L=0.15
Xn_1008_p2 n_1008_x n_1007 vdd vdd sky130_fd_pr__pfet_01v8 W=1.4 L=0.15
Xn_1008_n1 n_1008 n_1002 vss vss sky130_fd_pr__nfet_01v8 W=0.42 L=0.15
Xn_1008_n2 n_1008 n_1007 vss vss sky130_fd_pr__nfet_01v8 W=0.42 L=0.15
Xn_1007_p1 n_1007 n_1006 n_1007_x vdd sky130_fd_pr__pfet_01v8 W=1.4 L=0.15
Xn_1007_p2 n_1007_x n_1008 vdd vdd sky130_fd_pr__pfet_01v8 W=1.4 L=0.15
Xn_1007_n1 n_1007 n_1006 vss vss sky130_fd_pr__nfet_01v8 W=0.42 L=0.15
Xn_1007_n2 n_1007 n_1008 vss vss sky130_fd_pr__nfet_01v8 W=0.42 L=0.15
Xn_1009_n n_1009 x_neg10 vss vss sky130_fd_pr__nfet_01v8 W=0.42 L=0.15
Xn_1009_p n_1009 x_neg10 vdd vdd sky130_fd_pr__pfet_01v8 W=0.7 L=0.15
Xn_1010_p1 n_1010 n_1007 vdd vdd sky130_fd_pr__pfet_01v8 W=0.7 L=0.15
Xn_1010_p2 n_1010 n_1009 vdd vdd sky130_fd_pr__pfet_01v8 W=0.7 L=0.15
Xn_1010_n1 n_1010 n_1007 n_1010_x vss sky130_fd_pr__nfet_01v8 W=0.84 L=0.15
Xn_1010_n2 n_1010_x n_1009 vss vss sky130_fd_pr__nfet_01v8 W=0.84 L=0.15
Xxin_p_r10_n xin_p_r10 n_1010 vss vss sky130_fd_pr__nfet_01v8 W=0.42 L=0.15
Xxin_p_r10_p xin_p_r10 n_1010 vdd vdd sky130_fd_pr__pfet_01v8 W=0.7 L=0.15
Xn_1011_p1 n_1011 n_1007 vdd vdd sky130_fd_pr__pfet_01v8 W=0.7 L=0.15
Xn_1011_p2 n_1011 x_neg10 vdd vdd sky130_fd_pr__pfet_01v8 W=0.7 L=0.15
Xn_1011_n1 n_1011 n_1007 n_1011_x vss sky130_fd_pr__nfet_01v8 W=0.84 L=0.15
Xn_1011_n2 n_1011_x x_neg10 vss vss sky130_fd_pr__nfet_01v8 W=0.84 L=0.15
Xxin_n_r10_n xin_n_r10 n_1011 vss vss sky130_fd_pr__nfet_01v8 W=0.42 L=0.15
Xxin_n_r10_p xin_n_r10 n_1011 vdd vdd sky130_fd_pr__pfet_01v8 W=0.7 L=0.15
Xn_1012_p1 n_1012 n_1007 vdd vdd sky130_fd_pr__pfet_01v8 W=0.7 L=0.15
Xn_1012_p2 n_1012 lora_en vdd vdd sky130_fd_pr__pfet_01v8 W=0.7 L=0.15
Xn_1012_n1 n_1012 n_1007 n_1012_x vss sky130_fd_pr__nfet_01v8 W=0.84 L=0.15
Xn_1012_n2 n_1012_x lora_en vss vss sky130_fd_pr__nfet_01v8 W=0.84 L=0.15
Xxrd_en10_n xrd_en10 n_1012 vss vss sky130_fd_pr__nfet_01v8 W=0.42 L=0.15
Xxrd_en10_p xrd_en10 n_1012 vdd vdd sky130_fd_pr__pfet_01v8 W=0.7 L=0.15
Xn_1013_p1 n_1013 n_491 vdd vdd sky130_fd_pr__pfet_01v8 W=0.7 L=0.15
Xn_1013_p2 n_1013 x_mag44 vdd vdd sky130_fd_pr__pfet_01v8 W=0.7 L=0.15
Xn_1013_n1 n_1013 n_491 n_1013_x vss sky130_fd_pr__nfet_01v8 W=0.84 L=0.15
Xn_1013_n2 n_1013_x x_mag44 vss vss sky130_fd_pr__nfet_01v8 W=0.84 L=0.15
Xn_1014_n n_1014 n_1013 vss vss sky130_fd_pr__nfet_01v8 W=0.42 L=0.15
Xn_1014_p n_1014 n_1013 vdd vdd sky130_fd_pr__pfet_01v8 W=0.7 L=0.15
Xn_1015_p1 n_1015 n_492 vdd vdd sky130_fd_pr__pfet_01v8 W=0.7 L=0.15
Xn_1015_p2 n_1015 x_mag45 vdd vdd sky130_fd_pr__pfet_01v8 W=0.7 L=0.15
Xn_1015_n1 n_1015 n_492 n_1015_x vss sky130_fd_pr__nfet_01v8 W=0.84 L=0.15
Xn_1015_n2 n_1015_x x_mag45 vss vss sky130_fd_pr__nfet_01v8 W=0.84 L=0.15
Xn_1016_p1 n_1016 n_492 n_1016_x vdd sky130_fd_pr__pfet_01v8 W=1.4 L=0.15
Xn_1016_p2 n_1016_x x_mag45 vdd vdd sky130_fd_pr__pfet_01v8 W=1.4 L=0.15
Xn_1016_n1 n_1016 n_492 vss vss sky130_fd_pr__nfet_01v8 W=0.42 L=0.15
Xn_1016_n2 n_1016 x_mag45 vss vss sky130_fd_pr__nfet_01v8 W=0.42 L=0.15
Xn_1017_n n_1017 n_1016 vss vss sky130_fd_pr__nfet_01v8 W=0.42 L=0.15
Xn_1017_p n_1017 n_1016 vdd vdd sky130_fd_pr__pfet_01v8 W=0.7 L=0.15
Xn_1018_p1 n_1018 n_1014 vdd vdd sky130_fd_pr__pfet_01v8 W=0.7 L=0.15
Xn_1018_p2 n_1018 n_1017 vdd vdd sky130_fd_pr__pfet_01v8 W=0.7 L=0.15
Xn_1018_n1 n_1018 n_1014 n_1018_x vss sky130_fd_pr__nfet_01v8 W=0.84 L=0.15
Xn_1018_n2 n_1018_x n_1017 vss vss sky130_fd_pr__nfet_01v8 W=0.84 L=0.15
Xn_1019_p1 n_1019 n_1015 vdd vdd sky130_fd_pr__pfet_01v8 W=0.7 L=0.15
Xn_1019_p2 n_1019 n_1018 vdd vdd sky130_fd_pr__pfet_01v8 W=0.7 L=0.15
Xn_1019_n1 n_1019 n_1015 n_1019_x vss sky130_fd_pr__nfet_01v8 W=0.84 L=0.15
Xn_1019_n2 n_1019_x n_1018 vss vss sky130_fd_pr__nfet_01v8 W=0.84 L=0.15
Xn_1020_p1 n_1020 n_493 vdd vdd sky130_fd_pr__pfet_01v8 W=0.7 L=0.15
Xn_1020_p2 n_1020 x_mag46 vdd vdd sky130_fd_pr__pfet_01v8 W=0.7 L=0.15
Xn_1020_n1 n_1020 n_493 n_1020_x vss sky130_fd_pr__nfet_01v8 W=0.84 L=0.15
Xn_1020_n2 n_1020_x x_mag46 vss vss sky130_fd_pr__nfet_01v8 W=0.84 L=0.15
Xn_1021_p1 n_1021 n_493 n_1021_x vdd sky130_fd_pr__pfet_01v8 W=1.4 L=0.15
Xn_1021_p2 n_1021_x x_mag46 vdd vdd sky130_fd_pr__pfet_01v8 W=1.4 L=0.15
Xn_1021_n1 n_1021 n_493 vss vss sky130_fd_pr__nfet_01v8 W=0.42 L=0.15
Xn_1021_n2 n_1021 x_mag46 vss vss sky130_fd_pr__nfet_01v8 W=0.42 L=0.15
Xn_1022_n n_1022 n_1021 vss vss sky130_fd_pr__nfet_01v8 W=0.42 L=0.15
Xn_1022_p n_1022 n_1021 vdd vdd sky130_fd_pr__pfet_01v8 W=0.7 L=0.15
Xn_1023_p1 n_1023 n_1019 vdd vdd sky130_fd_pr__pfet_01v8 W=0.7 L=0.15
Xn_1023_p2 n_1023 n_1022 vdd vdd sky130_fd_pr__pfet_01v8 W=0.7 L=0.15
Xn_1023_n1 n_1023 n_1019 n_1023_x vss sky130_fd_pr__nfet_01v8 W=0.84 L=0.15
Xn_1023_n2 n_1023_x n_1022 vss vss sky130_fd_pr__nfet_01v8 W=0.84 L=0.15
Xn_1024_p1 n_1024 n_1020 vdd vdd sky130_fd_pr__pfet_01v8 W=0.7 L=0.15
Xn_1024_p2 n_1024 n_1023 vdd vdd sky130_fd_pr__pfet_01v8 W=0.7 L=0.15
Xn_1024_n1 n_1024 n_1020 n_1024_x vss sky130_fd_pr__nfet_01v8 W=0.84 L=0.15
Xn_1024_n2 n_1024_x n_1023 vss vss sky130_fd_pr__nfet_01v8 W=0.84 L=0.15
Xn_1025_p1 n_1025 n_494 vdd vdd sky130_fd_pr__pfet_01v8 W=0.7 L=0.15
Xn_1025_p2 n_1025 x_mag47 vdd vdd sky130_fd_pr__pfet_01v8 W=0.7 L=0.15
Xn_1025_n1 n_1025 n_494 n_1025_x vss sky130_fd_pr__nfet_01v8 W=0.84 L=0.15
Xn_1025_n2 n_1025_x x_mag47 vss vss sky130_fd_pr__nfet_01v8 W=0.84 L=0.15
Xn_1026_p1 n_1026 n_494 n_1026_x vdd sky130_fd_pr__pfet_01v8 W=1.4 L=0.15
Xn_1026_p2 n_1026_x x_mag47 vdd vdd sky130_fd_pr__pfet_01v8 W=1.4 L=0.15
Xn_1026_n1 n_1026 n_494 vss vss sky130_fd_pr__nfet_01v8 W=0.42 L=0.15
Xn_1026_n2 n_1026 x_mag47 vss vss sky130_fd_pr__nfet_01v8 W=0.42 L=0.15
Xn_1027_n n_1027 n_1026 vss vss sky130_fd_pr__nfet_01v8 W=0.42 L=0.15
Xn_1027_p n_1027 n_1026 vdd vdd sky130_fd_pr__pfet_01v8 W=0.7 L=0.15
Xn_1028_p1 n_1028 n_1024 vdd vdd sky130_fd_pr__pfet_01v8 W=0.7 L=0.15
Xn_1028_p2 n_1028 n_1027 vdd vdd sky130_fd_pr__pfet_01v8 W=0.7 L=0.15
Xn_1028_n1 n_1028 n_1024 n_1028_x vss sky130_fd_pr__nfet_01v8 W=0.84 L=0.15
Xn_1028_n2 n_1028_x n_1027 vss vss sky130_fd_pr__nfet_01v8 W=0.84 L=0.15
Xn_1029_p1 n_1029 n_1025 vdd vdd sky130_fd_pr__pfet_01v8 W=0.7 L=0.15
Xn_1029_p2 n_1029 n_1028 vdd vdd sky130_fd_pr__pfet_01v8 W=0.7 L=0.15
Xn_1029_n1 n_1029 n_1025 n_1029_x vss sky130_fd_pr__nfet_01v8 W=0.84 L=0.15
Xn_1029_n2 n_1029_x n_1028 vss vss sky130_fd_pr__nfet_01v8 W=0.84 L=0.15
Xn_1030_p1 n_1030 n_307 vdd vdd sky130_fd_pr__pfet_01v8 W=0.7 L=0.15
Xn_1030_p2 n_1030 n_1029 vdd vdd sky130_fd_pr__pfet_01v8 W=0.7 L=0.15
Xn_1030_n1 n_1030 n_307 n_1030_x vss sky130_fd_pr__nfet_01v8 W=0.84 L=0.15
Xn_1030_n2 n_1030_x n_1029 vss vss sky130_fd_pr__nfet_01v8 W=0.84 L=0.15
Xn_1031_n n_1031 n_1030 vss vss sky130_fd_pr__nfet_01v8 W=0.42 L=0.15
Xn_1031_p n_1031 n_1030 vdd vdd sky130_fd_pr__pfet_01v8 W=0.7 L=0.15
Xn_1032_p1 n_1032 n_344 vdd vdd sky130_fd_pr__pfet_01v8 W=0.7 L=0.15
Xn_1032_p2 n_1032 n_1031 vdd vdd sky130_fd_pr__pfet_01v8 W=0.7 L=0.15
Xn_1032_n1 n_1032 n_344 n_1032_x vss sky130_fd_pr__nfet_01v8 W=0.84 L=0.15
Xn_1032_n2 n_1032_x n_1031 vss vss sky130_fd_pr__nfet_01v8 W=0.84 L=0.15
Xn_1033_p1 n_1033 n_495 vdd vdd sky130_fd_pr__pfet_01v8 W=0.7 L=0.15
Xn_1033_p2 n_1033 env11 vdd vdd sky130_fd_pr__pfet_01v8 W=0.7 L=0.15
Xn_1033_n1 n_1033 n_495 n_1033_x vss sky130_fd_pr__nfet_01v8 W=0.84 L=0.15
Xn_1033_n2 n_1033_x env11 vss vss sky130_fd_pr__nfet_01v8 W=0.84 L=0.15
Xn_1034_p1 n_1034 n_1032 vdd vdd sky130_fd_pr__pfet_01v8 W=0.7 L=0.15
Xn_1034_p2 n_1034 n_1033 vdd vdd sky130_fd_pr__pfet_01v8 W=0.7 L=0.15
Xn_1034_n1 n_1034 n_1032 n_1034_x vss sky130_fd_pr__nfet_01v8 W=0.84 L=0.15
Xn_1034_n2 n_1034_x n_1033 vss vss sky130_fd_pr__nfet_01v8 W=0.84 L=0.15
Xn_1035_n n_1035 n_1034 vss vss sky130_fd_pr__nfet_01v8 W=0.42 L=0.15
Xn_1035_p n_1035 n_1034 vdd vdd sky130_fd_pr__pfet_01v8 W=0.7 L=0.15
Xn_1036_p1 n_1036 n_1034 n_1036_x vdd sky130_fd_pr__pfet_01v8 W=1.4 L=0.15
Xn_1036_p2 n_1036_x n_106 vdd vdd sky130_fd_pr__pfet_01v8 W=1.4 L=0.15
Xn_1036_n1 n_1036 n_1034 vss vss sky130_fd_pr__nfet_01v8 W=0.42 L=0.15
Xn_1036_n2 n_1036 n_106 vss vss sky130_fd_pr__nfet_01v8 W=0.42 L=0.15
Xn_1037_p1 n_1037 n_1036 n_1037_x vdd sky130_fd_pr__pfet_01v8 W=1.4 L=0.15
Xn_1037_p2 n_1037_x n_4 vdd vdd sky130_fd_pr__pfet_01v8 W=1.4 L=0.15
Xn_1037_n1 n_1037 n_1036 vss vss sky130_fd_pr__nfet_01v8 W=0.42 L=0.15
Xn_1037_n2 n_1037 n_4 vss vss sky130_fd_pr__nfet_01v8 W=0.42 L=0.15
Xn_1038_n n_1038 n_1037 vss vss sky130_fd_pr__nfet_01v8 W=0.42 L=0.15
Xn_1038_p n_1038 n_1037 vdd vdd sky130_fd_pr__pfet_01v8 W=0.7 L=0.15
Xn_1041_p1 n_1041 n_1035 n_1041_x vdd sky130_fd_pr__pfet_01v8 W=1.4 L=0.15
Xn_1041_p2 n_1041_x n_106 vdd vdd sky130_fd_pr__pfet_01v8 W=1.4 L=0.15
Xn_1041_n1 n_1041 n_1035 vss vss sky130_fd_pr__nfet_01v8 W=0.42 L=0.15
Xn_1041_n2 n_1041 n_106 vss vss sky130_fd_pr__nfet_01v8 W=0.42 L=0.15
Xn_1040_p1 n_1040 n_1041 n_1040_x vdd sky130_fd_pr__pfet_01v8 W=1.4 L=0.15
Xn_1040_p2 n_1040_x n_1039 vdd vdd sky130_fd_pr__pfet_01v8 W=1.4 L=0.15
Xn_1040_n1 n_1040 n_1041 vss vss sky130_fd_pr__nfet_01v8 W=0.42 L=0.15
Xn_1040_n2 n_1040 n_1039 vss vss sky130_fd_pr__nfet_01v8 W=0.42 L=0.15
Xn_1039_p1 n_1039 n_1038 n_1039_x vdd sky130_fd_pr__pfet_01v8 W=1.4 L=0.15
Xn_1039_p2 n_1039_x n_1040 vdd vdd sky130_fd_pr__pfet_01v8 W=1.4 L=0.15
Xn_1039_n1 n_1039 n_1038 vss vss sky130_fd_pr__nfet_01v8 W=0.42 L=0.15
Xn_1039_n2 n_1039 n_1040 vss vss sky130_fd_pr__nfet_01v8 W=0.42 L=0.15
Xn_1042_p1 n_1042 n_1039 n_1042_x vdd sky130_fd_pr__pfet_01v8 W=1.4 L=0.15
Xn_1042_p2 n_1042_x n_109 vdd vdd sky130_fd_pr__pfet_01v8 W=1.4 L=0.15
Xn_1042_n1 n_1042 n_1039 vss vss sky130_fd_pr__nfet_01v8 W=0.42 L=0.15
Xn_1042_n2 n_1042 n_109 vss vss sky130_fd_pr__nfet_01v8 W=0.42 L=0.15
Xn_1043_p1 n_1043 n_1042 n_1043_x vdd sky130_fd_pr__pfet_01v8 W=1.4 L=0.15
Xn_1043_p2 n_1043_x n_4 vdd vdd sky130_fd_pr__pfet_01v8 W=1.4 L=0.15
Xn_1043_n1 n_1043 n_1042 vss vss sky130_fd_pr__nfet_01v8 W=0.42 L=0.15
Xn_1043_n2 n_1043 n_4 vss vss sky130_fd_pr__nfet_01v8 W=0.42 L=0.15
Xn_1044_n n_1044 n_1043 vss vss sky130_fd_pr__nfet_01v8 W=0.42 L=0.15
Xn_1044_p n_1044 n_1043 vdd vdd sky130_fd_pr__pfet_01v8 W=0.7 L=0.15
Xn_1046_p1 n_1046 n_1040 n_1046_x vdd sky130_fd_pr__pfet_01v8 W=1.4 L=0.15
Xn_1046_p2 n_1046_x n_109 vdd vdd sky130_fd_pr__pfet_01v8 W=1.4 L=0.15
Xn_1046_n1 n_1046 n_1040 vss vss sky130_fd_pr__nfet_01v8 W=0.42 L=0.15
Xn_1046_n2 n_1046 n_109 vss vss sky130_fd_pr__nfet_01v8 W=0.42 L=0.15
Xn_1045_p1 n_1045 n_1046 n_1045_x vdd sky130_fd_pr__pfet_01v8 W=1.4 L=0.15
Xn_1045_p2 n_1045_x env11 vdd vdd sky130_fd_pr__pfet_01v8 W=1.4 L=0.15
Xn_1045_n1 n_1045 n_1046 vss vss sky130_fd_pr__nfet_01v8 W=0.42 L=0.15
Xn_1045_n2 n_1045 env11 vss vss sky130_fd_pr__nfet_01v8 W=0.42 L=0.15
Xenv11_p1 env11 n_1044 env11_x vdd sky130_fd_pr__pfet_01v8 W=1.4 L=0.15
Xenv11_p2 env11_x n_1045 vdd vdd sky130_fd_pr__pfet_01v8 W=1.4 L=0.15
Xenv11_n1 env11 n_1044 vss vss sky130_fd_pr__nfet_01v8 W=0.42 L=0.15
Xenv11_n2 env11 n_1045 vss vss sky130_fd_pr__nfet_01v8 W=0.42 L=0.15
Xn_1047_n n_1047 env11 vss vss sky130_fd_pr__nfet_01v8 W=0.42 L=0.15
Xn_1047_p n_1047 env11 vdd vdd sky130_fd_pr__pfet_01v8 W=0.7 L=0.15
Xn_1048_p1 n_1048 env11 vdd vdd sky130_fd_pr__pfet_01v8 W=0.7 L=0.15
Xn_1048_p2 n_1048 t_ck vdd vdd sky130_fd_pr__pfet_01v8 W=0.7 L=0.15
Xn_1048_n1 n_1048 env11 n_1048_x vss sky130_fd_pr__nfet_01v8 W=0.84 L=0.15
Xn_1048_n2 n_1048_x t_ck vss vss sky130_fd_pr__nfet_01v8 W=0.84 L=0.15
Xn_1049_n n_1049 n_1048 vss vss sky130_fd_pr__nfet_01v8 W=0.42 L=0.15
Xn_1049_p n_1049 n_1048 vdd vdd sky130_fd_pr__pfet_01v8 W=0.7 L=0.15
Xn_1050_p1 n_1050 n_1047 vdd vdd sky130_fd_pr__pfet_01v8 W=0.7 L=0.15
Xn_1050_p2 n_1050 t_ck vdd vdd sky130_fd_pr__pfet_01v8 W=0.7 L=0.15
Xn_1050_n1 n_1050 n_1047 n_1050_x vss sky130_fd_pr__nfet_01v8 W=0.84 L=0.15
Xn_1050_n2 n_1050_x t_ck vss vss sky130_fd_pr__nfet_01v8 W=0.84 L=0.15
Xn_1051_n n_1051 n_1050 vss vss sky130_fd_pr__nfet_01v8 W=0.42 L=0.15
Xn_1051_p n_1051 n_1050 vdd vdd sky130_fd_pr__pfet_01v8 W=0.7 L=0.15
Xn_1052_p1 n_1052 n_1051 n_1052_x vdd sky130_fd_pr__pfet_01v8 W=1.4 L=0.15
Xn_1052_p2 n_1052_x n_4 vdd vdd sky130_fd_pr__pfet_01v8 W=1.4 L=0.15
Xn_1052_n1 n_1052 n_1051 vss vss sky130_fd_pr__nfet_01v8 W=0.42 L=0.15
Xn_1052_n2 n_1052 n_4 vss vss sky130_fd_pr__nfet_01v8 W=0.42 L=0.15
Xn_1053_n n_1053 n_1052 vss vss sky130_fd_pr__nfet_01v8 W=0.42 L=0.15
Xn_1053_p n_1053 n_1052 vdd vdd sky130_fd_pr__pfet_01v8 W=0.7 L=0.15
Xn_1055_p1 n_1055 n_1049 n_1055_x vdd sky130_fd_pr__pfet_01v8 W=1.4 L=0.15
Xn_1055_p2 n_1055_x n_1054 vdd vdd sky130_fd_pr__pfet_01v8 W=1.4 L=0.15
Xn_1055_n1 n_1055 n_1049 vss vss sky130_fd_pr__nfet_01v8 W=0.42 L=0.15
Xn_1055_n2 n_1055 n_1054 vss vss sky130_fd_pr__nfet_01v8 W=0.42 L=0.15
Xn_1054_p1 n_1054 n_1053 n_1054_x vdd sky130_fd_pr__pfet_01v8 W=1.4 L=0.15
Xn_1054_p2 n_1054_x n_1055 vdd vdd sky130_fd_pr__pfet_01v8 W=1.4 L=0.15
Xn_1054_n1 n_1054 n_1053 vss vss sky130_fd_pr__nfet_01v8 W=0.42 L=0.15
Xn_1054_n2 n_1054 n_1055 vss vss sky130_fd_pr__nfet_01v8 W=0.42 L=0.15
Xn_1056_n n_1056 x_neg11 vss vss sky130_fd_pr__nfet_01v8 W=0.42 L=0.15
Xn_1056_p n_1056 x_neg11 vdd vdd sky130_fd_pr__pfet_01v8 W=0.7 L=0.15
Xn_1057_p1 n_1057 n_1054 vdd vdd sky130_fd_pr__pfet_01v8 W=0.7 L=0.15
Xn_1057_p2 n_1057 n_1056 vdd vdd sky130_fd_pr__pfet_01v8 W=0.7 L=0.15
Xn_1057_n1 n_1057 n_1054 n_1057_x vss sky130_fd_pr__nfet_01v8 W=0.84 L=0.15
Xn_1057_n2 n_1057_x n_1056 vss vss sky130_fd_pr__nfet_01v8 W=0.84 L=0.15
Xxin_p_r11_n xin_p_r11 n_1057 vss vss sky130_fd_pr__nfet_01v8 W=0.42 L=0.15
Xxin_p_r11_p xin_p_r11 n_1057 vdd vdd sky130_fd_pr__pfet_01v8 W=0.7 L=0.15
Xn_1058_p1 n_1058 n_1054 vdd vdd sky130_fd_pr__pfet_01v8 W=0.7 L=0.15
Xn_1058_p2 n_1058 x_neg11 vdd vdd sky130_fd_pr__pfet_01v8 W=0.7 L=0.15
Xn_1058_n1 n_1058 n_1054 n_1058_x vss sky130_fd_pr__nfet_01v8 W=0.84 L=0.15
Xn_1058_n2 n_1058_x x_neg11 vss vss sky130_fd_pr__nfet_01v8 W=0.84 L=0.15
Xxin_n_r11_n xin_n_r11 n_1058 vss vss sky130_fd_pr__nfet_01v8 W=0.42 L=0.15
Xxin_n_r11_p xin_n_r11 n_1058 vdd vdd sky130_fd_pr__pfet_01v8 W=0.7 L=0.15
Xn_1059_p1 n_1059 n_1054 vdd vdd sky130_fd_pr__pfet_01v8 W=0.7 L=0.15
Xn_1059_p2 n_1059 lora_en vdd vdd sky130_fd_pr__pfet_01v8 W=0.7 L=0.15
Xn_1059_n1 n_1059 n_1054 n_1059_x vss sky130_fd_pr__nfet_01v8 W=0.84 L=0.15
Xn_1059_n2 n_1059_x lora_en vss vss sky130_fd_pr__nfet_01v8 W=0.84 L=0.15
Xxrd_en11_n xrd_en11 n_1059 vss vss sky130_fd_pr__nfet_01v8 W=0.42 L=0.15
Xxrd_en11_p xrd_en11 n_1059 vdd vdd sky130_fd_pr__pfet_01v8 W=0.7 L=0.15
Xn_1060_p1 n_1060 n_491 vdd vdd sky130_fd_pr__pfet_01v8 W=0.7 L=0.15
Xn_1060_p2 n_1060 x_mag48 vdd vdd sky130_fd_pr__pfet_01v8 W=0.7 L=0.15
Xn_1060_n1 n_1060 n_491 n_1060_x vss sky130_fd_pr__nfet_01v8 W=0.84 L=0.15
Xn_1060_n2 n_1060_x x_mag48 vss vss sky130_fd_pr__nfet_01v8 W=0.84 L=0.15
Xn_1061_n n_1061 n_1060 vss vss sky130_fd_pr__nfet_01v8 W=0.42 L=0.15
Xn_1061_p n_1061 n_1060 vdd vdd sky130_fd_pr__pfet_01v8 W=0.7 L=0.15
Xn_1062_p1 n_1062 n_492 vdd vdd sky130_fd_pr__pfet_01v8 W=0.7 L=0.15
Xn_1062_p2 n_1062 x_mag49 vdd vdd sky130_fd_pr__pfet_01v8 W=0.7 L=0.15
Xn_1062_n1 n_1062 n_492 n_1062_x vss sky130_fd_pr__nfet_01v8 W=0.84 L=0.15
Xn_1062_n2 n_1062_x x_mag49 vss vss sky130_fd_pr__nfet_01v8 W=0.84 L=0.15
Xn_1063_p1 n_1063 n_492 n_1063_x vdd sky130_fd_pr__pfet_01v8 W=1.4 L=0.15
Xn_1063_p2 n_1063_x x_mag49 vdd vdd sky130_fd_pr__pfet_01v8 W=1.4 L=0.15
Xn_1063_n1 n_1063 n_492 vss vss sky130_fd_pr__nfet_01v8 W=0.42 L=0.15
Xn_1063_n2 n_1063 x_mag49 vss vss sky130_fd_pr__nfet_01v8 W=0.42 L=0.15
Xn_1064_n n_1064 n_1063 vss vss sky130_fd_pr__nfet_01v8 W=0.42 L=0.15
Xn_1064_p n_1064 n_1063 vdd vdd sky130_fd_pr__pfet_01v8 W=0.7 L=0.15
Xn_1065_p1 n_1065 n_1061 vdd vdd sky130_fd_pr__pfet_01v8 W=0.7 L=0.15
Xn_1065_p2 n_1065 n_1064 vdd vdd sky130_fd_pr__pfet_01v8 W=0.7 L=0.15
Xn_1065_n1 n_1065 n_1061 n_1065_x vss sky130_fd_pr__nfet_01v8 W=0.84 L=0.15
Xn_1065_n2 n_1065_x n_1064 vss vss sky130_fd_pr__nfet_01v8 W=0.84 L=0.15
Xn_1066_p1 n_1066 n_1062 vdd vdd sky130_fd_pr__pfet_01v8 W=0.7 L=0.15
Xn_1066_p2 n_1066 n_1065 vdd vdd sky130_fd_pr__pfet_01v8 W=0.7 L=0.15
Xn_1066_n1 n_1066 n_1062 n_1066_x vss sky130_fd_pr__nfet_01v8 W=0.84 L=0.15
Xn_1066_n2 n_1066_x n_1065 vss vss sky130_fd_pr__nfet_01v8 W=0.84 L=0.15
Xn_1067_p1 n_1067 n_493 vdd vdd sky130_fd_pr__pfet_01v8 W=0.7 L=0.15
Xn_1067_p2 n_1067 x_mag50 vdd vdd sky130_fd_pr__pfet_01v8 W=0.7 L=0.15
Xn_1067_n1 n_1067 n_493 n_1067_x vss sky130_fd_pr__nfet_01v8 W=0.84 L=0.15
Xn_1067_n2 n_1067_x x_mag50 vss vss sky130_fd_pr__nfet_01v8 W=0.84 L=0.15
Xn_1068_p1 n_1068 n_493 n_1068_x vdd sky130_fd_pr__pfet_01v8 W=1.4 L=0.15
Xn_1068_p2 n_1068_x x_mag50 vdd vdd sky130_fd_pr__pfet_01v8 W=1.4 L=0.15
Xn_1068_n1 n_1068 n_493 vss vss sky130_fd_pr__nfet_01v8 W=0.42 L=0.15
Xn_1068_n2 n_1068 x_mag50 vss vss sky130_fd_pr__nfet_01v8 W=0.42 L=0.15
Xn_1069_n n_1069 n_1068 vss vss sky130_fd_pr__nfet_01v8 W=0.42 L=0.15
Xn_1069_p n_1069 n_1068 vdd vdd sky130_fd_pr__pfet_01v8 W=0.7 L=0.15
Xn_1070_p1 n_1070 n_1066 vdd vdd sky130_fd_pr__pfet_01v8 W=0.7 L=0.15
Xn_1070_p2 n_1070 n_1069 vdd vdd sky130_fd_pr__pfet_01v8 W=0.7 L=0.15
Xn_1070_n1 n_1070 n_1066 n_1070_x vss sky130_fd_pr__nfet_01v8 W=0.84 L=0.15
Xn_1070_n2 n_1070_x n_1069 vss vss sky130_fd_pr__nfet_01v8 W=0.84 L=0.15
Xn_1071_p1 n_1071 n_1067 vdd vdd sky130_fd_pr__pfet_01v8 W=0.7 L=0.15
Xn_1071_p2 n_1071 n_1070 vdd vdd sky130_fd_pr__pfet_01v8 W=0.7 L=0.15
Xn_1071_n1 n_1071 n_1067 n_1071_x vss sky130_fd_pr__nfet_01v8 W=0.84 L=0.15
Xn_1071_n2 n_1071_x n_1070 vss vss sky130_fd_pr__nfet_01v8 W=0.84 L=0.15
Xn_1072_p1 n_1072 n_494 vdd vdd sky130_fd_pr__pfet_01v8 W=0.7 L=0.15
Xn_1072_p2 n_1072 x_mag51 vdd vdd sky130_fd_pr__pfet_01v8 W=0.7 L=0.15
Xn_1072_n1 n_1072 n_494 n_1072_x vss sky130_fd_pr__nfet_01v8 W=0.84 L=0.15
Xn_1072_n2 n_1072_x x_mag51 vss vss sky130_fd_pr__nfet_01v8 W=0.84 L=0.15
Xn_1073_p1 n_1073 n_494 n_1073_x vdd sky130_fd_pr__pfet_01v8 W=1.4 L=0.15
Xn_1073_p2 n_1073_x x_mag51 vdd vdd sky130_fd_pr__pfet_01v8 W=1.4 L=0.15
Xn_1073_n1 n_1073 n_494 vss vss sky130_fd_pr__nfet_01v8 W=0.42 L=0.15
Xn_1073_n2 n_1073 x_mag51 vss vss sky130_fd_pr__nfet_01v8 W=0.42 L=0.15
Xn_1074_n n_1074 n_1073 vss vss sky130_fd_pr__nfet_01v8 W=0.42 L=0.15
Xn_1074_p n_1074 n_1073 vdd vdd sky130_fd_pr__pfet_01v8 W=0.7 L=0.15
Xn_1075_p1 n_1075 n_1071 vdd vdd sky130_fd_pr__pfet_01v8 W=0.7 L=0.15
Xn_1075_p2 n_1075 n_1074 vdd vdd sky130_fd_pr__pfet_01v8 W=0.7 L=0.15
Xn_1075_n1 n_1075 n_1071 n_1075_x vss sky130_fd_pr__nfet_01v8 W=0.84 L=0.15
Xn_1075_n2 n_1075_x n_1074 vss vss sky130_fd_pr__nfet_01v8 W=0.84 L=0.15
Xn_1076_p1 n_1076 n_1072 vdd vdd sky130_fd_pr__pfet_01v8 W=0.7 L=0.15
Xn_1076_p2 n_1076 n_1075 vdd vdd sky130_fd_pr__pfet_01v8 W=0.7 L=0.15
Xn_1076_n1 n_1076 n_1072 n_1076_x vss sky130_fd_pr__nfet_01v8 W=0.84 L=0.15
Xn_1076_n2 n_1076_x n_1075 vss vss sky130_fd_pr__nfet_01v8 W=0.84 L=0.15
Xn_1077_p1 n_1077 n_307 vdd vdd sky130_fd_pr__pfet_01v8 W=0.7 L=0.15
Xn_1077_p2 n_1077 n_1076 vdd vdd sky130_fd_pr__pfet_01v8 W=0.7 L=0.15
Xn_1077_n1 n_1077 n_307 n_1077_x vss sky130_fd_pr__nfet_01v8 W=0.84 L=0.15
Xn_1077_n2 n_1077_x n_1076 vss vss sky130_fd_pr__nfet_01v8 W=0.84 L=0.15
Xn_1078_n n_1078 n_1077 vss vss sky130_fd_pr__nfet_01v8 W=0.42 L=0.15
Xn_1078_p n_1078 n_1077 vdd vdd sky130_fd_pr__pfet_01v8 W=0.7 L=0.15
Xn_1079_p1 n_1079 n_344 vdd vdd sky130_fd_pr__pfet_01v8 W=0.7 L=0.15
Xn_1079_p2 n_1079 n_1078 vdd vdd sky130_fd_pr__pfet_01v8 W=0.7 L=0.15
Xn_1079_n1 n_1079 n_344 n_1079_x vss sky130_fd_pr__nfet_01v8 W=0.84 L=0.15
Xn_1079_n2 n_1079_x n_1078 vss vss sky130_fd_pr__nfet_01v8 W=0.84 L=0.15
Xn_1080_p1 n_1080 n_495 vdd vdd sky130_fd_pr__pfet_01v8 W=0.7 L=0.15
Xn_1080_p2 n_1080 env12 vdd vdd sky130_fd_pr__pfet_01v8 W=0.7 L=0.15
Xn_1080_n1 n_1080 n_495 n_1080_x vss sky130_fd_pr__nfet_01v8 W=0.84 L=0.15
Xn_1080_n2 n_1080_x env12 vss vss sky130_fd_pr__nfet_01v8 W=0.84 L=0.15
Xn_1081_p1 n_1081 n_1079 vdd vdd sky130_fd_pr__pfet_01v8 W=0.7 L=0.15
Xn_1081_p2 n_1081 n_1080 vdd vdd sky130_fd_pr__pfet_01v8 W=0.7 L=0.15
Xn_1081_n1 n_1081 n_1079 n_1081_x vss sky130_fd_pr__nfet_01v8 W=0.84 L=0.15
Xn_1081_n2 n_1081_x n_1080 vss vss sky130_fd_pr__nfet_01v8 W=0.84 L=0.15
Xn_1082_n n_1082 n_1081 vss vss sky130_fd_pr__nfet_01v8 W=0.42 L=0.15
Xn_1082_p n_1082 n_1081 vdd vdd sky130_fd_pr__pfet_01v8 W=0.7 L=0.15
Xn_1083_p1 n_1083 n_1081 n_1083_x vdd sky130_fd_pr__pfet_01v8 W=1.4 L=0.15
Xn_1083_p2 n_1083_x n_106 vdd vdd sky130_fd_pr__pfet_01v8 W=1.4 L=0.15
Xn_1083_n1 n_1083 n_1081 vss vss sky130_fd_pr__nfet_01v8 W=0.42 L=0.15
Xn_1083_n2 n_1083 n_106 vss vss sky130_fd_pr__nfet_01v8 W=0.42 L=0.15
Xn_1084_p1 n_1084 n_1083 n_1084_x vdd sky130_fd_pr__pfet_01v8 W=1.4 L=0.15
Xn_1084_p2 n_1084_x n_4 vdd vdd sky130_fd_pr__pfet_01v8 W=1.4 L=0.15
Xn_1084_n1 n_1084 n_1083 vss vss sky130_fd_pr__nfet_01v8 W=0.42 L=0.15
Xn_1084_n2 n_1084 n_4 vss vss sky130_fd_pr__nfet_01v8 W=0.42 L=0.15
Xn_1085_n n_1085 n_1084 vss vss sky130_fd_pr__nfet_01v8 W=0.42 L=0.15
Xn_1085_p n_1085 n_1084 vdd vdd sky130_fd_pr__pfet_01v8 W=0.7 L=0.15
Xn_1088_p1 n_1088 n_1082 n_1088_x vdd sky130_fd_pr__pfet_01v8 W=1.4 L=0.15
Xn_1088_p2 n_1088_x n_106 vdd vdd sky130_fd_pr__pfet_01v8 W=1.4 L=0.15
Xn_1088_n1 n_1088 n_1082 vss vss sky130_fd_pr__nfet_01v8 W=0.42 L=0.15
Xn_1088_n2 n_1088 n_106 vss vss sky130_fd_pr__nfet_01v8 W=0.42 L=0.15
Xn_1087_p1 n_1087 n_1088 n_1087_x vdd sky130_fd_pr__pfet_01v8 W=1.4 L=0.15
Xn_1087_p2 n_1087_x n_1086 vdd vdd sky130_fd_pr__pfet_01v8 W=1.4 L=0.15
Xn_1087_n1 n_1087 n_1088 vss vss sky130_fd_pr__nfet_01v8 W=0.42 L=0.15
Xn_1087_n2 n_1087 n_1086 vss vss sky130_fd_pr__nfet_01v8 W=0.42 L=0.15
Xn_1086_p1 n_1086 n_1085 n_1086_x vdd sky130_fd_pr__pfet_01v8 W=1.4 L=0.15
Xn_1086_p2 n_1086_x n_1087 vdd vdd sky130_fd_pr__pfet_01v8 W=1.4 L=0.15
Xn_1086_n1 n_1086 n_1085 vss vss sky130_fd_pr__nfet_01v8 W=0.42 L=0.15
Xn_1086_n2 n_1086 n_1087 vss vss sky130_fd_pr__nfet_01v8 W=0.42 L=0.15
Xn_1089_p1 n_1089 n_1086 n_1089_x vdd sky130_fd_pr__pfet_01v8 W=1.4 L=0.15
Xn_1089_p2 n_1089_x n_109 vdd vdd sky130_fd_pr__pfet_01v8 W=1.4 L=0.15
Xn_1089_n1 n_1089 n_1086 vss vss sky130_fd_pr__nfet_01v8 W=0.42 L=0.15
Xn_1089_n2 n_1089 n_109 vss vss sky130_fd_pr__nfet_01v8 W=0.42 L=0.15
Xn_1090_p1 n_1090 n_1089 n_1090_x vdd sky130_fd_pr__pfet_01v8 W=1.4 L=0.15
Xn_1090_p2 n_1090_x n_4 vdd vdd sky130_fd_pr__pfet_01v8 W=1.4 L=0.15
Xn_1090_n1 n_1090 n_1089 vss vss sky130_fd_pr__nfet_01v8 W=0.42 L=0.15
Xn_1090_n2 n_1090 n_4 vss vss sky130_fd_pr__nfet_01v8 W=0.42 L=0.15
Xn_1091_n n_1091 n_1090 vss vss sky130_fd_pr__nfet_01v8 W=0.42 L=0.15
Xn_1091_p n_1091 n_1090 vdd vdd sky130_fd_pr__pfet_01v8 W=0.7 L=0.15
Xn_1093_p1 n_1093 n_1087 n_1093_x vdd sky130_fd_pr__pfet_01v8 W=1.4 L=0.15
Xn_1093_p2 n_1093_x n_109 vdd vdd sky130_fd_pr__pfet_01v8 W=1.4 L=0.15
Xn_1093_n1 n_1093 n_1087 vss vss sky130_fd_pr__nfet_01v8 W=0.42 L=0.15
Xn_1093_n2 n_1093 n_109 vss vss sky130_fd_pr__nfet_01v8 W=0.42 L=0.15
Xn_1092_p1 n_1092 n_1093 n_1092_x vdd sky130_fd_pr__pfet_01v8 W=1.4 L=0.15
Xn_1092_p2 n_1092_x env12 vdd vdd sky130_fd_pr__pfet_01v8 W=1.4 L=0.15
Xn_1092_n1 n_1092 n_1093 vss vss sky130_fd_pr__nfet_01v8 W=0.42 L=0.15
Xn_1092_n2 n_1092 env12 vss vss sky130_fd_pr__nfet_01v8 W=0.42 L=0.15
Xenv12_p1 env12 n_1091 env12_x vdd sky130_fd_pr__pfet_01v8 W=1.4 L=0.15
Xenv12_p2 env12_x n_1092 vdd vdd sky130_fd_pr__pfet_01v8 W=1.4 L=0.15
Xenv12_n1 env12 n_1091 vss vss sky130_fd_pr__nfet_01v8 W=0.42 L=0.15
Xenv12_n2 env12 n_1092 vss vss sky130_fd_pr__nfet_01v8 W=0.42 L=0.15
Xn_1094_n n_1094 env12 vss vss sky130_fd_pr__nfet_01v8 W=0.42 L=0.15
Xn_1094_p n_1094 env12 vdd vdd sky130_fd_pr__pfet_01v8 W=0.7 L=0.15
Xn_1095_p1 n_1095 env12 vdd vdd sky130_fd_pr__pfet_01v8 W=0.7 L=0.15
Xn_1095_p2 n_1095 t_ck vdd vdd sky130_fd_pr__pfet_01v8 W=0.7 L=0.15
Xn_1095_n1 n_1095 env12 n_1095_x vss sky130_fd_pr__nfet_01v8 W=0.84 L=0.15
Xn_1095_n2 n_1095_x t_ck vss vss sky130_fd_pr__nfet_01v8 W=0.84 L=0.15
Xn_1096_n n_1096 n_1095 vss vss sky130_fd_pr__nfet_01v8 W=0.42 L=0.15
Xn_1096_p n_1096 n_1095 vdd vdd sky130_fd_pr__pfet_01v8 W=0.7 L=0.15
Xn_1097_p1 n_1097 n_1094 vdd vdd sky130_fd_pr__pfet_01v8 W=0.7 L=0.15
Xn_1097_p2 n_1097 t_ck vdd vdd sky130_fd_pr__pfet_01v8 W=0.7 L=0.15
Xn_1097_n1 n_1097 n_1094 n_1097_x vss sky130_fd_pr__nfet_01v8 W=0.84 L=0.15
Xn_1097_n2 n_1097_x t_ck vss vss sky130_fd_pr__nfet_01v8 W=0.84 L=0.15
Xn_1098_n n_1098 n_1097 vss vss sky130_fd_pr__nfet_01v8 W=0.42 L=0.15
Xn_1098_p n_1098 n_1097 vdd vdd sky130_fd_pr__pfet_01v8 W=0.7 L=0.15
Xn_1099_p1 n_1099 n_1098 n_1099_x vdd sky130_fd_pr__pfet_01v8 W=1.4 L=0.15
Xn_1099_p2 n_1099_x n_4 vdd vdd sky130_fd_pr__pfet_01v8 W=1.4 L=0.15
Xn_1099_n1 n_1099 n_1098 vss vss sky130_fd_pr__nfet_01v8 W=0.42 L=0.15
Xn_1099_n2 n_1099 n_4 vss vss sky130_fd_pr__nfet_01v8 W=0.42 L=0.15
Xn_1100_n n_1100 n_1099 vss vss sky130_fd_pr__nfet_01v8 W=0.42 L=0.15
Xn_1100_p n_1100 n_1099 vdd vdd sky130_fd_pr__pfet_01v8 W=0.7 L=0.15
Xn_1102_p1 n_1102 n_1096 n_1102_x vdd sky130_fd_pr__pfet_01v8 W=1.4 L=0.15
Xn_1102_p2 n_1102_x n_1101 vdd vdd sky130_fd_pr__pfet_01v8 W=1.4 L=0.15
Xn_1102_n1 n_1102 n_1096 vss vss sky130_fd_pr__nfet_01v8 W=0.42 L=0.15
Xn_1102_n2 n_1102 n_1101 vss vss sky130_fd_pr__nfet_01v8 W=0.42 L=0.15
Xn_1101_p1 n_1101 n_1100 n_1101_x vdd sky130_fd_pr__pfet_01v8 W=1.4 L=0.15
Xn_1101_p2 n_1101_x n_1102 vdd vdd sky130_fd_pr__pfet_01v8 W=1.4 L=0.15
Xn_1101_n1 n_1101 n_1100 vss vss sky130_fd_pr__nfet_01v8 W=0.42 L=0.15
Xn_1101_n2 n_1101 n_1102 vss vss sky130_fd_pr__nfet_01v8 W=0.42 L=0.15
Xn_1103_n n_1103 x_neg12 vss vss sky130_fd_pr__nfet_01v8 W=0.42 L=0.15
Xn_1103_p n_1103 x_neg12 vdd vdd sky130_fd_pr__pfet_01v8 W=0.7 L=0.15
Xn_1104_p1 n_1104 n_1101 vdd vdd sky130_fd_pr__pfet_01v8 W=0.7 L=0.15
Xn_1104_p2 n_1104 n_1103 vdd vdd sky130_fd_pr__pfet_01v8 W=0.7 L=0.15
Xn_1104_n1 n_1104 n_1101 n_1104_x vss sky130_fd_pr__nfet_01v8 W=0.84 L=0.15
Xn_1104_n2 n_1104_x n_1103 vss vss sky130_fd_pr__nfet_01v8 W=0.84 L=0.15
Xxin_p_r12_n xin_p_r12 n_1104 vss vss sky130_fd_pr__nfet_01v8 W=0.42 L=0.15
Xxin_p_r12_p xin_p_r12 n_1104 vdd vdd sky130_fd_pr__pfet_01v8 W=0.7 L=0.15
Xn_1105_p1 n_1105 n_1101 vdd vdd sky130_fd_pr__pfet_01v8 W=0.7 L=0.15
Xn_1105_p2 n_1105 x_neg12 vdd vdd sky130_fd_pr__pfet_01v8 W=0.7 L=0.15
Xn_1105_n1 n_1105 n_1101 n_1105_x vss sky130_fd_pr__nfet_01v8 W=0.84 L=0.15
Xn_1105_n2 n_1105_x x_neg12 vss vss sky130_fd_pr__nfet_01v8 W=0.84 L=0.15
Xxin_n_r12_n xin_n_r12 n_1105 vss vss sky130_fd_pr__nfet_01v8 W=0.42 L=0.15
Xxin_n_r12_p xin_n_r12 n_1105 vdd vdd sky130_fd_pr__pfet_01v8 W=0.7 L=0.15
Xn_1106_p1 n_1106 n_1101 vdd vdd sky130_fd_pr__pfet_01v8 W=0.7 L=0.15
Xn_1106_p2 n_1106 lora_en vdd vdd sky130_fd_pr__pfet_01v8 W=0.7 L=0.15
Xn_1106_n1 n_1106 n_1101 n_1106_x vss sky130_fd_pr__nfet_01v8 W=0.84 L=0.15
Xn_1106_n2 n_1106_x lora_en vss vss sky130_fd_pr__nfet_01v8 W=0.84 L=0.15
Xxrd_en12_n xrd_en12 n_1106 vss vss sky130_fd_pr__nfet_01v8 W=0.42 L=0.15
Xxrd_en12_p xrd_en12 n_1106 vdd vdd sky130_fd_pr__pfet_01v8 W=0.7 L=0.15
Xn_1107_p1 n_1107 n_491 vdd vdd sky130_fd_pr__pfet_01v8 W=0.7 L=0.15
Xn_1107_p2 n_1107 x_mag52 vdd vdd sky130_fd_pr__pfet_01v8 W=0.7 L=0.15
Xn_1107_n1 n_1107 n_491 n_1107_x vss sky130_fd_pr__nfet_01v8 W=0.84 L=0.15
Xn_1107_n2 n_1107_x x_mag52 vss vss sky130_fd_pr__nfet_01v8 W=0.84 L=0.15
Xn_1108_n n_1108 n_1107 vss vss sky130_fd_pr__nfet_01v8 W=0.42 L=0.15
Xn_1108_p n_1108 n_1107 vdd vdd sky130_fd_pr__pfet_01v8 W=0.7 L=0.15
Xn_1109_p1 n_1109 n_492 vdd vdd sky130_fd_pr__pfet_01v8 W=0.7 L=0.15
Xn_1109_p2 n_1109 x_mag53 vdd vdd sky130_fd_pr__pfet_01v8 W=0.7 L=0.15
Xn_1109_n1 n_1109 n_492 n_1109_x vss sky130_fd_pr__nfet_01v8 W=0.84 L=0.15
Xn_1109_n2 n_1109_x x_mag53 vss vss sky130_fd_pr__nfet_01v8 W=0.84 L=0.15
Xn_1110_p1 n_1110 n_492 n_1110_x vdd sky130_fd_pr__pfet_01v8 W=1.4 L=0.15
Xn_1110_p2 n_1110_x x_mag53 vdd vdd sky130_fd_pr__pfet_01v8 W=1.4 L=0.15
Xn_1110_n1 n_1110 n_492 vss vss sky130_fd_pr__nfet_01v8 W=0.42 L=0.15
Xn_1110_n2 n_1110 x_mag53 vss vss sky130_fd_pr__nfet_01v8 W=0.42 L=0.15
Xn_1111_n n_1111 n_1110 vss vss sky130_fd_pr__nfet_01v8 W=0.42 L=0.15
Xn_1111_p n_1111 n_1110 vdd vdd sky130_fd_pr__pfet_01v8 W=0.7 L=0.15
Xn_1112_p1 n_1112 n_1108 vdd vdd sky130_fd_pr__pfet_01v8 W=0.7 L=0.15
Xn_1112_p2 n_1112 n_1111 vdd vdd sky130_fd_pr__pfet_01v8 W=0.7 L=0.15
Xn_1112_n1 n_1112 n_1108 n_1112_x vss sky130_fd_pr__nfet_01v8 W=0.84 L=0.15
Xn_1112_n2 n_1112_x n_1111 vss vss sky130_fd_pr__nfet_01v8 W=0.84 L=0.15
Xn_1113_p1 n_1113 n_1109 vdd vdd sky130_fd_pr__pfet_01v8 W=0.7 L=0.15
Xn_1113_p2 n_1113 n_1112 vdd vdd sky130_fd_pr__pfet_01v8 W=0.7 L=0.15
Xn_1113_n1 n_1113 n_1109 n_1113_x vss sky130_fd_pr__nfet_01v8 W=0.84 L=0.15
Xn_1113_n2 n_1113_x n_1112 vss vss sky130_fd_pr__nfet_01v8 W=0.84 L=0.15
Xn_1114_p1 n_1114 n_493 vdd vdd sky130_fd_pr__pfet_01v8 W=0.7 L=0.15
Xn_1114_p2 n_1114 x_mag54 vdd vdd sky130_fd_pr__pfet_01v8 W=0.7 L=0.15
Xn_1114_n1 n_1114 n_493 n_1114_x vss sky130_fd_pr__nfet_01v8 W=0.84 L=0.15
Xn_1114_n2 n_1114_x x_mag54 vss vss sky130_fd_pr__nfet_01v8 W=0.84 L=0.15
Xn_1115_p1 n_1115 n_493 n_1115_x vdd sky130_fd_pr__pfet_01v8 W=1.4 L=0.15
Xn_1115_p2 n_1115_x x_mag54 vdd vdd sky130_fd_pr__pfet_01v8 W=1.4 L=0.15
Xn_1115_n1 n_1115 n_493 vss vss sky130_fd_pr__nfet_01v8 W=0.42 L=0.15
Xn_1115_n2 n_1115 x_mag54 vss vss sky130_fd_pr__nfet_01v8 W=0.42 L=0.15
Xn_1116_n n_1116 n_1115 vss vss sky130_fd_pr__nfet_01v8 W=0.42 L=0.15
Xn_1116_p n_1116 n_1115 vdd vdd sky130_fd_pr__pfet_01v8 W=0.7 L=0.15
Xn_1117_p1 n_1117 n_1113 vdd vdd sky130_fd_pr__pfet_01v8 W=0.7 L=0.15
Xn_1117_p2 n_1117 n_1116 vdd vdd sky130_fd_pr__pfet_01v8 W=0.7 L=0.15
Xn_1117_n1 n_1117 n_1113 n_1117_x vss sky130_fd_pr__nfet_01v8 W=0.84 L=0.15
Xn_1117_n2 n_1117_x n_1116 vss vss sky130_fd_pr__nfet_01v8 W=0.84 L=0.15
Xn_1118_p1 n_1118 n_1114 vdd vdd sky130_fd_pr__pfet_01v8 W=0.7 L=0.15
Xn_1118_p2 n_1118 n_1117 vdd vdd sky130_fd_pr__pfet_01v8 W=0.7 L=0.15
Xn_1118_n1 n_1118 n_1114 n_1118_x vss sky130_fd_pr__nfet_01v8 W=0.84 L=0.15
Xn_1118_n2 n_1118_x n_1117 vss vss sky130_fd_pr__nfet_01v8 W=0.84 L=0.15
Xn_1119_p1 n_1119 n_494 vdd vdd sky130_fd_pr__pfet_01v8 W=0.7 L=0.15
Xn_1119_p2 n_1119 x_mag55 vdd vdd sky130_fd_pr__pfet_01v8 W=0.7 L=0.15
Xn_1119_n1 n_1119 n_494 n_1119_x vss sky130_fd_pr__nfet_01v8 W=0.84 L=0.15
Xn_1119_n2 n_1119_x x_mag55 vss vss sky130_fd_pr__nfet_01v8 W=0.84 L=0.15
Xn_1120_p1 n_1120 n_494 n_1120_x vdd sky130_fd_pr__pfet_01v8 W=1.4 L=0.15
Xn_1120_p2 n_1120_x x_mag55 vdd vdd sky130_fd_pr__pfet_01v8 W=1.4 L=0.15
Xn_1120_n1 n_1120 n_494 vss vss sky130_fd_pr__nfet_01v8 W=0.42 L=0.15
Xn_1120_n2 n_1120 x_mag55 vss vss sky130_fd_pr__nfet_01v8 W=0.42 L=0.15
Xn_1121_n n_1121 n_1120 vss vss sky130_fd_pr__nfet_01v8 W=0.42 L=0.15
Xn_1121_p n_1121 n_1120 vdd vdd sky130_fd_pr__pfet_01v8 W=0.7 L=0.15
Xn_1122_p1 n_1122 n_1118 vdd vdd sky130_fd_pr__pfet_01v8 W=0.7 L=0.15
Xn_1122_p2 n_1122 n_1121 vdd vdd sky130_fd_pr__pfet_01v8 W=0.7 L=0.15
Xn_1122_n1 n_1122 n_1118 n_1122_x vss sky130_fd_pr__nfet_01v8 W=0.84 L=0.15
Xn_1122_n2 n_1122_x n_1121 vss vss sky130_fd_pr__nfet_01v8 W=0.84 L=0.15
Xn_1123_p1 n_1123 n_1119 vdd vdd sky130_fd_pr__pfet_01v8 W=0.7 L=0.15
Xn_1123_p2 n_1123 n_1122 vdd vdd sky130_fd_pr__pfet_01v8 W=0.7 L=0.15
Xn_1123_n1 n_1123 n_1119 n_1123_x vss sky130_fd_pr__nfet_01v8 W=0.84 L=0.15
Xn_1123_n2 n_1123_x n_1122 vss vss sky130_fd_pr__nfet_01v8 W=0.84 L=0.15
Xn_1124_p1 n_1124 n_307 vdd vdd sky130_fd_pr__pfet_01v8 W=0.7 L=0.15
Xn_1124_p2 n_1124 n_1123 vdd vdd sky130_fd_pr__pfet_01v8 W=0.7 L=0.15
Xn_1124_n1 n_1124 n_307 n_1124_x vss sky130_fd_pr__nfet_01v8 W=0.84 L=0.15
Xn_1124_n2 n_1124_x n_1123 vss vss sky130_fd_pr__nfet_01v8 W=0.84 L=0.15
Xn_1125_n n_1125 n_1124 vss vss sky130_fd_pr__nfet_01v8 W=0.42 L=0.15
Xn_1125_p n_1125 n_1124 vdd vdd sky130_fd_pr__pfet_01v8 W=0.7 L=0.15
Xn_1126_p1 n_1126 n_344 vdd vdd sky130_fd_pr__pfet_01v8 W=0.7 L=0.15
Xn_1126_p2 n_1126 n_1125 vdd vdd sky130_fd_pr__pfet_01v8 W=0.7 L=0.15
Xn_1126_n1 n_1126 n_344 n_1126_x vss sky130_fd_pr__nfet_01v8 W=0.84 L=0.15
Xn_1126_n2 n_1126_x n_1125 vss vss sky130_fd_pr__nfet_01v8 W=0.84 L=0.15
Xn_1127_p1 n_1127 n_495 vdd vdd sky130_fd_pr__pfet_01v8 W=0.7 L=0.15
Xn_1127_p2 n_1127 env13 vdd vdd sky130_fd_pr__pfet_01v8 W=0.7 L=0.15
Xn_1127_n1 n_1127 n_495 n_1127_x vss sky130_fd_pr__nfet_01v8 W=0.84 L=0.15
Xn_1127_n2 n_1127_x env13 vss vss sky130_fd_pr__nfet_01v8 W=0.84 L=0.15
Xn_1128_p1 n_1128 n_1126 vdd vdd sky130_fd_pr__pfet_01v8 W=0.7 L=0.15
Xn_1128_p2 n_1128 n_1127 vdd vdd sky130_fd_pr__pfet_01v8 W=0.7 L=0.15
Xn_1128_n1 n_1128 n_1126 n_1128_x vss sky130_fd_pr__nfet_01v8 W=0.84 L=0.15
Xn_1128_n2 n_1128_x n_1127 vss vss sky130_fd_pr__nfet_01v8 W=0.84 L=0.15
Xn_1129_n n_1129 n_1128 vss vss sky130_fd_pr__nfet_01v8 W=0.42 L=0.15
Xn_1129_p n_1129 n_1128 vdd vdd sky130_fd_pr__pfet_01v8 W=0.7 L=0.15
Xn_1130_p1 n_1130 n_1128 n_1130_x vdd sky130_fd_pr__pfet_01v8 W=1.4 L=0.15
Xn_1130_p2 n_1130_x n_106 vdd vdd sky130_fd_pr__pfet_01v8 W=1.4 L=0.15
Xn_1130_n1 n_1130 n_1128 vss vss sky130_fd_pr__nfet_01v8 W=0.42 L=0.15
Xn_1130_n2 n_1130 n_106 vss vss sky130_fd_pr__nfet_01v8 W=0.42 L=0.15
Xn_1131_p1 n_1131 n_1130 n_1131_x vdd sky130_fd_pr__pfet_01v8 W=1.4 L=0.15
Xn_1131_p2 n_1131_x n_4 vdd vdd sky130_fd_pr__pfet_01v8 W=1.4 L=0.15
Xn_1131_n1 n_1131 n_1130 vss vss sky130_fd_pr__nfet_01v8 W=0.42 L=0.15
Xn_1131_n2 n_1131 n_4 vss vss sky130_fd_pr__nfet_01v8 W=0.42 L=0.15
Xn_1132_n n_1132 n_1131 vss vss sky130_fd_pr__nfet_01v8 W=0.42 L=0.15
Xn_1132_p n_1132 n_1131 vdd vdd sky130_fd_pr__pfet_01v8 W=0.7 L=0.15
Xn_1135_p1 n_1135 n_1129 n_1135_x vdd sky130_fd_pr__pfet_01v8 W=1.4 L=0.15
Xn_1135_p2 n_1135_x n_106 vdd vdd sky130_fd_pr__pfet_01v8 W=1.4 L=0.15
Xn_1135_n1 n_1135 n_1129 vss vss sky130_fd_pr__nfet_01v8 W=0.42 L=0.15
Xn_1135_n2 n_1135 n_106 vss vss sky130_fd_pr__nfet_01v8 W=0.42 L=0.15
Xn_1134_p1 n_1134 n_1135 n_1134_x vdd sky130_fd_pr__pfet_01v8 W=1.4 L=0.15
Xn_1134_p2 n_1134_x n_1133 vdd vdd sky130_fd_pr__pfet_01v8 W=1.4 L=0.15
Xn_1134_n1 n_1134 n_1135 vss vss sky130_fd_pr__nfet_01v8 W=0.42 L=0.15
Xn_1134_n2 n_1134 n_1133 vss vss sky130_fd_pr__nfet_01v8 W=0.42 L=0.15
Xn_1133_p1 n_1133 n_1132 n_1133_x vdd sky130_fd_pr__pfet_01v8 W=1.4 L=0.15
Xn_1133_p2 n_1133_x n_1134 vdd vdd sky130_fd_pr__pfet_01v8 W=1.4 L=0.15
Xn_1133_n1 n_1133 n_1132 vss vss sky130_fd_pr__nfet_01v8 W=0.42 L=0.15
Xn_1133_n2 n_1133 n_1134 vss vss sky130_fd_pr__nfet_01v8 W=0.42 L=0.15
Xn_1136_p1 n_1136 n_1133 n_1136_x vdd sky130_fd_pr__pfet_01v8 W=1.4 L=0.15
Xn_1136_p2 n_1136_x n_109 vdd vdd sky130_fd_pr__pfet_01v8 W=1.4 L=0.15
Xn_1136_n1 n_1136 n_1133 vss vss sky130_fd_pr__nfet_01v8 W=0.42 L=0.15
Xn_1136_n2 n_1136 n_109 vss vss sky130_fd_pr__nfet_01v8 W=0.42 L=0.15
Xn_1137_p1 n_1137 n_1136 n_1137_x vdd sky130_fd_pr__pfet_01v8 W=1.4 L=0.15
Xn_1137_p2 n_1137_x n_4 vdd vdd sky130_fd_pr__pfet_01v8 W=1.4 L=0.15
Xn_1137_n1 n_1137 n_1136 vss vss sky130_fd_pr__nfet_01v8 W=0.42 L=0.15
Xn_1137_n2 n_1137 n_4 vss vss sky130_fd_pr__nfet_01v8 W=0.42 L=0.15
Xn_1138_n n_1138 n_1137 vss vss sky130_fd_pr__nfet_01v8 W=0.42 L=0.15
Xn_1138_p n_1138 n_1137 vdd vdd sky130_fd_pr__pfet_01v8 W=0.7 L=0.15
Xn_1140_p1 n_1140 n_1134 n_1140_x vdd sky130_fd_pr__pfet_01v8 W=1.4 L=0.15
Xn_1140_p2 n_1140_x n_109 vdd vdd sky130_fd_pr__pfet_01v8 W=1.4 L=0.15
Xn_1140_n1 n_1140 n_1134 vss vss sky130_fd_pr__nfet_01v8 W=0.42 L=0.15
Xn_1140_n2 n_1140 n_109 vss vss sky130_fd_pr__nfet_01v8 W=0.42 L=0.15
Xn_1139_p1 n_1139 n_1140 n_1139_x vdd sky130_fd_pr__pfet_01v8 W=1.4 L=0.15
Xn_1139_p2 n_1139_x env13 vdd vdd sky130_fd_pr__pfet_01v8 W=1.4 L=0.15
Xn_1139_n1 n_1139 n_1140 vss vss sky130_fd_pr__nfet_01v8 W=0.42 L=0.15
Xn_1139_n2 n_1139 env13 vss vss sky130_fd_pr__nfet_01v8 W=0.42 L=0.15
Xenv13_p1 env13 n_1138 env13_x vdd sky130_fd_pr__pfet_01v8 W=1.4 L=0.15
Xenv13_p2 env13_x n_1139 vdd vdd sky130_fd_pr__pfet_01v8 W=1.4 L=0.15
Xenv13_n1 env13 n_1138 vss vss sky130_fd_pr__nfet_01v8 W=0.42 L=0.15
Xenv13_n2 env13 n_1139 vss vss sky130_fd_pr__nfet_01v8 W=0.42 L=0.15
Xn_1141_n n_1141 env13 vss vss sky130_fd_pr__nfet_01v8 W=0.42 L=0.15
Xn_1141_p n_1141 env13 vdd vdd sky130_fd_pr__pfet_01v8 W=0.7 L=0.15
Xn_1142_p1 n_1142 env13 vdd vdd sky130_fd_pr__pfet_01v8 W=0.7 L=0.15
Xn_1142_p2 n_1142 t_ck vdd vdd sky130_fd_pr__pfet_01v8 W=0.7 L=0.15
Xn_1142_n1 n_1142 env13 n_1142_x vss sky130_fd_pr__nfet_01v8 W=0.84 L=0.15
Xn_1142_n2 n_1142_x t_ck vss vss sky130_fd_pr__nfet_01v8 W=0.84 L=0.15
Xn_1143_n n_1143 n_1142 vss vss sky130_fd_pr__nfet_01v8 W=0.42 L=0.15
Xn_1143_p n_1143 n_1142 vdd vdd sky130_fd_pr__pfet_01v8 W=0.7 L=0.15
Xn_1144_p1 n_1144 n_1141 vdd vdd sky130_fd_pr__pfet_01v8 W=0.7 L=0.15
Xn_1144_p2 n_1144 t_ck vdd vdd sky130_fd_pr__pfet_01v8 W=0.7 L=0.15
Xn_1144_n1 n_1144 n_1141 n_1144_x vss sky130_fd_pr__nfet_01v8 W=0.84 L=0.15
Xn_1144_n2 n_1144_x t_ck vss vss sky130_fd_pr__nfet_01v8 W=0.84 L=0.15
Xn_1145_n n_1145 n_1144 vss vss sky130_fd_pr__nfet_01v8 W=0.42 L=0.15
Xn_1145_p n_1145 n_1144 vdd vdd sky130_fd_pr__pfet_01v8 W=0.7 L=0.15
Xn_1146_p1 n_1146 n_1145 n_1146_x vdd sky130_fd_pr__pfet_01v8 W=1.4 L=0.15
Xn_1146_p2 n_1146_x n_4 vdd vdd sky130_fd_pr__pfet_01v8 W=1.4 L=0.15
Xn_1146_n1 n_1146 n_1145 vss vss sky130_fd_pr__nfet_01v8 W=0.42 L=0.15
Xn_1146_n2 n_1146 n_4 vss vss sky130_fd_pr__nfet_01v8 W=0.42 L=0.15
Xn_1147_n n_1147 n_1146 vss vss sky130_fd_pr__nfet_01v8 W=0.42 L=0.15
Xn_1147_p n_1147 n_1146 vdd vdd sky130_fd_pr__pfet_01v8 W=0.7 L=0.15
Xn_1149_p1 n_1149 n_1143 n_1149_x vdd sky130_fd_pr__pfet_01v8 W=1.4 L=0.15
Xn_1149_p2 n_1149_x n_1148 vdd vdd sky130_fd_pr__pfet_01v8 W=1.4 L=0.15
Xn_1149_n1 n_1149 n_1143 vss vss sky130_fd_pr__nfet_01v8 W=0.42 L=0.15
Xn_1149_n2 n_1149 n_1148 vss vss sky130_fd_pr__nfet_01v8 W=0.42 L=0.15
Xn_1148_p1 n_1148 n_1147 n_1148_x vdd sky130_fd_pr__pfet_01v8 W=1.4 L=0.15
Xn_1148_p2 n_1148_x n_1149 vdd vdd sky130_fd_pr__pfet_01v8 W=1.4 L=0.15
Xn_1148_n1 n_1148 n_1147 vss vss sky130_fd_pr__nfet_01v8 W=0.42 L=0.15
Xn_1148_n2 n_1148 n_1149 vss vss sky130_fd_pr__nfet_01v8 W=0.42 L=0.15
Xn_1150_n n_1150 x_neg13 vss vss sky130_fd_pr__nfet_01v8 W=0.42 L=0.15
Xn_1150_p n_1150 x_neg13 vdd vdd sky130_fd_pr__pfet_01v8 W=0.7 L=0.15
Xn_1151_p1 n_1151 n_1148 vdd vdd sky130_fd_pr__pfet_01v8 W=0.7 L=0.15
Xn_1151_p2 n_1151 n_1150 vdd vdd sky130_fd_pr__pfet_01v8 W=0.7 L=0.15
Xn_1151_n1 n_1151 n_1148 n_1151_x vss sky130_fd_pr__nfet_01v8 W=0.84 L=0.15
Xn_1151_n2 n_1151_x n_1150 vss vss sky130_fd_pr__nfet_01v8 W=0.84 L=0.15
Xxin_p_r13_n xin_p_r13 n_1151 vss vss sky130_fd_pr__nfet_01v8 W=0.42 L=0.15
Xxin_p_r13_p xin_p_r13 n_1151 vdd vdd sky130_fd_pr__pfet_01v8 W=0.7 L=0.15
Xn_1152_p1 n_1152 n_1148 vdd vdd sky130_fd_pr__pfet_01v8 W=0.7 L=0.15
Xn_1152_p2 n_1152 x_neg13 vdd vdd sky130_fd_pr__pfet_01v8 W=0.7 L=0.15
Xn_1152_n1 n_1152 n_1148 n_1152_x vss sky130_fd_pr__nfet_01v8 W=0.84 L=0.15
Xn_1152_n2 n_1152_x x_neg13 vss vss sky130_fd_pr__nfet_01v8 W=0.84 L=0.15
Xxin_n_r13_n xin_n_r13 n_1152 vss vss sky130_fd_pr__nfet_01v8 W=0.42 L=0.15
Xxin_n_r13_p xin_n_r13 n_1152 vdd vdd sky130_fd_pr__pfet_01v8 W=0.7 L=0.15
Xn_1153_p1 n_1153 n_1148 vdd vdd sky130_fd_pr__pfet_01v8 W=0.7 L=0.15
Xn_1153_p2 n_1153 lora_en vdd vdd sky130_fd_pr__pfet_01v8 W=0.7 L=0.15
Xn_1153_n1 n_1153 n_1148 n_1153_x vss sky130_fd_pr__nfet_01v8 W=0.84 L=0.15
Xn_1153_n2 n_1153_x lora_en vss vss sky130_fd_pr__nfet_01v8 W=0.84 L=0.15
Xxrd_en13_n xrd_en13 n_1153 vss vss sky130_fd_pr__nfet_01v8 W=0.42 L=0.15
Xxrd_en13_p xrd_en13 n_1153 vdd vdd sky130_fd_pr__pfet_01v8 W=0.7 L=0.15
Xn_1154_p1 n_1154 n_491 vdd vdd sky130_fd_pr__pfet_01v8 W=0.7 L=0.15
Xn_1154_p2 n_1154 x_mag56 vdd vdd sky130_fd_pr__pfet_01v8 W=0.7 L=0.15
Xn_1154_n1 n_1154 n_491 n_1154_x vss sky130_fd_pr__nfet_01v8 W=0.84 L=0.15
Xn_1154_n2 n_1154_x x_mag56 vss vss sky130_fd_pr__nfet_01v8 W=0.84 L=0.15
Xn_1155_n n_1155 n_1154 vss vss sky130_fd_pr__nfet_01v8 W=0.42 L=0.15
Xn_1155_p n_1155 n_1154 vdd vdd sky130_fd_pr__pfet_01v8 W=0.7 L=0.15
Xn_1156_p1 n_1156 n_492 vdd vdd sky130_fd_pr__pfet_01v8 W=0.7 L=0.15
Xn_1156_p2 n_1156 x_mag57 vdd vdd sky130_fd_pr__pfet_01v8 W=0.7 L=0.15
Xn_1156_n1 n_1156 n_492 n_1156_x vss sky130_fd_pr__nfet_01v8 W=0.84 L=0.15
Xn_1156_n2 n_1156_x x_mag57 vss vss sky130_fd_pr__nfet_01v8 W=0.84 L=0.15
Xn_1157_p1 n_1157 n_492 n_1157_x vdd sky130_fd_pr__pfet_01v8 W=1.4 L=0.15
Xn_1157_p2 n_1157_x x_mag57 vdd vdd sky130_fd_pr__pfet_01v8 W=1.4 L=0.15
Xn_1157_n1 n_1157 n_492 vss vss sky130_fd_pr__nfet_01v8 W=0.42 L=0.15
Xn_1157_n2 n_1157 x_mag57 vss vss sky130_fd_pr__nfet_01v8 W=0.42 L=0.15
Xn_1158_n n_1158 n_1157 vss vss sky130_fd_pr__nfet_01v8 W=0.42 L=0.15
Xn_1158_p n_1158 n_1157 vdd vdd sky130_fd_pr__pfet_01v8 W=0.7 L=0.15
Xn_1159_p1 n_1159 n_1155 vdd vdd sky130_fd_pr__pfet_01v8 W=0.7 L=0.15
Xn_1159_p2 n_1159 n_1158 vdd vdd sky130_fd_pr__pfet_01v8 W=0.7 L=0.15
Xn_1159_n1 n_1159 n_1155 n_1159_x vss sky130_fd_pr__nfet_01v8 W=0.84 L=0.15
Xn_1159_n2 n_1159_x n_1158 vss vss sky130_fd_pr__nfet_01v8 W=0.84 L=0.15
Xn_1160_p1 n_1160 n_1156 vdd vdd sky130_fd_pr__pfet_01v8 W=0.7 L=0.15
Xn_1160_p2 n_1160 n_1159 vdd vdd sky130_fd_pr__pfet_01v8 W=0.7 L=0.15
Xn_1160_n1 n_1160 n_1156 n_1160_x vss sky130_fd_pr__nfet_01v8 W=0.84 L=0.15
Xn_1160_n2 n_1160_x n_1159 vss vss sky130_fd_pr__nfet_01v8 W=0.84 L=0.15
Xn_1161_p1 n_1161 n_493 vdd vdd sky130_fd_pr__pfet_01v8 W=0.7 L=0.15
Xn_1161_p2 n_1161 x_mag58 vdd vdd sky130_fd_pr__pfet_01v8 W=0.7 L=0.15
Xn_1161_n1 n_1161 n_493 n_1161_x vss sky130_fd_pr__nfet_01v8 W=0.84 L=0.15
Xn_1161_n2 n_1161_x x_mag58 vss vss sky130_fd_pr__nfet_01v8 W=0.84 L=0.15
Xn_1162_p1 n_1162 n_493 n_1162_x vdd sky130_fd_pr__pfet_01v8 W=1.4 L=0.15
Xn_1162_p2 n_1162_x x_mag58 vdd vdd sky130_fd_pr__pfet_01v8 W=1.4 L=0.15
Xn_1162_n1 n_1162 n_493 vss vss sky130_fd_pr__nfet_01v8 W=0.42 L=0.15
Xn_1162_n2 n_1162 x_mag58 vss vss sky130_fd_pr__nfet_01v8 W=0.42 L=0.15
Xn_1163_n n_1163 n_1162 vss vss sky130_fd_pr__nfet_01v8 W=0.42 L=0.15
Xn_1163_p n_1163 n_1162 vdd vdd sky130_fd_pr__pfet_01v8 W=0.7 L=0.15
Xn_1164_p1 n_1164 n_1160 vdd vdd sky130_fd_pr__pfet_01v8 W=0.7 L=0.15
Xn_1164_p2 n_1164 n_1163 vdd vdd sky130_fd_pr__pfet_01v8 W=0.7 L=0.15
Xn_1164_n1 n_1164 n_1160 n_1164_x vss sky130_fd_pr__nfet_01v8 W=0.84 L=0.15
Xn_1164_n2 n_1164_x n_1163 vss vss sky130_fd_pr__nfet_01v8 W=0.84 L=0.15
Xn_1165_p1 n_1165 n_1161 vdd vdd sky130_fd_pr__pfet_01v8 W=0.7 L=0.15
Xn_1165_p2 n_1165 n_1164 vdd vdd sky130_fd_pr__pfet_01v8 W=0.7 L=0.15
Xn_1165_n1 n_1165 n_1161 n_1165_x vss sky130_fd_pr__nfet_01v8 W=0.84 L=0.15
Xn_1165_n2 n_1165_x n_1164 vss vss sky130_fd_pr__nfet_01v8 W=0.84 L=0.15
Xn_1166_p1 n_1166 n_494 vdd vdd sky130_fd_pr__pfet_01v8 W=0.7 L=0.15
Xn_1166_p2 n_1166 x_mag59 vdd vdd sky130_fd_pr__pfet_01v8 W=0.7 L=0.15
Xn_1166_n1 n_1166 n_494 n_1166_x vss sky130_fd_pr__nfet_01v8 W=0.84 L=0.15
Xn_1166_n2 n_1166_x x_mag59 vss vss sky130_fd_pr__nfet_01v8 W=0.84 L=0.15
Xn_1167_p1 n_1167 n_494 n_1167_x vdd sky130_fd_pr__pfet_01v8 W=1.4 L=0.15
Xn_1167_p2 n_1167_x x_mag59 vdd vdd sky130_fd_pr__pfet_01v8 W=1.4 L=0.15
Xn_1167_n1 n_1167 n_494 vss vss sky130_fd_pr__nfet_01v8 W=0.42 L=0.15
Xn_1167_n2 n_1167 x_mag59 vss vss sky130_fd_pr__nfet_01v8 W=0.42 L=0.15
Xn_1168_n n_1168 n_1167 vss vss sky130_fd_pr__nfet_01v8 W=0.42 L=0.15
Xn_1168_p n_1168 n_1167 vdd vdd sky130_fd_pr__pfet_01v8 W=0.7 L=0.15
Xn_1169_p1 n_1169 n_1165 vdd vdd sky130_fd_pr__pfet_01v8 W=0.7 L=0.15
Xn_1169_p2 n_1169 n_1168 vdd vdd sky130_fd_pr__pfet_01v8 W=0.7 L=0.15
Xn_1169_n1 n_1169 n_1165 n_1169_x vss sky130_fd_pr__nfet_01v8 W=0.84 L=0.15
Xn_1169_n2 n_1169_x n_1168 vss vss sky130_fd_pr__nfet_01v8 W=0.84 L=0.15
Xn_1170_p1 n_1170 n_1166 vdd vdd sky130_fd_pr__pfet_01v8 W=0.7 L=0.15
Xn_1170_p2 n_1170 n_1169 vdd vdd sky130_fd_pr__pfet_01v8 W=0.7 L=0.15
Xn_1170_n1 n_1170 n_1166 n_1170_x vss sky130_fd_pr__nfet_01v8 W=0.84 L=0.15
Xn_1170_n2 n_1170_x n_1169 vss vss sky130_fd_pr__nfet_01v8 W=0.84 L=0.15
Xn_1171_p1 n_1171 n_307 vdd vdd sky130_fd_pr__pfet_01v8 W=0.7 L=0.15
Xn_1171_p2 n_1171 n_1170 vdd vdd sky130_fd_pr__pfet_01v8 W=0.7 L=0.15
Xn_1171_n1 n_1171 n_307 n_1171_x vss sky130_fd_pr__nfet_01v8 W=0.84 L=0.15
Xn_1171_n2 n_1171_x n_1170 vss vss sky130_fd_pr__nfet_01v8 W=0.84 L=0.15
Xn_1172_n n_1172 n_1171 vss vss sky130_fd_pr__nfet_01v8 W=0.42 L=0.15
Xn_1172_p n_1172 n_1171 vdd vdd sky130_fd_pr__pfet_01v8 W=0.7 L=0.15
Xn_1173_p1 n_1173 n_344 vdd vdd sky130_fd_pr__pfet_01v8 W=0.7 L=0.15
Xn_1173_p2 n_1173 n_1172 vdd vdd sky130_fd_pr__pfet_01v8 W=0.7 L=0.15
Xn_1173_n1 n_1173 n_344 n_1173_x vss sky130_fd_pr__nfet_01v8 W=0.84 L=0.15
Xn_1173_n2 n_1173_x n_1172 vss vss sky130_fd_pr__nfet_01v8 W=0.84 L=0.15
Xn_1174_p1 n_1174 n_495 vdd vdd sky130_fd_pr__pfet_01v8 W=0.7 L=0.15
Xn_1174_p2 n_1174 env14 vdd vdd sky130_fd_pr__pfet_01v8 W=0.7 L=0.15
Xn_1174_n1 n_1174 n_495 n_1174_x vss sky130_fd_pr__nfet_01v8 W=0.84 L=0.15
Xn_1174_n2 n_1174_x env14 vss vss sky130_fd_pr__nfet_01v8 W=0.84 L=0.15
Xn_1175_p1 n_1175 n_1173 vdd vdd sky130_fd_pr__pfet_01v8 W=0.7 L=0.15
Xn_1175_p2 n_1175 n_1174 vdd vdd sky130_fd_pr__pfet_01v8 W=0.7 L=0.15
Xn_1175_n1 n_1175 n_1173 n_1175_x vss sky130_fd_pr__nfet_01v8 W=0.84 L=0.15
Xn_1175_n2 n_1175_x n_1174 vss vss sky130_fd_pr__nfet_01v8 W=0.84 L=0.15
Xn_1176_n n_1176 n_1175 vss vss sky130_fd_pr__nfet_01v8 W=0.42 L=0.15
Xn_1176_p n_1176 n_1175 vdd vdd sky130_fd_pr__pfet_01v8 W=0.7 L=0.15
Xn_1177_p1 n_1177 n_1175 n_1177_x vdd sky130_fd_pr__pfet_01v8 W=1.4 L=0.15
Xn_1177_p2 n_1177_x n_106 vdd vdd sky130_fd_pr__pfet_01v8 W=1.4 L=0.15
Xn_1177_n1 n_1177 n_1175 vss vss sky130_fd_pr__nfet_01v8 W=0.42 L=0.15
Xn_1177_n2 n_1177 n_106 vss vss sky130_fd_pr__nfet_01v8 W=0.42 L=0.15
Xn_1178_p1 n_1178 n_1177 n_1178_x vdd sky130_fd_pr__pfet_01v8 W=1.4 L=0.15
Xn_1178_p2 n_1178_x n_4 vdd vdd sky130_fd_pr__pfet_01v8 W=1.4 L=0.15
Xn_1178_n1 n_1178 n_1177 vss vss sky130_fd_pr__nfet_01v8 W=0.42 L=0.15
Xn_1178_n2 n_1178 n_4 vss vss sky130_fd_pr__nfet_01v8 W=0.42 L=0.15
Xn_1179_n n_1179 n_1178 vss vss sky130_fd_pr__nfet_01v8 W=0.42 L=0.15
Xn_1179_p n_1179 n_1178 vdd vdd sky130_fd_pr__pfet_01v8 W=0.7 L=0.15
Xn_1182_p1 n_1182 n_1176 n_1182_x vdd sky130_fd_pr__pfet_01v8 W=1.4 L=0.15
Xn_1182_p2 n_1182_x n_106 vdd vdd sky130_fd_pr__pfet_01v8 W=1.4 L=0.15
Xn_1182_n1 n_1182 n_1176 vss vss sky130_fd_pr__nfet_01v8 W=0.42 L=0.15
Xn_1182_n2 n_1182 n_106 vss vss sky130_fd_pr__nfet_01v8 W=0.42 L=0.15
Xn_1181_p1 n_1181 n_1182 n_1181_x vdd sky130_fd_pr__pfet_01v8 W=1.4 L=0.15
Xn_1181_p2 n_1181_x n_1180 vdd vdd sky130_fd_pr__pfet_01v8 W=1.4 L=0.15
Xn_1181_n1 n_1181 n_1182 vss vss sky130_fd_pr__nfet_01v8 W=0.42 L=0.15
Xn_1181_n2 n_1181 n_1180 vss vss sky130_fd_pr__nfet_01v8 W=0.42 L=0.15
Xn_1180_p1 n_1180 n_1179 n_1180_x vdd sky130_fd_pr__pfet_01v8 W=1.4 L=0.15
Xn_1180_p2 n_1180_x n_1181 vdd vdd sky130_fd_pr__pfet_01v8 W=1.4 L=0.15
Xn_1180_n1 n_1180 n_1179 vss vss sky130_fd_pr__nfet_01v8 W=0.42 L=0.15
Xn_1180_n2 n_1180 n_1181 vss vss sky130_fd_pr__nfet_01v8 W=0.42 L=0.15
Xn_1183_p1 n_1183 n_1180 n_1183_x vdd sky130_fd_pr__pfet_01v8 W=1.4 L=0.15
Xn_1183_p2 n_1183_x n_109 vdd vdd sky130_fd_pr__pfet_01v8 W=1.4 L=0.15
Xn_1183_n1 n_1183 n_1180 vss vss sky130_fd_pr__nfet_01v8 W=0.42 L=0.15
Xn_1183_n2 n_1183 n_109 vss vss sky130_fd_pr__nfet_01v8 W=0.42 L=0.15
Xn_1184_p1 n_1184 n_1183 n_1184_x vdd sky130_fd_pr__pfet_01v8 W=1.4 L=0.15
Xn_1184_p2 n_1184_x n_4 vdd vdd sky130_fd_pr__pfet_01v8 W=1.4 L=0.15
Xn_1184_n1 n_1184 n_1183 vss vss sky130_fd_pr__nfet_01v8 W=0.42 L=0.15
Xn_1184_n2 n_1184 n_4 vss vss sky130_fd_pr__nfet_01v8 W=0.42 L=0.15
Xn_1185_n n_1185 n_1184 vss vss sky130_fd_pr__nfet_01v8 W=0.42 L=0.15
Xn_1185_p n_1185 n_1184 vdd vdd sky130_fd_pr__pfet_01v8 W=0.7 L=0.15
Xn_1187_p1 n_1187 n_1181 n_1187_x vdd sky130_fd_pr__pfet_01v8 W=1.4 L=0.15
Xn_1187_p2 n_1187_x n_109 vdd vdd sky130_fd_pr__pfet_01v8 W=1.4 L=0.15
Xn_1187_n1 n_1187 n_1181 vss vss sky130_fd_pr__nfet_01v8 W=0.42 L=0.15
Xn_1187_n2 n_1187 n_109 vss vss sky130_fd_pr__nfet_01v8 W=0.42 L=0.15
Xn_1186_p1 n_1186 n_1187 n_1186_x vdd sky130_fd_pr__pfet_01v8 W=1.4 L=0.15
Xn_1186_p2 n_1186_x env14 vdd vdd sky130_fd_pr__pfet_01v8 W=1.4 L=0.15
Xn_1186_n1 n_1186 n_1187 vss vss sky130_fd_pr__nfet_01v8 W=0.42 L=0.15
Xn_1186_n2 n_1186 env14 vss vss sky130_fd_pr__nfet_01v8 W=0.42 L=0.15
Xenv14_p1 env14 n_1185 env14_x vdd sky130_fd_pr__pfet_01v8 W=1.4 L=0.15
Xenv14_p2 env14_x n_1186 vdd vdd sky130_fd_pr__pfet_01v8 W=1.4 L=0.15
Xenv14_n1 env14 n_1185 vss vss sky130_fd_pr__nfet_01v8 W=0.42 L=0.15
Xenv14_n2 env14 n_1186 vss vss sky130_fd_pr__nfet_01v8 W=0.42 L=0.15
Xn_1188_n n_1188 env14 vss vss sky130_fd_pr__nfet_01v8 W=0.42 L=0.15
Xn_1188_p n_1188 env14 vdd vdd sky130_fd_pr__pfet_01v8 W=0.7 L=0.15
Xn_1189_p1 n_1189 env14 vdd vdd sky130_fd_pr__pfet_01v8 W=0.7 L=0.15
Xn_1189_p2 n_1189 t_ck vdd vdd sky130_fd_pr__pfet_01v8 W=0.7 L=0.15
Xn_1189_n1 n_1189 env14 n_1189_x vss sky130_fd_pr__nfet_01v8 W=0.84 L=0.15
Xn_1189_n2 n_1189_x t_ck vss vss sky130_fd_pr__nfet_01v8 W=0.84 L=0.15
Xn_1190_n n_1190 n_1189 vss vss sky130_fd_pr__nfet_01v8 W=0.42 L=0.15
Xn_1190_p n_1190 n_1189 vdd vdd sky130_fd_pr__pfet_01v8 W=0.7 L=0.15
Xn_1191_p1 n_1191 n_1188 vdd vdd sky130_fd_pr__pfet_01v8 W=0.7 L=0.15
Xn_1191_p2 n_1191 t_ck vdd vdd sky130_fd_pr__pfet_01v8 W=0.7 L=0.15
Xn_1191_n1 n_1191 n_1188 n_1191_x vss sky130_fd_pr__nfet_01v8 W=0.84 L=0.15
Xn_1191_n2 n_1191_x t_ck vss vss sky130_fd_pr__nfet_01v8 W=0.84 L=0.15
Xn_1192_n n_1192 n_1191 vss vss sky130_fd_pr__nfet_01v8 W=0.42 L=0.15
Xn_1192_p n_1192 n_1191 vdd vdd sky130_fd_pr__pfet_01v8 W=0.7 L=0.15
Xn_1193_p1 n_1193 n_1192 n_1193_x vdd sky130_fd_pr__pfet_01v8 W=1.4 L=0.15
Xn_1193_p2 n_1193_x n_4 vdd vdd sky130_fd_pr__pfet_01v8 W=1.4 L=0.15
Xn_1193_n1 n_1193 n_1192 vss vss sky130_fd_pr__nfet_01v8 W=0.42 L=0.15
Xn_1193_n2 n_1193 n_4 vss vss sky130_fd_pr__nfet_01v8 W=0.42 L=0.15
Xn_1194_n n_1194 n_1193 vss vss sky130_fd_pr__nfet_01v8 W=0.42 L=0.15
Xn_1194_p n_1194 n_1193 vdd vdd sky130_fd_pr__pfet_01v8 W=0.7 L=0.15
Xn_1196_p1 n_1196 n_1190 n_1196_x vdd sky130_fd_pr__pfet_01v8 W=1.4 L=0.15
Xn_1196_p2 n_1196_x n_1195 vdd vdd sky130_fd_pr__pfet_01v8 W=1.4 L=0.15
Xn_1196_n1 n_1196 n_1190 vss vss sky130_fd_pr__nfet_01v8 W=0.42 L=0.15
Xn_1196_n2 n_1196 n_1195 vss vss sky130_fd_pr__nfet_01v8 W=0.42 L=0.15
Xn_1195_p1 n_1195 n_1194 n_1195_x vdd sky130_fd_pr__pfet_01v8 W=1.4 L=0.15
Xn_1195_p2 n_1195_x n_1196 vdd vdd sky130_fd_pr__pfet_01v8 W=1.4 L=0.15
Xn_1195_n1 n_1195 n_1194 vss vss sky130_fd_pr__nfet_01v8 W=0.42 L=0.15
Xn_1195_n2 n_1195 n_1196 vss vss sky130_fd_pr__nfet_01v8 W=0.42 L=0.15
Xn_1197_n n_1197 x_neg14 vss vss sky130_fd_pr__nfet_01v8 W=0.42 L=0.15
Xn_1197_p n_1197 x_neg14 vdd vdd sky130_fd_pr__pfet_01v8 W=0.7 L=0.15
Xn_1198_p1 n_1198 n_1195 vdd vdd sky130_fd_pr__pfet_01v8 W=0.7 L=0.15
Xn_1198_p2 n_1198 n_1197 vdd vdd sky130_fd_pr__pfet_01v8 W=0.7 L=0.15
Xn_1198_n1 n_1198 n_1195 n_1198_x vss sky130_fd_pr__nfet_01v8 W=0.84 L=0.15
Xn_1198_n2 n_1198_x n_1197 vss vss sky130_fd_pr__nfet_01v8 W=0.84 L=0.15
Xxin_p_r14_n xin_p_r14 n_1198 vss vss sky130_fd_pr__nfet_01v8 W=0.42 L=0.15
Xxin_p_r14_p xin_p_r14 n_1198 vdd vdd sky130_fd_pr__pfet_01v8 W=0.7 L=0.15
Xn_1199_p1 n_1199 n_1195 vdd vdd sky130_fd_pr__pfet_01v8 W=0.7 L=0.15
Xn_1199_p2 n_1199 x_neg14 vdd vdd sky130_fd_pr__pfet_01v8 W=0.7 L=0.15
Xn_1199_n1 n_1199 n_1195 n_1199_x vss sky130_fd_pr__nfet_01v8 W=0.84 L=0.15
Xn_1199_n2 n_1199_x x_neg14 vss vss sky130_fd_pr__nfet_01v8 W=0.84 L=0.15
Xxin_n_r14_n xin_n_r14 n_1199 vss vss sky130_fd_pr__nfet_01v8 W=0.42 L=0.15
Xxin_n_r14_p xin_n_r14 n_1199 vdd vdd sky130_fd_pr__pfet_01v8 W=0.7 L=0.15
Xn_1200_p1 n_1200 n_1195 vdd vdd sky130_fd_pr__pfet_01v8 W=0.7 L=0.15
Xn_1200_p2 n_1200 lora_en vdd vdd sky130_fd_pr__pfet_01v8 W=0.7 L=0.15
Xn_1200_n1 n_1200 n_1195 n_1200_x vss sky130_fd_pr__nfet_01v8 W=0.84 L=0.15
Xn_1200_n2 n_1200_x lora_en vss vss sky130_fd_pr__nfet_01v8 W=0.84 L=0.15
Xxrd_en14_n xrd_en14 n_1200 vss vss sky130_fd_pr__nfet_01v8 W=0.42 L=0.15
Xxrd_en14_p xrd_en14 n_1200 vdd vdd sky130_fd_pr__pfet_01v8 W=0.7 L=0.15
Xn_1201_p1 n_1201 n_491 vdd vdd sky130_fd_pr__pfet_01v8 W=0.7 L=0.15
Xn_1201_p2 n_1201 x_mag60 vdd vdd sky130_fd_pr__pfet_01v8 W=0.7 L=0.15
Xn_1201_n1 n_1201 n_491 n_1201_x vss sky130_fd_pr__nfet_01v8 W=0.84 L=0.15
Xn_1201_n2 n_1201_x x_mag60 vss vss sky130_fd_pr__nfet_01v8 W=0.84 L=0.15
Xn_1202_n n_1202 n_1201 vss vss sky130_fd_pr__nfet_01v8 W=0.42 L=0.15
Xn_1202_p n_1202 n_1201 vdd vdd sky130_fd_pr__pfet_01v8 W=0.7 L=0.15
Xn_1203_p1 n_1203 n_492 vdd vdd sky130_fd_pr__pfet_01v8 W=0.7 L=0.15
Xn_1203_p2 n_1203 x_mag61 vdd vdd sky130_fd_pr__pfet_01v8 W=0.7 L=0.15
Xn_1203_n1 n_1203 n_492 n_1203_x vss sky130_fd_pr__nfet_01v8 W=0.84 L=0.15
Xn_1203_n2 n_1203_x x_mag61 vss vss sky130_fd_pr__nfet_01v8 W=0.84 L=0.15
Xn_1204_p1 n_1204 n_492 n_1204_x vdd sky130_fd_pr__pfet_01v8 W=1.4 L=0.15
Xn_1204_p2 n_1204_x x_mag61 vdd vdd sky130_fd_pr__pfet_01v8 W=1.4 L=0.15
Xn_1204_n1 n_1204 n_492 vss vss sky130_fd_pr__nfet_01v8 W=0.42 L=0.15
Xn_1204_n2 n_1204 x_mag61 vss vss sky130_fd_pr__nfet_01v8 W=0.42 L=0.15
Xn_1205_n n_1205 n_1204 vss vss sky130_fd_pr__nfet_01v8 W=0.42 L=0.15
Xn_1205_p n_1205 n_1204 vdd vdd sky130_fd_pr__pfet_01v8 W=0.7 L=0.15
Xn_1206_p1 n_1206 n_1202 vdd vdd sky130_fd_pr__pfet_01v8 W=0.7 L=0.15
Xn_1206_p2 n_1206 n_1205 vdd vdd sky130_fd_pr__pfet_01v8 W=0.7 L=0.15
Xn_1206_n1 n_1206 n_1202 n_1206_x vss sky130_fd_pr__nfet_01v8 W=0.84 L=0.15
Xn_1206_n2 n_1206_x n_1205 vss vss sky130_fd_pr__nfet_01v8 W=0.84 L=0.15
Xn_1207_p1 n_1207 n_1203 vdd vdd sky130_fd_pr__pfet_01v8 W=0.7 L=0.15
Xn_1207_p2 n_1207 n_1206 vdd vdd sky130_fd_pr__pfet_01v8 W=0.7 L=0.15
Xn_1207_n1 n_1207 n_1203 n_1207_x vss sky130_fd_pr__nfet_01v8 W=0.84 L=0.15
Xn_1207_n2 n_1207_x n_1206 vss vss sky130_fd_pr__nfet_01v8 W=0.84 L=0.15
Xn_1208_p1 n_1208 n_493 vdd vdd sky130_fd_pr__pfet_01v8 W=0.7 L=0.15
Xn_1208_p2 n_1208 x_mag62 vdd vdd sky130_fd_pr__pfet_01v8 W=0.7 L=0.15
Xn_1208_n1 n_1208 n_493 n_1208_x vss sky130_fd_pr__nfet_01v8 W=0.84 L=0.15
Xn_1208_n2 n_1208_x x_mag62 vss vss sky130_fd_pr__nfet_01v8 W=0.84 L=0.15
Xn_1209_p1 n_1209 n_493 n_1209_x vdd sky130_fd_pr__pfet_01v8 W=1.4 L=0.15
Xn_1209_p2 n_1209_x x_mag62 vdd vdd sky130_fd_pr__pfet_01v8 W=1.4 L=0.15
Xn_1209_n1 n_1209 n_493 vss vss sky130_fd_pr__nfet_01v8 W=0.42 L=0.15
Xn_1209_n2 n_1209 x_mag62 vss vss sky130_fd_pr__nfet_01v8 W=0.42 L=0.15
Xn_1210_n n_1210 n_1209 vss vss sky130_fd_pr__nfet_01v8 W=0.42 L=0.15
Xn_1210_p n_1210 n_1209 vdd vdd sky130_fd_pr__pfet_01v8 W=0.7 L=0.15
Xn_1211_p1 n_1211 n_1207 vdd vdd sky130_fd_pr__pfet_01v8 W=0.7 L=0.15
Xn_1211_p2 n_1211 n_1210 vdd vdd sky130_fd_pr__pfet_01v8 W=0.7 L=0.15
Xn_1211_n1 n_1211 n_1207 n_1211_x vss sky130_fd_pr__nfet_01v8 W=0.84 L=0.15
Xn_1211_n2 n_1211_x n_1210 vss vss sky130_fd_pr__nfet_01v8 W=0.84 L=0.15
Xn_1212_p1 n_1212 n_1208 vdd vdd sky130_fd_pr__pfet_01v8 W=0.7 L=0.15
Xn_1212_p2 n_1212 n_1211 vdd vdd sky130_fd_pr__pfet_01v8 W=0.7 L=0.15
Xn_1212_n1 n_1212 n_1208 n_1212_x vss sky130_fd_pr__nfet_01v8 W=0.84 L=0.15
Xn_1212_n2 n_1212_x n_1211 vss vss sky130_fd_pr__nfet_01v8 W=0.84 L=0.15
Xn_1213_p1 n_1213 n_494 vdd vdd sky130_fd_pr__pfet_01v8 W=0.7 L=0.15
Xn_1213_p2 n_1213 x_mag63 vdd vdd sky130_fd_pr__pfet_01v8 W=0.7 L=0.15
Xn_1213_n1 n_1213 n_494 n_1213_x vss sky130_fd_pr__nfet_01v8 W=0.84 L=0.15
Xn_1213_n2 n_1213_x x_mag63 vss vss sky130_fd_pr__nfet_01v8 W=0.84 L=0.15
Xn_1214_p1 n_1214 n_494 n_1214_x vdd sky130_fd_pr__pfet_01v8 W=1.4 L=0.15
Xn_1214_p2 n_1214_x x_mag63 vdd vdd sky130_fd_pr__pfet_01v8 W=1.4 L=0.15
Xn_1214_n1 n_1214 n_494 vss vss sky130_fd_pr__nfet_01v8 W=0.42 L=0.15
Xn_1214_n2 n_1214 x_mag63 vss vss sky130_fd_pr__nfet_01v8 W=0.42 L=0.15
Xn_1215_n n_1215 n_1214 vss vss sky130_fd_pr__nfet_01v8 W=0.42 L=0.15
Xn_1215_p n_1215 n_1214 vdd vdd sky130_fd_pr__pfet_01v8 W=0.7 L=0.15
Xn_1216_p1 n_1216 n_1212 vdd vdd sky130_fd_pr__pfet_01v8 W=0.7 L=0.15
Xn_1216_p2 n_1216 n_1215 vdd vdd sky130_fd_pr__pfet_01v8 W=0.7 L=0.15
Xn_1216_n1 n_1216 n_1212 n_1216_x vss sky130_fd_pr__nfet_01v8 W=0.84 L=0.15
Xn_1216_n2 n_1216_x n_1215 vss vss sky130_fd_pr__nfet_01v8 W=0.84 L=0.15
Xn_1217_p1 n_1217 n_1213 vdd vdd sky130_fd_pr__pfet_01v8 W=0.7 L=0.15
Xn_1217_p2 n_1217 n_1216 vdd vdd sky130_fd_pr__pfet_01v8 W=0.7 L=0.15
Xn_1217_n1 n_1217 n_1213 n_1217_x vss sky130_fd_pr__nfet_01v8 W=0.84 L=0.15
Xn_1217_n2 n_1217_x n_1216 vss vss sky130_fd_pr__nfet_01v8 W=0.84 L=0.15
Xn_1218_p1 n_1218 n_307 vdd vdd sky130_fd_pr__pfet_01v8 W=0.7 L=0.15
Xn_1218_p2 n_1218 n_1217 vdd vdd sky130_fd_pr__pfet_01v8 W=0.7 L=0.15
Xn_1218_n1 n_1218 n_307 n_1218_x vss sky130_fd_pr__nfet_01v8 W=0.84 L=0.15
Xn_1218_n2 n_1218_x n_1217 vss vss sky130_fd_pr__nfet_01v8 W=0.84 L=0.15
Xn_1219_n n_1219 n_1218 vss vss sky130_fd_pr__nfet_01v8 W=0.42 L=0.15
Xn_1219_p n_1219 n_1218 vdd vdd sky130_fd_pr__pfet_01v8 W=0.7 L=0.15
Xn_1220_p1 n_1220 n_344 vdd vdd sky130_fd_pr__pfet_01v8 W=0.7 L=0.15
Xn_1220_p2 n_1220 n_1219 vdd vdd sky130_fd_pr__pfet_01v8 W=0.7 L=0.15
Xn_1220_n1 n_1220 n_344 n_1220_x vss sky130_fd_pr__nfet_01v8 W=0.84 L=0.15
Xn_1220_n2 n_1220_x n_1219 vss vss sky130_fd_pr__nfet_01v8 W=0.84 L=0.15
Xn_1221_p1 n_1221 n_495 vdd vdd sky130_fd_pr__pfet_01v8 W=0.7 L=0.15
Xn_1221_p2 n_1221 env15 vdd vdd sky130_fd_pr__pfet_01v8 W=0.7 L=0.15
Xn_1221_n1 n_1221 n_495 n_1221_x vss sky130_fd_pr__nfet_01v8 W=0.84 L=0.15
Xn_1221_n2 n_1221_x env15 vss vss sky130_fd_pr__nfet_01v8 W=0.84 L=0.15
Xn_1222_p1 n_1222 n_1220 vdd vdd sky130_fd_pr__pfet_01v8 W=0.7 L=0.15
Xn_1222_p2 n_1222 n_1221 vdd vdd sky130_fd_pr__pfet_01v8 W=0.7 L=0.15
Xn_1222_n1 n_1222 n_1220 n_1222_x vss sky130_fd_pr__nfet_01v8 W=0.84 L=0.15
Xn_1222_n2 n_1222_x n_1221 vss vss sky130_fd_pr__nfet_01v8 W=0.84 L=0.15
Xn_1223_n n_1223 n_1222 vss vss sky130_fd_pr__nfet_01v8 W=0.42 L=0.15
Xn_1223_p n_1223 n_1222 vdd vdd sky130_fd_pr__pfet_01v8 W=0.7 L=0.15
Xn_1224_p1 n_1224 n_1222 n_1224_x vdd sky130_fd_pr__pfet_01v8 W=1.4 L=0.15
Xn_1224_p2 n_1224_x n_106 vdd vdd sky130_fd_pr__pfet_01v8 W=1.4 L=0.15
Xn_1224_n1 n_1224 n_1222 vss vss sky130_fd_pr__nfet_01v8 W=0.42 L=0.15
Xn_1224_n2 n_1224 n_106 vss vss sky130_fd_pr__nfet_01v8 W=0.42 L=0.15
Xn_1225_p1 n_1225 n_1224 n_1225_x vdd sky130_fd_pr__pfet_01v8 W=1.4 L=0.15
Xn_1225_p2 n_1225_x n_4 vdd vdd sky130_fd_pr__pfet_01v8 W=1.4 L=0.15
Xn_1225_n1 n_1225 n_1224 vss vss sky130_fd_pr__nfet_01v8 W=0.42 L=0.15
Xn_1225_n2 n_1225 n_4 vss vss sky130_fd_pr__nfet_01v8 W=0.42 L=0.15
Xn_1226_n n_1226 n_1225 vss vss sky130_fd_pr__nfet_01v8 W=0.42 L=0.15
Xn_1226_p n_1226 n_1225 vdd vdd sky130_fd_pr__pfet_01v8 W=0.7 L=0.15
Xn_1229_p1 n_1229 n_1223 n_1229_x vdd sky130_fd_pr__pfet_01v8 W=1.4 L=0.15
Xn_1229_p2 n_1229_x n_106 vdd vdd sky130_fd_pr__pfet_01v8 W=1.4 L=0.15
Xn_1229_n1 n_1229 n_1223 vss vss sky130_fd_pr__nfet_01v8 W=0.42 L=0.15
Xn_1229_n2 n_1229 n_106 vss vss sky130_fd_pr__nfet_01v8 W=0.42 L=0.15
Xn_1228_p1 n_1228 n_1229 n_1228_x vdd sky130_fd_pr__pfet_01v8 W=1.4 L=0.15
Xn_1228_p2 n_1228_x n_1227 vdd vdd sky130_fd_pr__pfet_01v8 W=1.4 L=0.15
Xn_1228_n1 n_1228 n_1229 vss vss sky130_fd_pr__nfet_01v8 W=0.42 L=0.15
Xn_1228_n2 n_1228 n_1227 vss vss sky130_fd_pr__nfet_01v8 W=0.42 L=0.15
Xn_1227_p1 n_1227 n_1226 n_1227_x vdd sky130_fd_pr__pfet_01v8 W=1.4 L=0.15
Xn_1227_p2 n_1227_x n_1228 vdd vdd sky130_fd_pr__pfet_01v8 W=1.4 L=0.15
Xn_1227_n1 n_1227 n_1226 vss vss sky130_fd_pr__nfet_01v8 W=0.42 L=0.15
Xn_1227_n2 n_1227 n_1228 vss vss sky130_fd_pr__nfet_01v8 W=0.42 L=0.15
Xn_1230_p1 n_1230 n_1227 n_1230_x vdd sky130_fd_pr__pfet_01v8 W=1.4 L=0.15
Xn_1230_p2 n_1230_x n_109 vdd vdd sky130_fd_pr__pfet_01v8 W=1.4 L=0.15
Xn_1230_n1 n_1230 n_1227 vss vss sky130_fd_pr__nfet_01v8 W=0.42 L=0.15
Xn_1230_n2 n_1230 n_109 vss vss sky130_fd_pr__nfet_01v8 W=0.42 L=0.15
Xn_1231_p1 n_1231 n_1230 n_1231_x vdd sky130_fd_pr__pfet_01v8 W=1.4 L=0.15
Xn_1231_p2 n_1231_x n_4 vdd vdd sky130_fd_pr__pfet_01v8 W=1.4 L=0.15
Xn_1231_n1 n_1231 n_1230 vss vss sky130_fd_pr__nfet_01v8 W=0.42 L=0.15
Xn_1231_n2 n_1231 n_4 vss vss sky130_fd_pr__nfet_01v8 W=0.42 L=0.15
Xn_1232_n n_1232 n_1231 vss vss sky130_fd_pr__nfet_01v8 W=0.42 L=0.15
Xn_1232_p n_1232 n_1231 vdd vdd sky130_fd_pr__pfet_01v8 W=0.7 L=0.15
Xn_1234_p1 n_1234 n_1228 n_1234_x vdd sky130_fd_pr__pfet_01v8 W=1.4 L=0.15
Xn_1234_p2 n_1234_x n_109 vdd vdd sky130_fd_pr__pfet_01v8 W=1.4 L=0.15
Xn_1234_n1 n_1234 n_1228 vss vss sky130_fd_pr__nfet_01v8 W=0.42 L=0.15
Xn_1234_n2 n_1234 n_109 vss vss sky130_fd_pr__nfet_01v8 W=0.42 L=0.15
Xn_1233_p1 n_1233 n_1234 n_1233_x vdd sky130_fd_pr__pfet_01v8 W=1.4 L=0.15
Xn_1233_p2 n_1233_x env15 vdd vdd sky130_fd_pr__pfet_01v8 W=1.4 L=0.15
Xn_1233_n1 n_1233 n_1234 vss vss sky130_fd_pr__nfet_01v8 W=0.42 L=0.15
Xn_1233_n2 n_1233 env15 vss vss sky130_fd_pr__nfet_01v8 W=0.42 L=0.15
Xenv15_p1 env15 n_1232 env15_x vdd sky130_fd_pr__pfet_01v8 W=1.4 L=0.15
Xenv15_p2 env15_x n_1233 vdd vdd sky130_fd_pr__pfet_01v8 W=1.4 L=0.15
Xenv15_n1 env15 n_1232 vss vss sky130_fd_pr__nfet_01v8 W=0.42 L=0.15
Xenv15_n2 env15 n_1233 vss vss sky130_fd_pr__nfet_01v8 W=0.42 L=0.15
Xn_1235_n n_1235 env15 vss vss sky130_fd_pr__nfet_01v8 W=0.42 L=0.15
Xn_1235_p n_1235 env15 vdd vdd sky130_fd_pr__pfet_01v8 W=0.7 L=0.15
Xn_1236_p1 n_1236 env15 vdd vdd sky130_fd_pr__pfet_01v8 W=0.7 L=0.15
Xn_1236_p2 n_1236 t_ck vdd vdd sky130_fd_pr__pfet_01v8 W=0.7 L=0.15
Xn_1236_n1 n_1236 env15 n_1236_x vss sky130_fd_pr__nfet_01v8 W=0.84 L=0.15
Xn_1236_n2 n_1236_x t_ck vss vss sky130_fd_pr__nfet_01v8 W=0.84 L=0.15
Xn_1237_n n_1237 n_1236 vss vss sky130_fd_pr__nfet_01v8 W=0.42 L=0.15
Xn_1237_p n_1237 n_1236 vdd vdd sky130_fd_pr__pfet_01v8 W=0.7 L=0.15
Xn_1238_p1 n_1238 n_1235 vdd vdd sky130_fd_pr__pfet_01v8 W=0.7 L=0.15
Xn_1238_p2 n_1238 t_ck vdd vdd sky130_fd_pr__pfet_01v8 W=0.7 L=0.15
Xn_1238_n1 n_1238 n_1235 n_1238_x vss sky130_fd_pr__nfet_01v8 W=0.84 L=0.15
Xn_1238_n2 n_1238_x t_ck vss vss sky130_fd_pr__nfet_01v8 W=0.84 L=0.15
Xn_1239_n n_1239 n_1238 vss vss sky130_fd_pr__nfet_01v8 W=0.42 L=0.15
Xn_1239_p n_1239 n_1238 vdd vdd sky130_fd_pr__pfet_01v8 W=0.7 L=0.15
Xn_1240_p1 n_1240 n_1239 n_1240_x vdd sky130_fd_pr__pfet_01v8 W=1.4 L=0.15
Xn_1240_p2 n_1240_x n_4 vdd vdd sky130_fd_pr__pfet_01v8 W=1.4 L=0.15
Xn_1240_n1 n_1240 n_1239 vss vss sky130_fd_pr__nfet_01v8 W=0.42 L=0.15
Xn_1240_n2 n_1240 n_4 vss vss sky130_fd_pr__nfet_01v8 W=0.42 L=0.15
Xn_1241_n n_1241 n_1240 vss vss sky130_fd_pr__nfet_01v8 W=0.42 L=0.15
Xn_1241_p n_1241 n_1240 vdd vdd sky130_fd_pr__pfet_01v8 W=0.7 L=0.15
Xn_1243_p1 n_1243 n_1237 n_1243_x vdd sky130_fd_pr__pfet_01v8 W=1.4 L=0.15
Xn_1243_p2 n_1243_x n_1242 vdd vdd sky130_fd_pr__pfet_01v8 W=1.4 L=0.15
Xn_1243_n1 n_1243 n_1237 vss vss sky130_fd_pr__nfet_01v8 W=0.42 L=0.15
Xn_1243_n2 n_1243 n_1242 vss vss sky130_fd_pr__nfet_01v8 W=0.42 L=0.15
Xn_1242_p1 n_1242 n_1241 n_1242_x vdd sky130_fd_pr__pfet_01v8 W=1.4 L=0.15
Xn_1242_p2 n_1242_x n_1243 vdd vdd sky130_fd_pr__pfet_01v8 W=1.4 L=0.15
Xn_1242_n1 n_1242 n_1241 vss vss sky130_fd_pr__nfet_01v8 W=0.42 L=0.15
Xn_1242_n2 n_1242 n_1243 vss vss sky130_fd_pr__nfet_01v8 W=0.42 L=0.15
Xn_1244_n n_1244 x_neg15 vss vss sky130_fd_pr__nfet_01v8 W=0.42 L=0.15
Xn_1244_p n_1244 x_neg15 vdd vdd sky130_fd_pr__pfet_01v8 W=0.7 L=0.15
Xn_1245_p1 n_1245 n_1242 vdd vdd sky130_fd_pr__pfet_01v8 W=0.7 L=0.15
Xn_1245_p2 n_1245 n_1244 vdd vdd sky130_fd_pr__pfet_01v8 W=0.7 L=0.15
Xn_1245_n1 n_1245 n_1242 n_1245_x vss sky130_fd_pr__nfet_01v8 W=0.84 L=0.15
Xn_1245_n2 n_1245_x n_1244 vss vss sky130_fd_pr__nfet_01v8 W=0.84 L=0.15
Xxin_p_r15_n xin_p_r15 n_1245 vss vss sky130_fd_pr__nfet_01v8 W=0.42 L=0.15
Xxin_p_r15_p xin_p_r15 n_1245 vdd vdd sky130_fd_pr__pfet_01v8 W=0.7 L=0.15
Xn_1246_p1 n_1246 n_1242 vdd vdd sky130_fd_pr__pfet_01v8 W=0.7 L=0.15
Xn_1246_p2 n_1246 x_neg15 vdd vdd sky130_fd_pr__pfet_01v8 W=0.7 L=0.15
Xn_1246_n1 n_1246 n_1242 n_1246_x vss sky130_fd_pr__nfet_01v8 W=0.84 L=0.15
Xn_1246_n2 n_1246_x x_neg15 vss vss sky130_fd_pr__nfet_01v8 W=0.84 L=0.15
Xxin_n_r15_n xin_n_r15 n_1246 vss vss sky130_fd_pr__nfet_01v8 W=0.42 L=0.15
Xxin_n_r15_p xin_n_r15 n_1246 vdd vdd sky130_fd_pr__pfet_01v8 W=0.7 L=0.15
Xn_1247_p1 n_1247 n_1242 vdd vdd sky130_fd_pr__pfet_01v8 W=0.7 L=0.15
Xn_1247_p2 n_1247 lora_en vdd vdd sky130_fd_pr__pfet_01v8 W=0.7 L=0.15
Xn_1247_n1 n_1247 n_1242 n_1247_x vss sky130_fd_pr__nfet_01v8 W=0.84 L=0.15
Xn_1247_n2 n_1247_x lora_en vss vss sky130_fd_pr__nfet_01v8 W=0.84 L=0.15
Xxrd_en15_n xrd_en15 n_1247 vss vss sky130_fd_pr__nfet_01v8 W=0.42 L=0.15
Xxrd_en15_p xrd_en15 n_1247 vdd vdd sky130_fd_pr__pfet_01v8 W=0.7 L=0.15
Xn_1248_p1 n_1248 w vdd vdd sky130_fd_pr__pfet_01v8 W=0.7 L=0.15
Xn_1248_p2 n_1248 t_phi1 vdd vdd sky130_fd_pr__pfet_01v8 W=0.7 L=0.15
Xn_1248_n1 n_1248 w n_1248_x vss sky130_fd_pr__nfet_01v8 W=0.84 L=0.15
Xn_1248_n2 n_1248_x t_phi1 vss vss sky130_fd_pr__nfet_01v8 W=0.84 L=0.15
Xn_1249_n n_1249 n_1248 vss vss sky130_fd_pr__nfet_01v8 W=0.42 L=0.15
Xn_1249_p n_1249 n_1248 vdd vdd sky130_fd_pr__pfet_01v8 W=0.7 L=0.15
Xn_1250_n n_1250 w vss vss sky130_fd_pr__nfet_01v8 W=0.42 L=0.15
Xn_1250_p n_1250 w vdd vdd sky130_fd_pr__pfet_01v8 W=0.7 L=0.15
Xn_1251_p1 n_1251 n_1249 n_1251_x vdd sky130_fd_pr__pfet_01v8 W=1.4 L=0.15
Xn_1251_p2 n_1251_x w2 vdd vdd sky130_fd_pr__pfet_01v8 W=1.4 L=0.15
Xn_1251_n1 n_1251 n_1249 vss vss sky130_fd_pr__nfet_01v8 W=0.42 L=0.15
Xn_1251_n2 n_1251 w2 vss vss sky130_fd_pr__nfet_01v8 W=0.42 L=0.15
Xw2_p1 w2 n_1250 w2_x vdd sky130_fd_pr__pfet_01v8 W=1.4 L=0.15
Xw2_p2 w2_x n_1251 vdd vdd sky130_fd_pr__pfet_01v8 W=1.4 L=0.15
Xw2_n1 w2 n_1250 vss vss sky130_fd_pr__nfet_01v8 W=0.42 L=0.15
Xw2_n2 w2 n_1251 vss vss sky130_fd_pr__nfet_01v8 W=0.42 L=0.15
Xn_1252_n n_1252 w2 vss vss sky130_fd_pr__nfet_01v8 W=0.42 L=0.15
Xn_1252_p n_1252 w2 vdd vdd sky130_fd_pr__pfet_01v8 W=0.7 L=0.15
Xn_1253_p1 n_1253 n_1252 n_1253_x vdd sky130_fd_pr__pfet_01v8 W=1.4 L=0.15
Xn_1253_p2 n_1253_x t_phi1 vdd vdd sky130_fd_pr__pfet_01v8 W=1.4 L=0.15
Xn_1253_n1 n_1253 n_1252 vss vss sky130_fd_pr__nfet_01v8 W=0.42 L=0.15
Xn_1253_n2 n_1253 t_phi1 vss vss sky130_fd_pr__nfet_01v8 W=0.42 L=0.15
Xn_1254_n n_1254 n_1253 vss vss sky130_fd_pr__nfet_01v8 W=0.42 L=0.15
Xn_1254_p n_1254 n_1253 vdd vdd sky130_fd_pr__pfet_01v8 W=0.7 L=0.15
Xn_1255_n n_1255 n_1254 vss vss sky130_fd_pr__nfet_01v8 W=1.26 L=0.15
Xn_1255_p n_1255 n_1254 vdd vdd sky130_fd_pr__pfet_01v8 W=2.1 L=0.15
Xtphi1_n tphi1 n_1255 vss vss sky130_fd_pr__nfet_01v8 W=5.04 L=0.15
Xtphi1_p tphi1 n_1255 vdd vdd sky130_fd_pr__pfet_01v8 W=8.4 L=0.15
Xn_1256_p1 n_1256 n_1252 n_1256_x vdd sky130_fd_pr__pfet_01v8 W=1.4 L=0.15
Xn_1256_p2 n_1256_x t_phi1e vdd vdd sky130_fd_pr__pfet_01v8 W=1.4 L=0.15
Xn_1256_n1 n_1256 n_1252 vss vss sky130_fd_pr__nfet_01v8 W=0.42 L=0.15
Xn_1256_n2 n_1256 t_phi1e vss vss sky130_fd_pr__nfet_01v8 W=0.42 L=0.15
Xn_1257_n n_1257 n_1256 vss vss sky130_fd_pr__nfet_01v8 W=0.42 L=0.15
Xn_1257_p n_1257 n_1256 vdd vdd sky130_fd_pr__pfet_01v8 W=0.7 L=0.15
Xn_1258_n n_1258 n_1257 vss vss sky130_fd_pr__nfet_01v8 W=1.26 L=0.15
Xn_1258_p n_1258 n_1257 vdd vdd sky130_fd_pr__pfet_01v8 W=2.1 L=0.15
Xtphi1e_n tphi1e n_1258 vss vss sky130_fd_pr__nfet_01v8 W=3.36 L=0.15
Xtphi1e_p tphi1e n_1258 vdd vdd sky130_fd_pr__pfet_01v8 W=5.6 L=0.15
Xn_1259_p1 n_1259 w2 vdd vdd sky130_fd_pr__pfet_01v8 W=0.7 L=0.15
Xn_1259_p2 n_1259 t_phi2 vdd vdd sky130_fd_pr__pfet_01v8 W=0.7 L=0.15
Xn_1259_n1 n_1259 w2 n_1259_x vss sky130_fd_pr__nfet_01v8 W=0.84 L=0.15
Xn_1259_n2 n_1259_x t_phi2 vss vss sky130_fd_pr__nfet_01v8 W=0.84 L=0.15
Xn_1260_n n_1260 n_1259 vss vss sky130_fd_pr__nfet_01v8 W=0.42 L=0.15
Xn_1260_p n_1260 n_1259 vdd vdd sky130_fd_pr__pfet_01v8 W=0.7 L=0.15
Xn_1261_n n_1261 n_1260 vss vss sky130_fd_pr__nfet_01v8 W=0.42 L=0.15
Xn_1261_p n_1261 n_1260 vdd vdd sky130_fd_pr__pfet_01v8 W=0.7 L=0.15
Xtphi2_n tphi2 n_1261 vss vss sky130_fd_pr__nfet_01v8 W=0.42 L=0.15
Xtphi2_p tphi2 n_1261 vdd vdd sky130_fd_pr__pfet_01v8 W=0.7 L=0.15
.ends tile_seq

.subckt async_ctrl go adc_done xbar_rst adc_go latch_out done vdd vss
Xrst_dly go_buf rst_dly_raw vdd vss rst_delay
Xsettle_dly rst_delayed stl_dly_raw vdd vss settle_delay
Xinv_go1_n go_b go vss vss sky130_fd_pr__nfet_01v8 W=0.42 L=0.15
Xinv_go1_p go_b go vdd vdd sky130_fd_pr__pfet_01v8 W=0.7 L=0.15
Xinv_go2_n go_buf go_b vss vss sky130_fd_pr__nfet_01v8 W=0.42 L=0.15
Xinv_go2_p go_buf go_b vdd vdd sky130_fd_pr__pfet_01v8 W=0.7 L=0.15
Xinv_rd1_n rst_dly_b rst_dly_raw vss vss sky130_fd_pr__nfet_01v8 W=0.42 L=0.15
Xinv_rd1_p rst_dly_b rst_dly_raw vdd vdd sky130_fd_pr__pfet_01v8 W=0.7 L=0.15
Xinv_rd2_n rst_delayed rst_dly_b vss vss sky130_fd_pr__nfet_01v8 W=0.42 L=0.15
Xinv_rd2_p rst_delayed rst_dly_b vdd vdd sky130_fd_pr__pfet_01v8 W=0.7 L=0.15
Xnand_rst_p1 rst_nand go_buf vdd vdd sky130_fd_pr__pfet_01v8 W=0.7 L=0.15
Xnand_rst_p2 rst_nand rst_dly_b vdd vdd sky130_fd_pr__pfet_01v8 W=0.7 L=0.15
Xnand_rst_n1 rst_nand go_buf nand_rst_mid vss sky130_fd_pr__nfet_01v8 W=0.84 L=0.15
Xnand_rst_n2 nand_rst_mid rst_dly_b vss vss sky130_fd_pr__nfet_01v8 W=0.84 L=0.15
Xinv_rst_n xbar_rst rst_nand vss vss sky130_fd_pr__nfet_01v8 W=0.42 L=0.15
Xinv_rst_p xbar_rst rst_nand vdd vdd sky130_fd_pr__pfet_01v8 W=0.7 L=0.15
Xinv_sd1_n stl_dly_b stl_dly_raw vss vss sky130_fd_pr__nfet_01v8 W=0.42 L=0.15
Xinv_sd1_p stl_dly_b stl_dly_raw vdd vdd sky130_fd_pr__pfet_01v8 W=0.7 L=0.15
Xinv_sd2_n settle_delayed stl_dly_b vss vss sky130_fd_pr__nfet_01v8 W=0.42 L=0.15
Xinv_sd2_p settle_delayed stl_dly_b vdd vdd sky130_fd_pr__pfet_01v8 W=0.7 L=0.15
Xinv_ag1_n adc_go_b settle_delayed vss vss sky130_fd_pr__nfet_01v8 W=0.42 L=0.15
Xinv_ag1_p adc_go_b settle_delayed vdd vdd sky130_fd_pr__pfet_01v8 W=0.7 L=0.15
Xinv_ag2_n adc_go adc_go_b vss vss sky130_fd_pr__nfet_01v8 W=0.42 L=0.15
Xinv_ag2_p adc_go adc_go_b vdd vdd sky130_fd_pr__pfet_01v8 W=0.7 L=0.15
Xinv_ld1_n latch_b adc_done vss vss sky130_fd_pr__nfet_01v8 W=0.42 L=0.15
Xinv_ld1_p latch_b adc_done vdd vdd sky130_fd_pr__pfet_01v8 W=0.7 L=0.15
Xinv_ld2_n latch_out latch_b vss vss sky130_fd_pr__nfet_01v8 W=0.42 L=0.15
Xinv_ld2_p latch_out latch_b vdd vdd sky130_fd_pr__pfet_01v8 W=0.7 L=0.15
Xinv_dn1_n done_b latch_out vss vss sky130_fd_pr__nfet_01v8 W=0.42 L=0.15
Xinv_dn1_p done_b latch_out vdd vdd sky130_fd_pr__pfet_01v8 W=0.7 L=0.15
Xinv_dn2_n done done_b vss vss sky130_fd_pr__nfet_01v8 W=0.42 L=0.15
Xinv_dn2_p done done_b vdd vdd sky130_fd_pr__pfet_01v8 W=0.7 L=0.15
.ends async_ctrl
