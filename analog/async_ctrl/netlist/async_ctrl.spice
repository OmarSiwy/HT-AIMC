.subckt rst_delay in out vdd vss
X0_n d0 in vss vss sky130_fd_pr__nfet_01v8 W=0.42 L=0.15
X0_p d0 in vdd vdd sky130_fd_pr__pfet_01v8 W=0.7 L=0.15
Xload0 d0 vss sky130_fd_pr__cap_mim_m3_1 W=10.32 L=10.32
X1_n d1 d0 vss vss sky130_fd_pr__nfet_01v8 W=0.42 L=0.15
X1_p d1 d0 vdd vdd sky130_fd_pr__pfet_01v8 W=0.7 L=0.15
Xload1 d1 vss sky130_fd_pr__cap_mim_m3_1 W=10.32 L=10.32
X2_n d2 d1 vss vss sky130_fd_pr__nfet_01v8 W=0.42 L=0.15
X2_p d2 d1 vdd vdd sky130_fd_pr__pfet_01v8 W=0.7 L=0.15
Xload2 d2 vss sky130_fd_pr__cap_mim_m3_1 W=10.32 L=10.32
X3_n d3 d2 vss vss sky130_fd_pr__nfet_01v8 W=0.42 L=0.15
X3_p d3 d2 vdd vdd sky130_fd_pr__pfet_01v8 W=0.7 L=0.15
Xload3 d3 vss sky130_fd_pr__cap_mim_m3_1 W=10.32 L=10.32
X4_n d4 d3 vss vss sky130_fd_pr__nfet_01v8 W=0.42 L=0.15
X4_p d4 d3 vdd vdd sky130_fd_pr__pfet_01v8 W=0.7 L=0.15
Xload4 d4 vss sky130_fd_pr__cap_mim_m3_1 W=10.32 L=10.32
X5_n d5 d4 vss vss sky130_fd_pr__nfet_01v8 W=0.42 L=0.15
X5_p d5 d4 vdd vdd sky130_fd_pr__pfet_01v8 W=0.7 L=0.15
Xload5 d5 vss sky130_fd_pr__cap_mim_m3_1 W=10.32 L=10.32
X6_n d6 d5 vss vss sky130_fd_pr__nfet_01v8 W=0.42 L=0.15
X6_p d6 d5 vdd vdd sky130_fd_pr__pfet_01v8 W=0.7 L=0.15
Xload6 d6 vss sky130_fd_pr__cap_mim_m3_1 W=10.32 L=10.32
X7_n d7 d6 vss vss sky130_fd_pr__nfet_01v8 W=0.42 L=0.15
X7_p d7 d6 vdd vdd sky130_fd_pr__pfet_01v8 W=0.7 L=0.15
Xload7 d7 vss sky130_fd_pr__cap_mim_m3_1 W=10.32 L=10.32
X8_n d8 d7 vss vss sky130_fd_pr__nfet_01v8 W=0.42 L=0.15
X8_p d8 d7 vdd vdd sky130_fd_pr__pfet_01v8 W=0.7 L=0.15
Xload8 d8 vss sky130_fd_pr__cap_mim_m3_1 W=10.32 L=10.32
X9_n out d8 vss vss sky130_fd_pr__nfet_01v8 W=0.42 L=0.15
X9_p out d8 vdd vdd sky130_fd_pr__pfet_01v8 W=0.7 L=0.15
Xload9 out vss sky130_fd_pr__cap_mim_m3_1 W=10.32 L=10.32
.ends rst_delay

.subckt settle_delay in out vdd vss
X0_n d0 in vss vss sky130_fd_pr__nfet_01v8 W=0.42 L=0.15
X0_p d0 in vdd vdd sky130_fd_pr__pfet_01v8 W=0.7 L=0.15
Xload0 d0 vss sky130_fd_pr__cap_mim_m3_1 W=10.32 L=10.32
X1_n d1 d0 vss vss sky130_fd_pr__nfet_01v8 W=0.42 L=0.15
X1_p d1 d0 vdd vdd sky130_fd_pr__pfet_01v8 W=0.7 L=0.15
Xload1 d1 vss sky130_fd_pr__cap_mim_m3_1 W=10.32 L=10.32
X2_n d2 d1 vss vss sky130_fd_pr__nfet_01v8 W=0.42 L=0.15
X2_p d2 d1 vdd vdd sky130_fd_pr__pfet_01v8 W=0.7 L=0.15
Xload2 d2 vss sky130_fd_pr__cap_mim_m3_1 W=10.32 L=10.32
X3_n d3 d2 vss vss sky130_fd_pr__nfet_01v8 W=0.42 L=0.15
X3_p d3 d2 vdd vdd sky130_fd_pr__pfet_01v8 W=0.7 L=0.15
Xload3 d3 vss sky130_fd_pr__cap_mim_m3_1 W=10.32 L=10.32
X4_n d4 d3 vss vss sky130_fd_pr__nfet_01v8 W=0.42 L=0.15
X4_p d4 d3 vdd vdd sky130_fd_pr__pfet_01v8 W=0.7 L=0.15
Xload4 d4 vss sky130_fd_pr__cap_mim_m3_1 W=10.32 L=10.32
X5_n d5 d4 vss vss sky130_fd_pr__nfet_01v8 W=0.42 L=0.15
X5_p d5 d4 vdd vdd sky130_fd_pr__pfet_01v8 W=0.7 L=0.15
Xload5 d5 vss sky130_fd_pr__cap_mim_m3_1 W=10.32 L=10.32
X6_n d6 d5 vss vss sky130_fd_pr__nfet_01v8 W=0.42 L=0.15
X6_p d6 d5 vdd vdd sky130_fd_pr__pfet_01v8 W=0.7 L=0.15
Xload6 d6 vss sky130_fd_pr__cap_mim_m3_1 W=10.32 L=10.32
X7_n d7 d6 vss vss sky130_fd_pr__nfet_01v8 W=0.42 L=0.15
X7_p d7 d6 vdd vdd sky130_fd_pr__pfet_01v8 W=0.7 L=0.15
Xload7 d7 vss sky130_fd_pr__cap_mim_m3_1 W=10.32 L=10.32
X8_n d8 d7 vss vss sky130_fd_pr__nfet_01v8 W=0.42 L=0.15
X8_p d8 d7 vdd vdd sky130_fd_pr__pfet_01v8 W=0.7 L=0.15
Xload8 d8 vss sky130_fd_pr__cap_mim_m3_1 W=10.32 L=10.32
X9_n d9 d8 vss vss sky130_fd_pr__nfet_01v8 W=0.42 L=0.15
X9_p d9 d8 vdd vdd sky130_fd_pr__pfet_01v8 W=0.7 L=0.15
Xload9 d9 vss sky130_fd_pr__cap_mim_m3_1 W=10.32 L=10.32
X10_n d10 d9 vss vss sky130_fd_pr__nfet_01v8 W=0.42 L=0.15
X10_p d10 d9 vdd vdd sky130_fd_pr__pfet_01v8 W=0.7 L=0.15
Xload10 d10 vss sky130_fd_pr__cap_mim_m3_1 W=10.32 L=10.32
X11_n d11 d10 vss vss sky130_fd_pr__nfet_01v8 W=0.42 L=0.15
X11_p d11 d10 vdd vdd sky130_fd_pr__pfet_01v8 W=0.7 L=0.15
Xload11 d11 vss sky130_fd_pr__cap_mim_m3_1 W=10.32 L=10.32
X12_n d12 d11 vss vss sky130_fd_pr__nfet_01v8 W=0.42 L=0.15
X12_p d12 d11 vdd vdd sky130_fd_pr__pfet_01v8 W=0.7 L=0.15
Xload12 d12 vss sky130_fd_pr__cap_mim_m3_1 W=10.32 L=10.32
X13_n d13 d12 vss vss sky130_fd_pr__nfet_01v8 W=0.42 L=0.15
X13_p d13 d12 vdd vdd sky130_fd_pr__pfet_01v8 W=0.7 L=0.15
Xload13 d13 vss sky130_fd_pr__cap_mim_m3_1 W=10.32 L=10.32
X14_n d14 d13 vss vss sky130_fd_pr__nfet_01v8 W=0.42 L=0.15
X14_p d14 d13 vdd vdd sky130_fd_pr__pfet_01v8 W=0.7 L=0.15
Xload14 d14 vss sky130_fd_pr__cap_mim_m3_1 W=10.32 L=10.32
X15_n d15 d14 vss vss sky130_fd_pr__nfet_01v8 W=0.42 L=0.15
X15_p d15 d14 vdd vdd sky130_fd_pr__pfet_01v8 W=0.7 L=0.15
Xload15 d15 vss sky130_fd_pr__cap_mim_m3_1 W=10.32 L=10.32
X16_n d16 d15 vss vss sky130_fd_pr__nfet_01v8 W=0.42 L=0.15
X16_p d16 d15 vdd vdd sky130_fd_pr__pfet_01v8 W=0.7 L=0.15
Xload16 d16 vss sky130_fd_pr__cap_mim_m3_1 W=10.32 L=10.32
X17_n d17 d16 vss vss sky130_fd_pr__nfet_01v8 W=0.42 L=0.15
X17_p d17 d16 vdd vdd sky130_fd_pr__pfet_01v8 W=0.7 L=0.15
Xload17 d17 vss sky130_fd_pr__cap_mim_m3_1 W=10.32 L=10.32
X18_n d18 d17 vss vss sky130_fd_pr__nfet_01v8 W=0.42 L=0.15
X18_p d18 d17 vdd vdd sky130_fd_pr__pfet_01v8 W=0.7 L=0.15
Xload18 d18 vss sky130_fd_pr__cap_mim_m3_1 W=10.32 L=10.32
X19_n out d18 vss vss sky130_fd_pr__nfet_01v8 W=0.42 L=0.15
X19_p out d18 vdd vdd sky130_fd_pr__pfet_01v8 W=0.7 L=0.15
Xload19 out vss sky130_fd_pr__cap_mim_m3_1 W=10.32 L=10.32
.ends settle_delay

.subckt tq_chain in tap1 tap2 tap3 tap4 vdd vss
Xtq_tap1_m_n tap1_m in vss vss sky130_fd_pr__nfet_01v8 W=0.84 L=0.15
Xtq_tap1_m_p tap1_m in vdd vdd sky130_fd_pr__pfet_01v8 W=1.4 L=0.15
Xload_tap1_m tap1_m vss sky130_fd_pr__cap_mim_m3_1 W=21.87 L=21.87
Xtq_tap1_n tap1 tap1_m vss vss sky130_fd_pr__nfet_01v8 W=0.84 L=0.15
Xtq_tap1_p tap1 tap1_m vdd vdd sky130_fd_pr__pfet_01v8 W=1.4 L=0.15
Xload_tap1 tap1 vss sky130_fd_pr__cap_mim_m3_1 W=21.87 L=21.87
Xtq_tap2_m_n tap2_m tap1 vss vss sky130_fd_pr__nfet_01v8 W=0.84 L=0.15
Xtq_tap2_m_p tap2_m tap1 vdd vdd sky130_fd_pr__pfet_01v8 W=1.4 L=0.15
Xload_tap2_m tap2_m vss sky130_fd_pr__cap_mim_m3_1 W=21.87 L=21.87
Xtq_tap2_n tap2 tap2_m vss vss sky130_fd_pr__nfet_01v8 W=0.84 L=0.15
Xtq_tap2_p tap2 tap2_m vdd vdd sky130_fd_pr__pfet_01v8 W=1.4 L=0.15
Xload_tap2 tap2 vss sky130_fd_pr__cap_mim_m3_1 W=21.87 L=21.87
Xtq_tap3_m_n tap3_m tap2 vss vss sky130_fd_pr__nfet_01v8 W=0.84 L=0.15
Xtq_tap3_m_p tap3_m tap2 vdd vdd sky130_fd_pr__pfet_01v8 W=1.4 L=0.15
Xload_tap3_m tap3_m vss sky130_fd_pr__cap_mim_m3_1 W=21.87 L=21.87
Xtq_tap3_n tap3 tap3_m vss vss sky130_fd_pr__nfet_01v8 W=0.84 L=0.15
Xtq_tap3_p tap3 tap3_m vdd vdd sky130_fd_pr__pfet_01v8 W=1.4 L=0.15
Xload_tap3 tap3 vss sky130_fd_pr__cap_mim_m3_1 W=21.87 L=21.87
Xtq_tap4_m_n tap4_m tap3 vss vss sky130_fd_pr__nfet_01v8 W=0.84 L=0.15
Xtq_tap4_m_p tap4_m tap3 vdd vdd sky130_fd_pr__pfet_01v8 W=1.4 L=0.15
Xload_tap4_m tap4_m vss sky130_fd_pr__cap_mim_m3_1 W=21.87 L=21.87
Xtq_tap4_n tap4 tap4_m vss vss sky130_fd_pr__nfet_01v8 W=0.84 L=0.15
Xtq_tap4_p tap4 tap4_m vdd vdd sky130_fd_pr__pfet_01v8 W=1.4 L=0.15
Xload_tap4 tap4 vss sky130_fd_pr__cap_mim_m3_1 W=21.87 L=21.87
.ends tq_chain

.subckt muller_c a b out vdd vss
Xp1 out a n1p vdd sky130_fd_pr__pfet_01v8 W=1.4 L=0.15
Xp2 n1p b vdd vdd sky130_fd_pr__pfet_01v8 W=1.4 L=0.15
Xp3 out out_b vdd vdd sky130_fd_pr__pfet_01v8 W=0.42 L=0.6
Xn1 out a n1n vss sky130_fd_pr__nfet_01v8 W=0.84 L=0.15
Xn2 n1n b vss vss sky130_fd_pr__nfet_01v8 W=0.84 L=0.15
Xn3 out out_b vss vss sky130_fd_pr__nfet_01v8 W=0.42 L=0.6
Xfb_n out_b out vss vss sky130_fd_pr__nfet_01v8 W=0.42 L=0.15
Xfb_p out_b out vdd vdd sky130_fd_pr__pfet_01v8 W=0.7 L=0.15
.ends muller_c

.subckt dly_pace in out vdd vss
Xu0_p1 u0 in vdd vdd sky130_fd_pr__pfet_01v8 W=1.11 L=1.2
Xu0_p2 u0 in vdd vdd sky130_fd_pr__pfet_01v8 W=1.11 L=1.2
Xu0_n1 u0 in u0_m vss sky130_fd_pr__nfet_01v8 W=0.84 L=1.2
Xu0_n2 u0_m in vss vss sky130_fd_pr__nfet_01v8 W=0.84 L=1.2
Xd0_n d0 u0 vss vss sky130_fd_pr__nfet_01v8 W=0.42 L=1.2
Xd0_p d0 u0 vdd vdd sky130_fd_pr__pfet_01v8 W=1.11 L=1.2
Xcu0 u0 vss sky130_fd_pr__cap_mim_m3_1 W=7.65 L=7.65
Xcd0 d0 vss sky130_fd_pr__cap_mim_m3_1 W=7.65 L=7.65
Xu1_p1 u1 in vdd vdd sky130_fd_pr__pfet_01v8 W=1.11 L=1.2
Xu1_p2 u1 d0 vdd vdd sky130_fd_pr__pfet_01v8 W=1.11 L=1.2
Xu1_n1 u1 in u1_m vss sky130_fd_pr__nfet_01v8 W=0.84 L=1.2
Xu1_n2 u1_m d0 vss vss sky130_fd_pr__nfet_01v8 W=0.84 L=1.2
Xd1_n d1 u1 vss vss sky130_fd_pr__nfet_01v8 W=0.42 L=1.2
Xd1_p d1 u1 vdd vdd sky130_fd_pr__pfet_01v8 W=1.11 L=1.2
Xcu1 u1 vss sky130_fd_pr__cap_mim_m3_1 W=7.65 L=7.65
Xcd1 d1 vss sky130_fd_pr__cap_mim_m3_1 W=7.65 L=7.65
Xu2_p1 u2 in vdd vdd sky130_fd_pr__pfet_01v8 W=1.11 L=1.2
Xu2_p2 u2 d1 vdd vdd sky130_fd_pr__pfet_01v8 W=1.11 L=1.2
Xu2_n1 u2 in u2_m vss sky130_fd_pr__nfet_01v8 W=0.84 L=1.2
Xu2_n2 u2_m d1 vss vss sky130_fd_pr__nfet_01v8 W=0.84 L=1.2
Xd2_n d2 u2 vss vss sky130_fd_pr__nfet_01v8 W=0.42 L=1.2
Xd2_p d2 u2 vdd vdd sky130_fd_pr__pfet_01v8 W=1.11 L=1.2
Xcu2 u2 vss sky130_fd_pr__cap_mim_m3_1 W=7.65 L=7.65
Xcd2 d2 vss sky130_fd_pr__cap_mim_m3_1 W=7.65 L=7.65
Xu3_p1 u3 in vdd vdd sky130_fd_pr__pfet_01v8 W=1.11 L=1.2
Xu3_p2 u3 d2 vdd vdd sky130_fd_pr__pfet_01v8 W=1.11 L=1.2
Xu3_n1 u3 in u3_m vss sky130_fd_pr__nfet_01v8 W=0.84 L=1.2
Xu3_n2 u3_m d2 vss vss sky130_fd_pr__nfet_01v8 W=0.84 L=1.2
Xout_n out u3 vss vss sky130_fd_pr__nfet_01v8 W=0.42 L=1.2
Xout_p out u3 vdd vdd sky130_fd_pr__pfet_01v8 W=1.11 L=1.2
Xcu3 u3 vss sky130_fd_pr__cap_mim_m3_1 W=7.65 L=7.65
Xcout out vss sky130_fd_pr__cap_mim_m3_1 W=7.65 L=7.65
.ends dly_pace

.subckt dly_bundle in out vdd vss
Xu0_p1 u0 in vdd vdd sky130_fd_pr__pfet_01v8 W=0.7 L=0.15
Xu0_p2 u0 in vdd vdd sky130_fd_pr__pfet_01v8 W=0.7 L=0.15
Xu0_n1 u0 in u0_m vss sky130_fd_pr__nfet_01v8 W=0.84 L=0.15
Xu0_n2 u0_m in vss vss sky130_fd_pr__nfet_01v8 W=0.84 L=0.15
Xd0_n d0 u0 vss vss sky130_fd_pr__nfet_01v8 W=0.42 L=0.15
Xd0_p d0 u0 vdd vdd sky130_fd_pr__pfet_01v8 W=0.7 L=0.15
Xcu0 u0 vss sky130_fd_pr__cap_mim_m3_1 W=3.95 L=3.95
Xcd0 d0 vss sky130_fd_pr__cap_mim_m3_1 W=3.95 L=3.95
Xu1_p1 u1 in vdd vdd sky130_fd_pr__pfet_01v8 W=0.7 L=0.15
Xu1_p2 u1 d0 vdd vdd sky130_fd_pr__pfet_01v8 W=0.7 L=0.15
Xu1_n1 u1 in u1_m vss sky130_fd_pr__nfet_01v8 W=0.84 L=0.15
Xu1_n2 u1_m d0 vss vss sky130_fd_pr__nfet_01v8 W=0.84 L=0.15
Xd1_n d1 u1 vss vss sky130_fd_pr__nfet_01v8 W=0.42 L=0.15
Xd1_p d1 u1 vdd vdd sky130_fd_pr__pfet_01v8 W=0.7 L=0.15
Xcu1 u1 vss sky130_fd_pr__cap_mim_m3_1 W=3.95 L=3.95
Xcd1 d1 vss sky130_fd_pr__cap_mim_m3_1 W=3.95 L=3.95
Xu2_p1 u2 in vdd vdd sky130_fd_pr__pfet_01v8 W=0.7 L=0.15
Xu2_p2 u2 d1 vdd vdd sky130_fd_pr__pfet_01v8 W=0.7 L=0.15
Xu2_n1 u2 in u2_m vss sky130_fd_pr__nfet_01v8 W=0.84 L=0.15
Xu2_n2 u2_m d1 vss vss sky130_fd_pr__nfet_01v8 W=0.84 L=0.15
Xd2_n d2 u2 vss vss sky130_fd_pr__nfet_01v8 W=0.42 L=0.15
Xd2_p d2 u2 vdd vdd sky130_fd_pr__pfet_01v8 W=0.7 L=0.15
Xcu2 u2 vss sky130_fd_pr__cap_mim_m3_1 W=3.95 L=3.95
Xcd2 d2 vss sky130_fd_pr__cap_mim_m3_1 W=3.95 L=3.95
Xu3_p1 u3 in vdd vdd sky130_fd_pr__pfet_01v8 W=0.7 L=0.15
Xu3_p2 u3 d2 vdd vdd sky130_fd_pr__pfet_01v8 W=0.7 L=0.15
Xu3_n1 u3 in u3_m vss sky130_fd_pr__nfet_01v8 W=0.84 L=0.15
Xu3_n2 u3_m d2 vss vss sky130_fd_pr__nfet_01v8 W=0.84 L=0.15
Xout_n out u3 vss vss sky130_fd_pr__nfet_01v8 W=0.42 L=0.15
Xout_p out u3 vdd vdd sky130_fd_pr__pfet_01v8 W=0.7 L=0.15
Xcu3 u3 vss sky130_fd_pr__cap_mim_m3_1 W=3.95 L=3.95
Xcout out vss sky130_fd_pr__cap_mim_m3_1 W=3.95 L=3.95
.ends dly_bundle

.subckt dly_acq in out vdd vss
Xu0_p1 u0 in vdd vdd sky130_fd_pr__pfet_01v8 W=0.85 L=0.3
Xu0_p2 u0 in vdd vdd sky130_fd_pr__pfet_01v8 W=0.85 L=0.3
Xu0_n1 u0 in u0_m vss sky130_fd_pr__nfet_01v8 W=0.84 L=0.3
Xu0_n2 u0_m in vss vss sky130_fd_pr__nfet_01v8 W=0.84 L=0.3
Xd0_n d0 u0 vss vss sky130_fd_pr__nfet_01v8 W=0.42 L=0.3
Xd0_p d0 u0 vdd vdd sky130_fd_pr__pfet_01v8 W=0.85 L=0.3
Xcu0 u0 vss sky130_fd_pr__cap_mim_m3_1 W=8.07 L=8.07
Xcd0 d0 vss sky130_fd_pr__cap_mim_m3_1 W=8.07 L=8.07
Xu1_p1 u1 in vdd vdd sky130_fd_pr__pfet_01v8 W=0.85 L=0.3
Xu1_p2 u1 d0 vdd vdd sky130_fd_pr__pfet_01v8 W=0.85 L=0.3
Xu1_n1 u1 in u1_m vss sky130_fd_pr__nfet_01v8 W=0.84 L=0.3
Xu1_n2 u1_m d0 vss vss sky130_fd_pr__nfet_01v8 W=0.84 L=0.3
Xd1_n d1 u1 vss vss sky130_fd_pr__nfet_01v8 W=0.42 L=0.3
Xd1_p d1 u1 vdd vdd sky130_fd_pr__pfet_01v8 W=0.85 L=0.3
Xcu1 u1 vss sky130_fd_pr__cap_mim_m3_1 W=8.07 L=8.07
Xcd1 d1 vss sky130_fd_pr__cap_mim_m3_1 W=8.07 L=8.07
Xu2_p1 u2 in vdd vdd sky130_fd_pr__pfet_01v8 W=0.85 L=0.3
Xu2_p2 u2 d1 vdd vdd sky130_fd_pr__pfet_01v8 W=0.85 L=0.3
Xu2_n1 u2 in u2_m vss sky130_fd_pr__nfet_01v8 W=0.84 L=0.3
Xu2_n2 u2_m d1 vss vss sky130_fd_pr__nfet_01v8 W=0.84 L=0.3
Xd2_n d2 u2 vss vss sky130_fd_pr__nfet_01v8 W=0.42 L=0.3
Xd2_p d2 u2 vdd vdd sky130_fd_pr__pfet_01v8 W=0.85 L=0.3
Xcu2 u2 vss sky130_fd_pr__cap_mim_m3_1 W=8.07 L=8.07
Xcd2 d2 vss sky130_fd_pr__cap_mim_m3_1 W=8.07 L=8.07
Xu3_p1 u3 in vdd vdd sky130_fd_pr__pfet_01v8 W=0.85 L=0.3
Xu3_p2 u3 d2 vdd vdd sky130_fd_pr__pfet_01v8 W=0.85 L=0.3
Xu3_n1 u3 in u3_m vss sky130_fd_pr__nfet_01v8 W=0.84 L=0.3
Xu3_n2 u3_m d2 vss vss sky130_fd_pr__nfet_01v8 W=0.84 L=0.3
Xout_n out u3 vss vss sky130_fd_pr__nfet_01v8 W=0.42 L=0.3
Xout_p out u3 vdd vdd sky130_fd_pr__pfet_01v8 W=0.85 L=0.3
Xcu3 u3 vss sky130_fd_pr__cap_mim_m3_1 W=8.07 L=8.07
Xcout out vss sky130_fd_pr__cap_mim_m3_1 W=8.07 L=8.07
.ends dly_acq

.subckt dly_acq1 in out vdd vss
Xu0_p1 u0 in vdd vdd sky130_fd_pr__pfet_01v8 W=1.18 L=2.4
Xu0_p2 u0 in vdd vdd sky130_fd_pr__pfet_01v8 W=1.18 L=2.4
Xu0_n1 u0 in u0_m vss sky130_fd_pr__nfet_01v8 W=0.84 L=2.4
Xu0_n2 u0_m in vss vss sky130_fd_pr__nfet_01v8 W=0.84 L=2.4
Xd0_n d0 u0 vss vss sky130_fd_pr__nfet_01v8 W=0.42 L=2.4
Xd0_p d0 u0 vdd vdd sky130_fd_pr__pfet_01v8 W=1.18 L=2.4
Xcu0 u0 vss sky130_fd_pr__cap_mim_m3_1 W=7.81 L=7.81
Xcd0 d0 vss sky130_fd_pr__cap_mim_m3_1 W=7.81 L=7.81
Xu1_p1 u1 in vdd vdd sky130_fd_pr__pfet_01v8 W=1.18 L=2.4
Xu1_p2 u1 d0 vdd vdd sky130_fd_pr__pfet_01v8 W=1.18 L=2.4
Xu1_n1 u1 in u1_m vss sky130_fd_pr__nfet_01v8 W=0.84 L=2.4
Xu1_n2 u1_m d0 vss vss sky130_fd_pr__nfet_01v8 W=0.84 L=2.4
Xd1_n d1 u1 vss vss sky130_fd_pr__nfet_01v8 W=0.42 L=2.4
Xd1_p d1 u1 vdd vdd sky130_fd_pr__pfet_01v8 W=1.18 L=2.4
Xcu1 u1 vss sky130_fd_pr__cap_mim_m3_1 W=7.81 L=7.81
Xcd1 d1 vss sky130_fd_pr__cap_mim_m3_1 W=7.81 L=7.81
Xu2_p1 u2 in vdd vdd sky130_fd_pr__pfet_01v8 W=1.18 L=2.4
Xu2_p2 u2 d1 vdd vdd sky130_fd_pr__pfet_01v8 W=1.18 L=2.4
Xu2_n1 u2 in u2_m vss sky130_fd_pr__nfet_01v8 W=0.84 L=2.4
Xu2_n2 u2_m d1 vss vss sky130_fd_pr__nfet_01v8 W=0.84 L=2.4
Xd2_n d2 u2 vss vss sky130_fd_pr__nfet_01v8 W=0.42 L=2.4
Xd2_p d2 u2 vdd vdd sky130_fd_pr__pfet_01v8 W=1.18 L=2.4
Xcu2 u2 vss sky130_fd_pr__cap_mim_m3_1 W=7.81 L=7.81
Xcd2 d2 vss sky130_fd_pr__cap_mim_m3_1 W=7.81 L=7.81
Xu3_p1 u3 in vdd vdd sky130_fd_pr__pfet_01v8 W=1.18 L=2.4
Xu3_p2 u3 d2 vdd vdd sky130_fd_pr__pfet_01v8 W=1.18 L=2.4
Xu3_n1 u3 in u3_m vss sky130_fd_pr__nfet_01v8 W=0.84 L=2.4
Xu3_n2 u3_m d2 vss vss sky130_fd_pr__nfet_01v8 W=0.84 L=2.4
Xout_n out u3 vss vss sky130_fd_pr__nfet_01v8 W=0.42 L=2.4
Xout_p out u3 vdd vdd sky130_fd_pr__pfet_01v8 W=1.18 L=2.4
Xcu3 u3 vss sky130_fd_pr__cap_mim_m3_1 W=7.81 L=7.81
Xcout out vss sky130_fd_pr__cap_mim_m3_1 W=7.81 L=7.81
.ends dly_acq1

.subckt dly_hold in out vdd vss
Xu0_p1 u0 in vdd vdd sky130_fd_pr__pfet_01v8 W=0.85 L=0.3
Xu0_p2 u0 in vdd vdd sky130_fd_pr__pfet_01v8 W=0.85 L=0.3
Xu0_n1 u0 in u0_m vss sky130_fd_pr__nfet_01v8 W=0.84 L=0.3
Xu0_n2 u0_m in vss vss sky130_fd_pr__nfet_01v8 W=0.84 L=0.3
Xd0_n d0 u0 vss vss sky130_fd_pr__nfet_01v8 W=0.42 L=0.3
Xd0_p d0 u0 vdd vdd sky130_fd_pr__pfet_01v8 W=0.85 L=0.3
Xcu0 u0 vss sky130_fd_pr__cap_mim_m3_1 W=8.36 L=8.36
Xcd0 d0 vss sky130_fd_pr__cap_mim_m3_1 W=8.36 L=8.36
Xu1_p1 u1 in vdd vdd sky130_fd_pr__pfet_01v8 W=0.85 L=0.3
Xu1_p2 u1 d0 vdd vdd sky130_fd_pr__pfet_01v8 W=0.85 L=0.3
Xu1_n1 u1 in u1_m vss sky130_fd_pr__nfet_01v8 W=0.84 L=0.3
Xu1_n2 u1_m d0 vss vss sky130_fd_pr__nfet_01v8 W=0.84 L=0.3
Xd1_n d1 u1 vss vss sky130_fd_pr__nfet_01v8 W=0.42 L=0.3
Xd1_p d1 u1 vdd vdd sky130_fd_pr__pfet_01v8 W=0.85 L=0.3
Xcu1 u1 vss sky130_fd_pr__cap_mim_m3_1 W=8.36 L=8.36
Xcd1 d1 vss sky130_fd_pr__cap_mim_m3_1 W=8.36 L=8.36
Xu2_p1 u2 in vdd vdd sky130_fd_pr__pfet_01v8 W=0.85 L=0.3
Xu2_p2 u2 d1 vdd vdd sky130_fd_pr__pfet_01v8 W=0.85 L=0.3
Xu2_n1 u2 in u2_m vss sky130_fd_pr__nfet_01v8 W=0.84 L=0.3
Xu2_n2 u2_m d1 vss vss sky130_fd_pr__nfet_01v8 W=0.84 L=0.3
Xd2_n d2 u2 vss vss sky130_fd_pr__nfet_01v8 W=0.42 L=0.3
Xd2_p d2 u2 vdd vdd sky130_fd_pr__pfet_01v8 W=0.85 L=0.3
Xcu2 u2 vss sky130_fd_pr__cap_mim_m3_1 W=8.36 L=8.36
Xcd2 d2 vss sky130_fd_pr__cap_mim_m3_1 W=8.36 L=8.36
Xu3_p1 u3 in vdd vdd sky130_fd_pr__pfet_01v8 W=0.85 L=0.3
Xu3_p2 u3 d2 vdd vdd sky130_fd_pr__pfet_01v8 W=0.85 L=0.3
Xu3_n1 u3 in u3_m vss sky130_fd_pr__nfet_01v8 W=0.84 L=0.3
Xu3_n2 u3_m d2 vss vss sky130_fd_pr__nfet_01v8 W=0.84 L=0.3
Xout_n out u3 vss vss sky130_fd_pr__nfet_01v8 W=0.42 L=0.3
Xout_p out u3 vdd vdd sky130_fd_pr__pfet_01v8 W=0.85 L=0.3
Xcu3 u3 vss sky130_fd_pr__cap_mim_m3_1 W=8.36 L=8.36
Xcout out vss sky130_fd_pr__cap_mim_m3_1 W=8.36 L=8.36
.ends dly_hold

.subckt dly_fhi in out vdd vss
Xu0_p1 u0 in vdd vdd sky130_fd_pr__pfet_01v8 W=0.7 L=0.15
Xu0_p2 u0 in vdd vdd sky130_fd_pr__pfet_01v8 W=0.7 L=0.15
Xu0_n1 u0 in u0_m vss sky130_fd_pr__nfet_01v8 W=0.84 L=0.15
Xu0_n2 u0_m in vss vss sky130_fd_pr__nfet_01v8 W=0.84 L=0.15
Xd0_n d0 u0 vss vss sky130_fd_pr__nfet_01v8 W=0.42 L=0.15
Xd0_p d0 u0 vdd vdd sky130_fd_pr__pfet_01v8 W=0.7 L=0.15
Xcu0 u0 vss sky130_fd_pr__cap_mim_m3_1 W=5.65 L=5.65
Xcd0 d0 vss sky130_fd_pr__cap_mim_m3_1 W=5.65 L=5.65
Xu1_p1 u1 in vdd vdd sky130_fd_pr__pfet_01v8 W=0.7 L=0.15
Xu1_p2 u1 d0 vdd vdd sky130_fd_pr__pfet_01v8 W=0.7 L=0.15
Xu1_n1 u1 in u1_m vss sky130_fd_pr__nfet_01v8 W=0.84 L=0.15
Xu1_n2 u1_m d0 vss vss sky130_fd_pr__nfet_01v8 W=0.84 L=0.15
Xd1_n d1 u1 vss vss sky130_fd_pr__nfet_01v8 W=0.42 L=0.15
Xd1_p d1 u1 vdd vdd sky130_fd_pr__pfet_01v8 W=0.7 L=0.15
Xcu1 u1 vss sky130_fd_pr__cap_mim_m3_1 W=5.65 L=5.65
Xcd1 d1 vss sky130_fd_pr__cap_mim_m3_1 W=5.65 L=5.65
Xu2_p1 u2 in vdd vdd sky130_fd_pr__pfet_01v8 W=0.7 L=0.15
Xu2_p2 u2 d1 vdd vdd sky130_fd_pr__pfet_01v8 W=0.7 L=0.15
Xu2_n1 u2 in u2_m vss sky130_fd_pr__nfet_01v8 W=0.84 L=0.15
Xu2_n2 u2_m d1 vss vss sky130_fd_pr__nfet_01v8 W=0.84 L=0.15
Xd2_n d2 u2 vss vss sky130_fd_pr__nfet_01v8 W=0.42 L=0.15
Xd2_p d2 u2 vdd vdd sky130_fd_pr__pfet_01v8 W=0.7 L=0.15
Xcu2 u2 vss sky130_fd_pr__cap_mim_m3_1 W=5.65 L=5.65
Xcd2 d2 vss sky130_fd_pr__cap_mim_m3_1 W=5.65 L=5.65
Xu3_p1 u3 in vdd vdd sky130_fd_pr__pfet_01v8 W=0.7 L=0.15
Xu3_p2 u3 d2 vdd vdd sky130_fd_pr__pfet_01v8 W=0.7 L=0.15
Xu3_n1 u3 in u3_m vss sky130_fd_pr__nfet_01v8 W=0.84 L=0.15
Xu3_n2 u3_m d2 vss vss sky130_fd_pr__nfet_01v8 W=0.84 L=0.15
Xout_n out u3 vss vss sky130_fd_pr__nfet_01v8 W=0.42 L=0.15
Xout_p out u3 vdd vdd sky130_fd_pr__pfet_01v8 W=0.7 L=0.15
Xcu3 u3 vss sky130_fd_pr__cap_mim_m3_1 W=5.65 L=5.65
Xcout out vss sky130_fd_pr__cap_mim_m3_1 W=5.65 L=5.65
.ends dly_fhi

.subckt chop_gen p phi1r phi1er phi2r ck vdd vss
Xn_1_n n_1 p vss vss sky130_fd_pr__nfet_01v8 W=0.42 L=0.15
Xn_1_p n_1 p vdd vdd sky130_fd_pr__pfet_01v8 W=0.7 L=0.15
Xn_2_n n_2 p vss vss sky130_fd_pr__nfet_01v8 W=0.42 L=0.15
Xn_2_p n_2 p vdd vdd sky130_fd_pr__pfet_01v8 W=0.7 L=0.15
Xcm1 n_2 vss sky130_fd_pr__cap_mim_m3_1 W=2.05 L=2.05
Xdl1_n dl1 n_2 vss vss sky130_fd_pr__nfet_01v8 W=0.42 L=0.15
Xdl1_p dl1 n_2 vdd vdd sky130_fd_pr__pfet_01v8 W=0.7 L=0.15
Xcd1 dl1 vss sky130_fd_pr__cap_mim_m3_1 W=2.05 L=2.05
Xn_3_n n_3 dl1 vss vss sky130_fd_pr__nfet_01v8 W=0.42 L=0.15
Xn_3_p n_3 dl1 vdd vdd sky130_fd_pr__pfet_01v8 W=0.7 L=0.15
Xn_4_n n_4 dl1 vss vss sky130_fd_pr__nfet_01v8 W=0.42 L=0.15
Xn_4_p n_4 dl1 vdd vdd sky130_fd_pr__pfet_01v8 W=0.7 L=0.15
Xcm2 n_4 vss sky130_fd_pr__cap_mim_m3_1 W=2.05 L=2.05
Xdl2_n dl2 n_4 vss vss sky130_fd_pr__nfet_01v8 W=0.42 L=0.15
Xdl2_p dl2 n_4 vdd vdd sky130_fd_pr__pfet_01v8 W=0.7 L=0.15
Xcd2 dl2 vss sky130_fd_pr__cap_mim_m3_1 W=2.05 L=2.05
Xn_5_n n_5 dl2 vss vss sky130_fd_pr__nfet_01v8 W=0.42 L=0.15
Xn_5_p n_5 dl2 vdd vdd sky130_fd_pr__pfet_01v8 W=0.7 L=0.15
Xn_6_n n_6 dl2 vss vss sky130_fd_pr__nfet_01v8 W=0.42 L=0.15
Xn_6_p n_6 dl2 vdd vdd sky130_fd_pr__pfet_01v8 W=0.7 L=0.15
Xcm3 n_6 vss sky130_fd_pr__cap_mim_m3_1 W=2.05 L=2.05
Xdl3_n dl3 n_6 vss vss sky130_fd_pr__nfet_01v8 W=0.42 L=0.15
Xdl3_p dl3 n_6 vdd vdd sky130_fd_pr__pfet_01v8 W=0.7 L=0.15
Xcd3 dl3 vss sky130_fd_pr__cap_mim_m3_1 W=2.05 L=2.05
Xn_7_n n_7 dl3 vss vss sky130_fd_pr__nfet_01v8 W=0.42 L=0.15
Xn_7_p n_7 dl3 vdd vdd sky130_fd_pr__pfet_01v8 W=0.7 L=0.15
Xn_8_n n_8 dl3 vss vss sky130_fd_pr__nfet_01v8 W=0.42 L=0.15
Xn_8_p n_8 dl3 vdd vdd sky130_fd_pr__pfet_01v8 W=0.7 L=0.15
Xcm4 n_8 vss sky130_fd_pr__cap_mim_m3_1 W=2.05 L=2.05
Xdl4_n dl4 n_8 vss vss sky130_fd_pr__nfet_01v8 W=0.42 L=0.15
Xdl4_p dl4 n_8 vdd vdd sky130_fd_pr__pfet_01v8 W=0.7 L=0.15
Xcd4 dl4 vss sky130_fd_pr__cap_mim_m3_1 W=2.05 L=2.05
Xn_9_n n_9 dl4 vss vss sky130_fd_pr__nfet_01v8 W=0.42 L=0.15
Xn_9_p n_9 dl4 vdd vdd sky130_fd_pr__pfet_01v8 W=0.7 L=0.15
Xn_10_n n_10 dl4 vss vss sky130_fd_pr__nfet_01v8 W=0.42 L=0.15
Xn_10_p n_10 dl4 vdd vdd sky130_fd_pr__pfet_01v8 W=0.7 L=0.15
Xcm5 n_10 vss sky130_fd_pr__cap_mim_m3_1 W=2.05 L=2.05
Xdl5_n dl5 n_10 vss vss sky130_fd_pr__nfet_01v8 W=0.42 L=0.15
Xdl5_p dl5 n_10 vdd vdd sky130_fd_pr__pfet_01v8 W=0.7 L=0.15
Xcd5 dl5 vss sky130_fd_pr__cap_mim_m3_1 W=2.05 L=2.05
Xn_11_n n_11 dl5 vss vss sky130_fd_pr__nfet_01v8 W=0.42 L=0.15
Xn_11_p n_11 dl5 vdd vdd sky130_fd_pr__pfet_01v8 W=0.7 L=0.15
Xn_12_n n_12 dl5 vss vss sky130_fd_pr__nfet_01v8 W=0.42 L=0.15
Xn_12_p n_12 dl5 vdd vdd sky130_fd_pr__pfet_01v8 W=0.7 L=0.15
Xcm6 n_12 vss sky130_fd_pr__cap_mim_m3_1 W=2.05 L=2.05
Xdl6_n dl6 n_12 vss vss sky130_fd_pr__nfet_01v8 W=0.42 L=0.15
Xdl6_p dl6 n_12 vdd vdd sky130_fd_pr__pfet_01v8 W=0.7 L=0.15
Xcd6 dl6 vss sky130_fd_pr__cap_mim_m3_1 W=2.05 L=2.05
Xn_13_n n_13 dl6 vss vss sky130_fd_pr__nfet_01v8 W=0.42 L=0.15
Xn_13_p n_13 dl6 vdd vdd sky130_fd_pr__pfet_01v8 W=0.7 L=0.15
Xn_14_n n_14 dl6 vss vss sky130_fd_pr__nfet_01v8 W=0.42 L=0.15
Xn_14_p n_14 dl6 vdd vdd sky130_fd_pr__pfet_01v8 W=0.7 L=0.15
Xcm7 n_14 vss sky130_fd_pr__cap_mim_m3_1 W=2.05 L=2.05
Xdl7_n dl7 n_14 vss vss sky130_fd_pr__nfet_01v8 W=0.42 L=0.15
Xdl7_p dl7 n_14 vdd vdd sky130_fd_pr__pfet_01v8 W=0.7 L=0.15
Xcd7 dl7 vss sky130_fd_pr__cap_mim_m3_1 W=2.05 L=2.05
Xn_15_n n_15 dl7 vss vss sky130_fd_pr__nfet_01v8 W=0.42 L=0.15
Xn_15_p n_15 dl7 vdd vdd sky130_fd_pr__pfet_01v8 W=0.7 L=0.15
Xn_16_n n_16 dl7 vss vss sky130_fd_pr__nfet_01v8 W=0.42 L=0.15
Xn_16_p n_16 dl7 vdd vdd sky130_fd_pr__pfet_01v8 W=0.7 L=0.15
Xcm8 n_16 vss sky130_fd_pr__cap_mim_m3_1 W=2.05 L=2.05
Xdl8_n dl8 n_16 vss vss sky130_fd_pr__nfet_01v8 W=0.42 L=0.15
Xdl8_p dl8 n_16 vdd vdd sky130_fd_pr__pfet_01v8 W=0.7 L=0.15
Xcd8 dl8 vss sky130_fd_pr__cap_mim_m3_1 W=2.05 L=2.05
Xn_17_n n_17 dl8 vss vss sky130_fd_pr__nfet_01v8 W=0.42 L=0.15
Xn_17_p n_17 dl8 vdd vdd sky130_fd_pr__pfet_01v8 W=0.7 L=0.15
Xn_18_n n_18 dl8 vss vss sky130_fd_pr__nfet_01v8 W=0.42 L=0.15
Xn_18_p n_18 dl8 vdd vdd sky130_fd_pr__pfet_01v8 W=0.7 L=0.15
Xcm9 n_18 vss sky130_fd_pr__cap_mim_m3_1 W=2.05 L=2.05
Xdl9_n dl9 n_18 vss vss sky130_fd_pr__nfet_01v8 W=0.42 L=0.15
Xdl9_p dl9 n_18 vdd vdd sky130_fd_pr__pfet_01v8 W=0.7 L=0.15
Xcd9 dl9 vss sky130_fd_pr__cap_mim_m3_1 W=2.05 L=2.05
Xn_19_n n_19 dl9 vss vss sky130_fd_pr__nfet_01v8 W=0.42 L=0.15
Xn_19_p n_19 dl9 vdd vdd sky130_fd_pr__pfet_01v8 W=0.7 L=0.15
Xn_20_n n_20 dl9 vss vss sky130_fd_pr__nfet_01v8 W=0.42 L=0.15
Xn_20_p n_20 dl9 vdd vdd sky130_fd_pr__pfet_01v8 W=0.7 L=0.15
Xcm10 n_20 vss sky130_fd_pr__cap_mim_m3_1 W=2.05 L=2.05
Xdl10_n dl10 n_20 vss vss sky130_fd_pr__nfet_01v8 W=0.42 L=0.15
Xdl10_p dl10 n_20 vdd vdd sky130_fd_pr__pfet_01v8 W=0.7 L=0.15
Xcd10 dl10 vss sky130_fd_pr__cap_mim_m3_1 W=2.05 L=2.05
Xn_21_n n_21 dl10 vss vss sky130_fd_pr__nfet_01v8 W=0.42 L=0.15
Xn_21_p n_21 dl10 vdd vdd sky130_fd_pr__pfet_01v8 W=0.7 L=0.15
Xn_22_n n_22 dl10 vss vss sky130_fd_pr__nfet_01v8 W=0.42 L=0.15
Xn_22_p n_22 dl10 vdd vdd sky130_fd_pr__pfet_01v8 W=0.7 L=0.15
Xcm11 n_22 vss sky130_fd_pr__cap_mim_m3_1 W=2.05 L=2.05
Xdl11_n dl11 n_22 vss vss sky130_fd_pr__nfet_01v8 W=0.42 L=0.15
Xdl11_p dl11 n_22 vdd vdd sky130_fd_pr__pfet_01v8 W=0.7 L=0.15
Xcd11 dl11 vss sky130_fd_pr__cap_mim_m3_1 W=2.05 L=2.05
Xn_23_n n_23 dl11 vss vss sky130_fd_pr__nfet_01v8 W=0.42 L=0.15
Xn_23_p n_23 dl11 vdd vdd sky130_fd_pr__pfet_01v8 W=0.7 L=0.15
Xn_24_n n_24 dl11 vss vss sky130_fd_pr__nfet_01v8 W=0.42 L=0.15
Xn_24_p n_24 dl11 vdd vdd sky130_fd_pr__pfet_01v8 W=0.7 L=0.15
Xcm12 n_24 vss sky130_fd_pr__cap_mim_m3_1 W=2.05 L=2.05
Xdl12_n dl12 n_24 vss vss sky130_fd_pr__nfet_01v8 W=0.42 L=0.15
Xdl12_p dl12 n_24 vdd vdd sky130_fd_pr__pfet_01v8 W=0.7 L=0.15
Xcd12 dl12 vss sky130_fd_pr__cap_mim_m3_1 W=2.05 L=2.05
Xn_25_n n_25 dl12 vss vss sky130_fd_pr__nfet_01v8 W=0.42 L=0.15
Xn_25_p n_25 dl12 vdd vdd sky130_fd_pr__pfet_01v8 W=0.7 L=0.15
Xn_26_n n_26 dl12 vss vss sky130_fd_pr__nfet_01v8 W=0.42 L=0.15
Xn_26_p n_26 dl12 vdd vdd sky130_fd_pr__pfet_01v8 W=0.7 L=0.15
Xcm13 n_26 vss sky130_fd_pr__cap_mim_m3_1 W=2.05 L=2.05
Xdl13_n dl13 n_26 vss vss sky130_fd_pr__nfet_01v8 W=0.42 L=0.15
Xdl13_p dl13 n_26 vdd vdd sky130_fd_pr__pfet_01v8 W=0.7 L=0.15
Xcd13 dl13 vss sky130_fd_pr__cap_mim_m3_1 W=2.05 L=2.05
Xn_27_n n_27 dl13 vss vss sky130_fd_pr__nfet_01v8 W=0.42 L=0.15
Xn_27_p n_27 dl13 vdd vdd sky130_fd_pr__pfet_01v8 W=0.7 L=0.15
Xn_28_n n_28 dl13 vss vss sky130_fd_pr__nfet_01v8 W=0.42 L=0.15
Xn_28_p n_28 dl13 vdd vdd sky130_fd_pr__pfet_01v8 W=0.7 L=0.15
Xcm14 n_28 vss sky130_fd_pr__cap_mim_m3_1 W=2.05 L=2.05
Xdl14_n dl14 n_28 vss vss sky130_fd_pr__nfet_01v8 W=0.42 L=0.15
Xdl14_p dl14 n_28 vdd vdd sky130_fd_pr__pfet_01v8 W=0.7 L=0.15
Xcd14 dl14 vss sky130_fd_pr__cap_mim_m3_1 W=2.05 L=2.05
Xn_29_n n_29 dl14 vss vss sky130_fd_pr__nfet_01v8 W=0.42 L=0.15
Xn_29_p n_29 dl14 vdd vdd sky130_fd_pr__pfet_01v8 W=0.7 L=0.15
Xn_30_n n_30 dl14 vss vss sky130_fd_pr__nfet_01v8 W=0.42 L=0.15
Xn_30_p n_30 dl14 vdd vdd sky130_fd_pr__pfet_01v8 W=0.7 L=0.15
Xcm15 n_30 vss sky130_fd_pr__cap_mim_m3_1 W=2.05 L=2.05
Xdl15_n dl15 n_30 vss vss sky130_fd_pr__nfet_01v8 W=0.42 L=0.15
Xdl15_p dl15 n_30 vdd vdd sky130_fd_pr__pfet_01v8 W=0.7 L=0.15
Xcd15 dl15 vss sky130_fd_pr__cap_mim_m3_1 W=2.05 L=2.05
Xn_31_n n_31 dl15 vss vss sky130_fd_pr__nfet_01v8 W=0.42 L=0.15
Xn_31_p n_31 dl15 vdd vdd sky130_fd_pr__pfet_01v8 W=0.7 L=0.15
Xn_32_p1 n_32 n_1 vdd vdd sky130_fd_pr__pfet_01v8 W=0.7 L=0.15
Xn_32_p2 n_32 n_9 vdd vdd sky130_fd_pr__pfet_01v8 W=0.7 L=0.15
Xn_32_n1 n_32 n_1 n_32_x vss sky130_fd_pr__nfet_01v8 W=0.84 L=0.15
Xn_32_n2 n_32_x n_9 vss vss sky130_fd_pr__nfet_01v8 W=0.84 L=0.15
Xn_33_p1 n_33 n_1 vdd vdd sky130_fd_pr__pfet_01v8 W=0.7 L=0.15
Xn_33_p2 n_33 n_32 vdd vdd sky130_fd_pr__pfet_01v8 W=0.7 L=0.15
Xn_33_n1 n_33 n_1 n_33_x vss sky130_fd_pr__nfet_01v8 W=0.84 L=0.15
Xn_33_n2 n_33_x n_32 vss vss sky130_fd_pr__nfet_01v8 W=0.84 L=0.15
Xn_34_p1 n_34 n_9 vdd vdd sky130_fd_pr__pfet_01v8 W=0.7 L=0.15
Xn_34_p2 n_34 n_32 vdd vdd sky130_fd_pr__pfet_01v8 W=0.7 L=0.15
Xn_34_n1 n_34 n_9 n_34_x vss sky130_fd_pr__nfet_01v8 W=0.84 L=0.15
Xn_34_n2 n_34_x n_32 vss vss sky130_fd_pr__nfet_01v8 W=0.84 L=0.15
Xn_35_p1 n_35 n_33 vdd vdd sky130_fd_pr__pfet_01v8 W=0.7 L=0.15
Xn_35_p2 n_35 n_34 vdd vdd sky130_fd_pr__pfet_01v8 W=0.7 L=0.15
Xn_35_n1 n_35 n_33 n_35_x vss sky130_fd_pr__nfet_01v8 W=0.84 L=0.15
Xn_35_n2 n_35_x n_34 vss vss sky130_fd_pr__nfet_01v8 W=0.84 L=0.15
Xn_36_p1 n_36 n_1 vdd vdd sky130_fd_pr__pfet_01v8 W=0.7 L=0.15
Xn_36_p2 n_36 n_25 vdd vdd sky130_fd_pr__pfet_01v8 W=0.7 L=0.15
Xn_36_n1 n_36 n_1 n_36_x vss sky130_fd_pr__nfet_01v8 W=0.84 L=0.15
Xn_36_n2 n_36_x n_25 vss vss sky130_fd_pr__nfet_01v8 W=0.84 L=0.15
Xn_37_p1 n_37 n_1 vdd vdd sky130_fd_pr__pfet_01v8 W=0.7 L=0.15
Xn_37_p2 n_37 n_36 vdd vdd sky130_fd_pr__pfet_01v8 W=0.7 L=0.15
Xn_37_n1 n_37 n_1 n_37_x vss sky130_fd_pr__nfet_01v8 W=0.84 L=0.15
Xn_37_n2 n_37_x n_36 vss vss sky130_fd_pr__nfet_01v8 W=0.84 L=0.15
Xn_38_p1 n_38 n_25 vdd vdd sky130_fd_pr__pfet_01v8 W=0.7 L=0.15
Xn_38_p2 n_38 n_36 vdd vdd sky130_fd_pr__pfet_01v8 W=0.7 L=0.15
Xn_38_n1 n_38 n_25 n_38_x vss sky130_fd_pr__nfet_01v8 W=0.84 L=0.15
Xn_38_n2 n_38_x n_36 vss vss sky130_fd_pr__nfet_01v8 W=0.84 L=0.15
Xn_39_p1 n_39 n_37 vdd vdd sky130_fd_pr__pfet_01v8 W=0.7 L=0.15
Xn_39_p2 n_39 n_38 vdd vdd sky130_fd_pr__pfet_01v8 W=0.7 L=0.15
Xn_39_n1 n_39 n_37 n_39_x vss sky130_fd_pr__nfet_01v8 W=0.84 L=0.15
Xn_39_n2 n_39_x n_38 vss vss sky130_fd_pr__nfet_01v8 W=0.84 L=0.15
Xn_40_p1 n_40 n_1 vdd vdd sky130_fd_pr__pfet_01v8 W=0.7 L=0.15
Xn_40_p2 n_40 n_27 vdd vdd sky130_fd_pr__pfet_01v8 W=0.7 L=0.15
Xn_40_n1 n_40 n_1 n_40_x vss sky130_fd_pr__nfet_01v8 W=0.84 L=0.15
Xn_40_n2 n_40_x n_27 vss vss sky130_fd_pr__nfet_01v8 W=0.84 L=0.15
Xn_41_p1 n_41 n_1 vdd vdd sky130_fd_pr__pfet_01v8 W=0.7 L=0.15
Xn_41_p2 n_41 n_40 vdd vdd sky130_fd_pr__pfet_01v8 W=0.7 L=0.15
Xn_41_n1 n_41 n_1 n_41_x vss sky130_fd_pr__nfet_01v8 W=0.84 L=0.15
Xn_41_n2 n_41_x n_40 vss vss sky130_fd_pr__nfet_01v8 W=0.84 L=0.15
Xn_42_p1 n_42 n_27 vdd vdd sky130_fd_pr__pfet_01v8 W=0.7 L=0.15
Xn_42_p2 n_42 n_40 vdd vdd sky130_fd_pr__pfet_01v8 W=0.7 L=0.15
Xn_42_n1 n_42 n_27 n_42_x vss sky130_fd_pr__nfet_01v8 W=0.84 L=0.15
Xn_42_n2 n_42_x n_40 vss vss sky130_fd_pr__nfet_01v8 W=0.84 L=0.15
Xn_43_p1 n_43 n_41 vdd vdd sky130_fd_pr__pfet_01v8 W=0.7 L=0.15
Xn_43_p2 n_43 n_42 vdd vdd sky130_fd_pr__pfet_01v8 W=0.7 L=0.15
Xn_43_n1 n_43 n_41 n_43_x vss sky130_fd_pr__nfet_01v8 W=0.84 L=0.15
Xn_43_n2 n_43_x n_42 vss vss sky130_fd_pr__nfet_01v8 W=0.84 L=0.15
Xn_44_p1 n_44 n_1 vdd vdd sky130_fd_pr__pfet_01v8 W=0.7 L=0.15
Xn_44_p2 n_44 n_31 vdd vdd sky130_fd_pr__pfet_01v8 W=0.7 L=0.15
Xn_44_n1 n_44 n_1 n_44_x vss sky130_fd_pr__nfet_01v8 W=0.84 L=0.15
Xn_44_n2 n_44_x n_31 vss vss sky130_fd_pr__nfet_01v8 W=0.84 L=0.15
Xn_45_p1 n_45 n_1 vdd vdd sky130_fd_pr__pfet_01v8 W=0.7 L=0.15
Xn_45_p2 n_45 n_44 vdd vdd sky130_fd_pr__pfet_01v8 W=0.7 L=0.15
Xn_45_n1 n_45 n_1 n_45_x vss sky130_fd_pr__nfet_01v8 W=0.84 L=0.15
Xn_45_n2 n_45_x n_44 vss vss sky130_fd_pr__nfet_01v8 W=0.84 L=0.15
Xn_46_p1 n_46 n_31 vdd vdd sky130_fd_pr__pfet_01v8 W=0.7 L=0.15
Xn_46_p2 n_46 n_44 vdd vdd sky130_fd_pr__pfet_01v8 W=0.7 L=0.15
Xn_46_n1 n_46 n_31 n_46_x vss sky130_fd_pr__nfet_01v8 W=0.84 L=0.15
Xn_46_n2 n_46_x n_44 vss vss sky130_fd_pr__nfet_01v8 W=0.84 L=0.15
Xn_47_p1 n_47 n_45 vdd vdd sky130_fd_pr__pfet_01v8 W=0.7 L=0.15
Xn_47_p2 n_47 n_46 vdd vdd sky130_fd_pr__pfet_01v8 W=0.7 L=0.15
Xn_47_n1 n_47 n_45 n_47_x vss sky130_fd_pr__nfet_01v8 W=0.84 L=0.15
Xn_47_n2 n_47_x n_46 vss vss sky130_fd_pr__nfet_01v8 W=0.84 L=0.15
Xn_48_n n_48 n_35 vss vss sky130_fd_pr__nfet_01v8 W=0.42 L=0.15
Xn_48_p n_48 n_35 vdd vdd sky130_fd_pr__pfet_01v8 W=0.7 L=0.15
Xn_49_p1 n_49 n_39 vdd vdd sky130_fd_pr__pfet_01v8 W=0.7 L=0.15
Xn_49_p2 n_49 n_48 vdd vdd sky130_fd_pr__pfet_01v8 W=0.7 L=0.15
Xn_49_n1 n_49 n_39 n_49_x vss sky130_fd_pr__nfet_01v8 W=0.84 L=0.15
Xn_49_n2 n_49_x n_48 vss vss sky130_fd_pr__nfet_01v8 W=0.84 L=0.15
Xphi1r_n phi1r n_49 vss vss sky130_fd_pr__nfet_01v8 W=0.42 L=0.15
Xphi1r_p phi1r n_49 vdd vdd sky130_fd_pr__pfet_01v8 W=0.7 L=0.15
Xn_50_p1 n_50 n_43 vdd vdd sky130_fd_pr__pfet_01v8 W=0.7 L=0.15
Xn_50_p2 n_50 n_48 vdd vdd sky130_fd_pr__pfet_01v8 W=0.7 L=0.15
Xn_50_n1 n_50 n_43 n_50_x vss sky130_fd_pr__nfet_01v8 W=0.84 L=0.15
Xn_50_n2 n_50_x n_48 vss vss sky130_fd_pr__nfet_01v8 W=0.84 L=0.15
Xphi1er_n phi1er n_50 vss vss sky130_fd_pr__nfet_01v8 W=0.42 L=0.15
Xphi1er_p phi1er n_50 vdd vdd sky130_fd_pr__pfet_01v8 W=0.7 L=0.15
Xphi2r_n phi2r n_47 vss vss sky130_fd_pr__nfet_01v8 W=0.42 L=0.15
Xphi2r_p phi2r n_47 vdd vdd sky130_fd_pr__pfet_01v8 W=0.7 L=0.15
Xck_n ck n_48 vss vss sky130_fd_pr__nfet_01v8 W=0.42 L=0.15
Xck_p ck n_48 vdd vdd sky130_fd_pr__pfet_01v8 W=0.7 L=0.15
.ends chop_gen

.subckt conv_seq rst_n sgo phi1 phi2 coarse_en cb_ack cmp_req ota_en pkt_d0 pkt_d1 pkt_d2 c1p c1n c2p c2n sdone col_sign cb_req cb_cross cmp_ack cmp_result busy run fire sign sgd clk_c acq clk_f awake vdd vss
Xxn_28 n_27 n_28 vdd vss dly_pace
Xxn_86 n_85 n_86 vdd vss dly_bundle
Xxn_216 cmp_req n_216 vdd vss dly_acq
Xxn_217 cmp_req n_217 vdd vss dly_acq1
Xxn_225 n_223 n_225 vdd vss dly_hold
Xxn_241 n_240 n_241 vdd vss dly_fhi
Xxn_261 n_260 n_261 vdd vss dly_bundle
Xn_1_p1 n_1 rst_n vdd vdd sky130_fd_pr__pfet_01v8 W=0.7 L=0.15
Xn_1_p2 n_1 sgo vdd vdd sky130_fd_pr__pfet_01v8 W=0.7 L=0.15
Xn_1_n1 n_1 rst_n n_1_x vss sky130_fd_pr__nfet_01v8 W=0.84 L=0.15
Xn_1_n2 n_1_x sgo vss vss sky130_fd_pr__nfet_01v8 W=0.84 L=0.15
Xn_2_n n_2 c1n vss vss sky130_fd_pr__nfet_01v8 W=0.42 L=0.15
Xn_2_p n_2 c1n vdd vdd sky130_fd_pr__pfet_01v8 W=0.7 L=0.15
Xn_3_p1 n_3 c1p n_3_x vdd sky130_fd_pr__pfet_01v8 W=1.4 L=0.15
Xn_3_p2 n_3_x n_2 vdd vdd sky130_fd_pr__pfet_01v8 W=1.4 L=0.15
Xn_3_n1 n_3 c1p vss vss sky130_fd_pr__nfet_01v8 W=0.42 L=0.15
Xn_3_n2 n_3 n_2 vss vss sky130_fd_pr__nfet_01v8 W=0.42 L=0.15
Xn_4_n n_4 c1p vss vss sky130_fd_pr__nfet_01v8 W=0.42 L=0.15
Xn_4_p n_4 c1p vdd vdd sky130_fd_pr__pfet_01v8 W=0.7 L=0.15
Xn_5_p1 n_5 c1n n_5_x vdd sky130_fd_pr__pfet_01v8 W=1.4 L=0.15
Xn_5_p2 n_5_x n_4 vdd vdd sky130_fd_pr__pfet_01v8 W=1.4 L=0.15
Xn_5_n1 n_5 c1n vss vss sky130_fd_pr__nfet_01v8 W=0.42 L=0.15
Xn_5_n2 n_5 n_4 vss vss sky130_fd_pr__nfet_01v8 W=0.42 L=0.15
Xn_6_p1 n_6 n_3 n_6_x vdd sky130_fd_pr__pfet_01v8 W=1.4 L=0.15
Xn_6_p2 n_6_x n_5 vdd vdd sky130_fd_pr__pfet_01v8 W=1.4 L=0.15
Xn_6_n1 n_6 n_3 vss vss sky130_fd_pr__nfet_01v8 W=0.42 L=0.15
Xn_6_n2 n_6 n_5 vss vss sky130_fd_pr__nfet_01v8 W=0.42 L=0.15
Xn_7_n n_7 n_6 vss vss sky130_fd_pr__nfet_01v8 W=0.42 L=0.15
Xn_7_p n_7 n_6 vdd vdd sky130_fd_pr__pfet_01v8 W=0.7 L=0.15
Xn_8_n n_8 sgd vss vss sky130_fd_pr__nfet_01v8 W=0.42 L=0.15
Xn_8_p n_8 sgd vdd vdd sky130_fd_pr__pfet_01v8 W=0.7 L=0.15
Xn_9_p1 n_9 n_3 vdd vdd sky130_fd_pr__pfet_01v8 W=0.7 L=0.15
Xn_9_p2 n_9 n_8 vdd vdd sky130_fd_pr__pfet_01v8 W=0.7 L=0.15
Xn_9_n1 n_9 n_3 n_9_x vss sky130_fd_pr__nfet_01v8 W=0.84 L=0.15
Xn_9_n2 n_9_x n_8 vss vss sky130_fd_pr__nfet_01v8 W=0.84 L=0.15
Xn_10_n n_10 n_9 vss vss sky130_fd_pr__nfet_01v8 W=0.42 L=0.15
Xn_10_p n_10 n_9 vdd vdd sky130_fd_pr__pfet_01v8 W=0.7 L=0.15
Xn_11_p1 n_11 n_5 vdd vdd sky130_fd_pr__pfet_01v8 W=0.7 L=0.15
Xn_11_p2 n_11 n_8 vdd vdd sky130_fd_pr__pfet_01v8 W=0.7 L=0.15
Xn_11_n1 n_11 n_5 n_11_x vss sky130_fd_pr__nfet_01v8 W=0.84 L=0.15
Xn_11_n2 n_11_x n_8 vss vss sky130_fd_pr__nfet_01v8 W=0.84 L=0.15
Xn_12_n n_12 n_11 vss vss sky130_fd_pr__nfet_01v8 W=0.42 L=0.15
Xn_12_p n_12 n_11 vdd vdd sky130_fd_pr__pfet_01v8 W=0.7 L=0.15
Xn_13_p1 n_13 n_12 n_13_x vdd sky130_fd_pr__pfet_01v8 W=1.4 L=0.15
Xn_13_p2 n_13_x n_1 vdd vdd sky130_fd_pr__pfet_01v8 W=1.4 L=0.15
Xn_13_n1 n_13 n_12 vss vss sky130_fd_pr__nfet_01v8 W=0.42 L=0.15
Xn_13_n2 n_13 n_1 vss vss sky130_fd_pr__nfet_01v8 W=0.42 L=0.15
Xn_14_n n_14 n_13 vss vss sky130_fd_pr__nfet_01v8 W=0.42 L=0.15
Xn_14_p n_14 n_13 vdd vdd sky130_fd_pr__pfet_01v8 W=0.7 L=0.15
Xn_15_p1 n_15 n_10 n_15_x vdd sky130_fd_pr__pfet_01v8 W=1.4 L=0.15
Xn_15_p2 n_15_x sign vdd vdd sky130_fd_pr__pfet_01v8 W=1.4 L=0.15
Xn_15_n1 n_15 n_10 vss vss sky130_fd_pr__nfet_01v8 W=0.42 L=0.15
Xn_15_n2 n_15 sign vss vss sky130_fd_pr__nfet_01v8 W=0.42 L=0.15
Xsign_p1 sign n_14 sign_x vdd sky130_fd_pr__pfet_01v8 W=1.4 L=0.15
Xsign_p2 sign_x n_15 vdd vdd sky130_fd_pr__pfet_01v8 W=1.4 L=0.15
Xsign_n1 sign n_14 vss vss sky130_fd_pr__nfet_01v8 W=0.42 L=0.15
Xsign_n2 sign n_15 vss vss sky130_fd_pr__nfet_01v8 W=0.42 L=0.15
Xn_16_p1 n_16 n_7 vdd vdd sky130_fd_pr__pfet_01v8 W=0.7 L=0.15
Xn_16_p2 n_16 n_8 vdd vdd sky130_fd_pr__pfet_01v8 W=0.7 L=0.15
Xn_16_n1 n_16 n_7 n_16_x vss sky130_fd_pr__nfet_01v8 W=0.84 L=0.15
Xn_16_n2 n_16_x n_8 vss vss sky130_fd_pr__nfet_01v8 W=0.84 L=0.15
Xn_17_n n_17 n_16 vss vss sky130_fd_pr__nfet_01v8 W=0.42 L=0.15
Xn_17_p n_17 n_16 vdd vdd sky130_fd_pr__pfet_01v8 W=0.7 L=0.15
Xn_19_p1 n_19 n_17 n_19_x vdd sky130_fd_pr__pfet_01v8 W=1.4 L=0.15
Xn_19_p2 n_19_x n_18 vdd vdd sky130_fd_pr__pfet_01v8 W=1.4 L=0.15
Xn_19_n1 n_19 n_17 vss vss sky130_fd_pr__nfet_01v8 W=0.42 L=0.15
Xn_19_n2 n_19 n_18 vss vss sky130_fd_pr__nfet_01v8 W=0.42 L=0.15
Xn_18_p1 n_18 n_1 n_18_x vdd sky130_fd_pr__pfet_01v8 W=1.4 L=0.15
Xn_18_p2 n_18_x n_19 vdd vdd sky130_fd_pr__pfet_01v8 W=1.4 L=0.15
Xn_18_n1 n_18 n_1 vss vss sky130_fd_pr__nfet_01v8 W=0.42 L=0.15
Xn_18_n2 n_18 n_19 vss vss sky130_fd_pr__nfet_01v8 W=0.42 L=0.15
Xn_20_p1 n_20 n_1 n_20_x vdd sky130_fd_pr__pfet_01v8 W=1.4 L=0.15
Xn_20_p2 n_20_x n_18 vdd vdd sky130_fd_pr__pfet_01v8 W=1.4 L=0.15
Xn_20_n1 n_20 n_1 vss vss sky130_fd_pr__nfet_01v8 W=0.42 L=0.15
Xn_20_n2 n_20 n_18 vss vss sky130_fd_pr__nfet_01v8 W=0.42 L=0.15
Xn_21_p1 n_21 n_7 n_21_x vdd sky130_fd_pr__pfet_01v8 W=1.4 L=0.15
Xn_21_p2 n_21_x clk_c vdd vdd sky130_fd_pr__pfet_01v8 W=1.4 L=0.15
Xn_21_n1 n_21 n_7 vss vss sky130_fd_pr__nfet_01v8 W=0.42 L=0.15
Xn_21_n2 n_21 clk_c vss vss sky130_fd_pr__nfet_01v8 W=0.42 L=0.15
Xn_22_p1 n_22 n_18 vdd vdd sky130_fd_pr__pfet_01v8 W=0.7 L=0.15
Xn_22_p2 n_22 n_21 vdd vdd sky130_fd_pr__pfet_01v8 W=0.7 L=0.15
Xn_22_n1 n_22 n_18 n_22_x vss sky130_fd_pr__nfet_01v8 W=0.84 L=0.15
Xn_22_n2 n_22_x n_21 vss vss sky130_fd_pr__nfet_01v8 W=0.84 L=0.15
Xn_23_n n_23 n_22 vss vss sky130_fd_pr__nfet_01v8 W=0.42 L=0.15
Xn_23_p n_23 n_22 vdd vdd sky130_fd_pr__pfet_01v8 W=0.7 L=0.15
Xn_24_p1 n_24 n_23 n_24_x vdd sky130_fd_pr__pfet_01v8 W=1.4 L=0.15
Xn_24_p2 n_24_x sgd vdd vdd sky130_fd_pr__pfet_01v8 W=1.4 L=0.15
Xn_24_n1 n_24 n_23 vss vss sky130_fd_pr__nfet_01v8 W=0.42 L=0.15
Xn_24_n2 n_24 sgd vss vss sky130_fd_pr__nfet_01v8 W=0.42 L=0.15
Xsgd_p1 sgd n_1 sgd_x vdd sky130_fd_pr__pfet_01v8 W=1.4 L=0.15
Xsgd_p2 sgd_x n_24 vdd vdd sky130_fd_pr__pfet_01v8 W=1.4 L=0.15
Xsgd_n1 sgd n_1 vss vss sky130_fd_pr__nfet_01v8 W=0.42 L=0.15
Xsgd_n2 sgd n_24 vss vss sky130_fd_pr__nfet_01v8 W=0.42 L=0.15
Xsdone_n sdone n_8 vss vss sky130_fd_pr__nfet_01v8 W=0.42 L=0.15
Xsdone_p sdone n_8 vdd vdd sky130_fd_pr__pfet_01v8 W=0.7 L=0.15
Xcol_sign_p1 col_sign sign col_sign_x vdd sky130_fd_pr__pfet_01v8 W=1.4 L=0.15
Xcol_sign_p2 col_sign_x n_8 vdd vdd sky130_fd_pr__pfet_01v8 W=1.4 L=0.15
Xcol_sign_n1 col_sign sign vss vss sky130_fd_pr__nfet_01v8 W=0.42 L=0.15
Xcol_sign_n2 col_sign n_8 vss vss sky130_fd_pr__nfet_01v8 W=0.42 L=0.15
Xn_25_n n_25 c_got vss vss sky130_fd_pr__nfet_01v8 W=0.42 L=0.15
Xn_25_p n_25 c_got vdd vdd sky130_fd_pr__pfet_01v8 W=0.7 L=0.15
Xn_26_p1 n_26 n_25 vdd vdd sky130_fd_pr__pfet_01v8 W=0.7 L=0.15
Xn_26_p2 n_26 sgd vdd vdd sky130_fd_pr__pfet_01v8 W=0.7 L=0.15
Xn_26_n1 n_26 n_25 n_26_x vss sky130_fd_pr__nfet_01v8 W=0.84 L=0.15
Xn_26_n2 n_26_x sgd vss vss sky130_fd_pr__nfet_01v8 W=0.84 L=0.15
Xn_27_n n_27 n_26 vss vss sky130_fd_pr__nfet_01v8 W=0.42 L=0.15
Xn_27_p n_27 n_26 vdd vdd sky130_fd_pr__pfet_01v8 W=0.7 L=0.15
Xn_29_p1 n_29 n_27 vdd vdd sky130_fd_pr__pfet_01v8 W=0.7 L=0.15
Xn_29_p2 n_29 n_28 vdd vdd sky130_fd_pr__pfet_01v8 W=0.7 L=0.15
Xn_29_n1 n_29 n_27 n_29_x vss sky130_fd_pr__nfet_01v8 W=0.84 L=0.15
Xn_29_n2 n_29_x n_28 vss vss sky130_fd_pr__nfet_01v8 W=0.84 L=0.15
Xn_30_n n_30 n_29 vss vss sky130_fd_pr__nfet_01v8 W=0.42 L=0.15
Xn_30_p n_30 n_29 vdd vdd sky130_fd_pr__pfet_01v8 W=0.7 L=0.15
Xn_31_n n_31 cb_ack vss vss sky130_fd_pr__nfet_01v8 W=0.42 L=0.15
Xn_31_p n_31 cb_ack vdd vdd sky130_fd_pr__pfet_01v8 W=0.7 L=0.15
Xn_32_p1 n_32 n_30 vdd vdd sky130_fd_pr__pfet_01v8 W=0.7 L=0.15
Xn_32_p2 n_32 coarse_en vdd vdd sky130_fd_pr__pfet_01v8 W=0.7 L=0.15
Xn_32_n1 n_32 n_30 n_32_x vss sky130_fd_pr__nfet_01v8 W=0.84 L=0.15
Xn_32_n2 n_32_x coarse_en vss vss sky130_fd_pr__nfet_01v8 W=0.84 L=0.15
Xn_33_n n_33 n_32 vss vss sky130_fd_pr__nfet_01v8 W=0.42 L=0.15
Xn_33_p n_33 n_32 vdd vdd sky130_fd_pr__pfet_01v8 W=0.7 L=0.15
Xn_34_p1 n_34 sgd vdd vdd sky130_fd_pr__pfet_01v8 W=0.7 L=0.15
Xn_34_p2 n_34 n_31 vdd vdd sky130_fd_pr__pfet_01v8 W=0.7 L=0.15
Xn_34_n1 n_34 sgd n_34_x vss sky130_fd_pr__nfet_01v8 W=0.84 L=0.15
Xn_34_n2 n_34_x n_31 vss vss sky130_fd_pr__nfet_01v8 W=0.84 L=0.15
Xn_35_n n_35 n_34 vss vss sky130_fd_pr__nfet_01v8 W=0.42 L=0.15
Xn_35_p n_35 n_34 vdd vdd sky130_fd_pr__pfet_01v8 W=0.7 L=0.15
Xn_36_p1 n_36 n_33 vdd vdd sky130_fd_pr__pfet_01v8 W=0.7 L=0.15
Xn_36_p2 n_36 n_35 vdd vdd sky130_fd_pr__pfet_01v8 W=0.7 L=0.15
Xn_36_n1 n_36 n_33 n_36_x vss sky130_fd_pr__nfet_01v8 W=0.84 L=0.15
Xn_36_n2 n_36_x n_35 vss vss sky130_fd_pr__nfet_01v8 W=0.84 L=0.15
Xn_37_n n_37 n_36 vss vss sky130_fd_pr__nfet_01v8 W=0.42 L=0.15
Xn_37_p n_37 n_36 vdd vdd sky130_fd_pr__pfet_01v8 W=0.7 L=0.15
Xn_38_p1 n_38 n_1 n_38_x vdd sky130_fd_pr__pfet_01v8 W=1.4 L=0.15
Xn_38_p2 n_38_x c_got vdd vdd sky130_fd_pr__pfet_01v8 W=1.4 L=0.15
Xn_38_n1 n_38 n_1 vss vss sky130_fd_pr__nfet_01v8 W=0.42 L=0.15
Xn_38_n2 n_38 c_got vss vss sky130_fd_pr__nfet_01v8 W=0.42 L=0.15
Xn_39_n n_39 n_38 vss vss sky130_fd_pr__nfet_01v8 W=0.42 L=0.15
Xn_39_p n_39 n_38 vdd vdd sky130_fd_pr__pfet_01v8 W=0.7 L=0.15
Xn_41_p1 n_41 n_37 n_41_x vdd sky130_fd_pr__pfet_01v8 W=1.4 L=0.15
Xn_41_p2 n_41_x n_40 vdd vdd sky130_fd_pr__pfet_01v8 W=1.4 L=0.15
Xn_41_n1 n_41 n_37 vss vss sky130_fd_pr__nfet_01v8 W=0.42 L=0.15
Xn_41_n2 n_41 n_40 vss vss sky130_fd_pr__nfet_01v8 W=0.42 L=0.15
Xn_40_p1 n_40 n_39 n_40_x vdd sky130_fd_pr__pfet_01v8 W=1.4 L=0.15
Xn_40_p2 n_40_x n_41 vdd vdd sky130_fd_pr__pfet_01v8 W=1.4 L=0.15
Xn_40_n1 n_40 n_39 vss vss sky130_fd_pr__nfet_01v8 W=0.42 L=0.15
Xn_40_n2 n_40 n_41 vss vss sky130_fd_pr__nfet_01v8 W=0.42 L=0.15
Xn_42_n n_42 sign vss vss sky130_fd_pr__nfet_01v8 W=0.42 L=0.15
Xn_42_p n_42 sign vdd vdd sky130_fd_pr__pfet_01v8 W=0.7 L=0.15
Xn_43_p1 n_43 sign vdd vdd sky130_fd_pr__pfet_01v8 W=0.7 L=0.15
Xn_43_p2 n_43 n_3 vdd vdd sky130_fd_pr__pfet_01v8 W=0.7 L=0.15
Xn_43_n1 n_43 sign n_43_x vss sky130_fd_pr__nfet_01v8 W=0.84 L=0.15
Xn_43_n2 n_43_x n_3 vss vss sky130_fd_pr__nfet_01v8 W=0.84 L=0.15
Xn_44_p1 n_44 n_42 vdd vdd sky130_fd_pr__pfet_01v8 W=0.7 L=0.15
Xn_44_p2 n_44 n_5 vdd vdd sky130_fd_pr__pfet_01v8 W=0.7 L=0.15
Xn_44_n1 n_44 n_42 n_44_x vss sky130_fd_pr__nfet_01v8 W=0.84 L=0.15
Xn_44_n2 n_44_x n_5 vss vss sky130_fd_pr__nfet_01v8 W=0.84 L=0.15
Xn_45_p1 n_45 n_43 vdd vdd sky130_fd_pr__pfet_01v8 W=0.7 L=0.15
Xn_45_p2 n_45 n_44 vdd vdd sky130_fd_pr__pfet_01v8 W=0.7 L=0.15
Xn_45_n1 n_45 n_43 n_45_x vss sky130_fd_pr__nfet_01v8 W=0.84 L=0.15
Xn_45_n2 n_45_x n_44 vss vss sky130_fd_pr__nfet_01v8 W=0.84 L=0.15
Xn_46_p1 n_46 sign vdd vdd sky130_fd_pr__pfet_01v8 W=0.7 L=0.15
Xn_46_p2 n_46 n_5 vdd vdd sky130_fd_pr__pfet_01v8 W=0.7 L=0.15
Xn_46_n1 n_46 sign n_46_x vss sky130_fd_pr__nfet_01v8 W=0.84 L=0.15
Xn_46_n2 n_46_x n_5 vss vss sky130_fd_pr__nfet_01v8 W=0.84 L=0.15
Xn_47_p1 n_47 n_42 vdd vdd sky130_fd_pr__pfet_01v8 W=0.7 L=0.15
Xn_47_p2 n_47 n_3 vdd vdd sky130_fd_pr__pfet_01v8 W=0.7 L=0.15
Xn_47_n1 n_47 n_42 n_47_x vss sky130_fd_pr__nfet_01v8 W=0.84 L=0.15
Xn_47_n2 n_47_x n_3 vss vss sky130_fd_pr__nfet_01v8 W=0.84 L=0.15
Xn_48_p1 n_48 n_46 vdd vdd sky130_fd_pr__pfet_01v8 W=0.7 L=0.15
Xn_48_p2 n_48 n_47 vdd vdd sky130_fd_pr__pfet_01v8 W=0.7 L=0.15
Xn_48_n1 n_48 n_46 n_48_x vss sky130_fd_pr__nfet_01v8 W=0.84 L=0.15
Xn_48_n2 n_48_x n_47 vss vss sky130_fd_pr__nfet_01v8 W=0.84 L=0.15
Xn_49_p1 n_49 n_45 vdd vdd sky130_fd_pr__pfet_01v8 W=0.7 L=0.15
Xn_49_p2 n_49 sgd vdd vdd sky130_fd_pr__pfet_01v8 W=0.7 L=0.15
Xn_49_n1 n_49 n_45 n_49_x vss sky130_fd_pr__nfet_01v8 W=0.84 L=0.15
Xn_49_n2 n_49_x sgd vss vss sky130_fd_pr__nfet_01v8 W=0.84 L=0.15
Xn_50_n n_50 n_49 vss vss sky130_fd_pr__nfet_01v8 W=0.42 L=0.15
Xn_50_p n_50 n_49 vdd vdd sky130_fd_pr__pfet_01v8 W=0.7 L=0.15
Xn_51_p1 n_51 n_48 vdd vdd sky130_fd_pr__pfet_01v8 W=0.7 L=0.15
Xn_51_p2 n_51 sgd vdd vdd sky130_fd_pr__pfet_01v8 W=0.7 L=0.15
Xn_51_n1 n_51 n_48 n_51_x vss sky130_fd_pr__nfet_01v8 W=0.84 L=0.15
Xn_51_n2 n_51_x sgd vss vss sky130_fd_pr__nfet_01v8 W=0.84 L=0.15
Xn_52_n n_52 n_51 vss vss sky130_fd_pr__nfet_01v8 W=0.42 L=0.15
Xn_52_p n_52 n_51 vdd vdd sky130_fd_pr__pfet_01v8 W=0.7 L=0.15
Xn_53_p1 n_53 n_52 n_53_x vdd sky130_fd_pr__pfet_01v8 W=1.4 L=0.15
Xn_53_p2 n_53_x n_1 vdd vdd sky130_fd_pr__pfet_01v8 W=1.4 L=0.15
Xn_53_n1 n_53 n_52 vss vss sky130_fd_pr__nfet_01v8 W=0.42 L=0.15
Xn_53_n2 n_53 n_1 vss vss sky130_fd_pr__nfet_01v8 W=0.42 L=0.15
Xn_54_n n_54 n_53 vss vss sky130_fd_pr__nfet_01v8 W=0.42 L=0.15
Xn_54_p n_54 n_53 vdd vdd sky130_fd_pr__pfet_01v8 W=0.7 L=0.15
Xn_55_p1 n_55 n_50 n_55_x vdd sky130_fd_pr__pfet_01v8 W=1.4 L=0.15
Xn_55_p2 n_55_x cb_cross vdd vdd sky130_fd_pr__pfet_01v8 W=1.4 L=0.15
Xn_55_n1 n_55 n_50 vss vss sky130_fd_pr__nfet_01v8 W=0.42 L=0.15
Xn_55_n2 n_55 cb_cross vss vss sky130_fd_pr__nfet_01v8 W=0.42 L=0.15
Xcb_cross_p1 cb_cross n_54 cb_cross_x vdd sky130_fd_pr__pfet_01v8 W=1.4 L=0.15
Xcb_cross_p2 cb_cross_x n_55 vdd vdd sky130_fd_pr__pfet_01v8 W=1.4 L=0.15
Xcb_cross_n1 cb_cross n_54 vss vss sky130_fd_pr__nfet_01v8 W=0.42 L=0.15
Xcb_cross_n2 cb_cross n_55 vss vss sky130_fd_pr__nfet_01v8 W=0.42 L=0.15
Xn_56_p1 n_56 n_7 vdd vdd sky130_fd_pr__pfet_01v8 W=0.7 L=0.15
Xn_56_p2 n_56 n_40 vdd vdd sky130_fd_pr__pfet_01v8 W=0.7 L=0.15
Xn_56_n1 n_56 n_7 n_56_x vss sky130_fd_pr__nfet_01v8 W=0.84 L=0.15
Xn_56_n2 n_56_x n_40 vss vss sky130_fd_pr__nfet_01v8 W=0.84 L=0.15
Xn_57_n n_57 n_56 vss vss sky130_fd_pr__nfet_01v8 W=0.42 L=0.15
Xn_57_p n_57 n_56 vdd vdd sky130_fd_pr__pfet_01v8 W=0.7 L=0.15
Xn_58_p1 n_58 acked vdd vdd sky130_fd_pr__pfet_01v8 W=0.7 L=0.15
Xn_58_p2 n_58 n_31 vdd vdd sky130_fd_pr__pfet_01v8 W=0.7 L=0.15
Xn_58_n1 n_58 acked n_58_x vss sky130_fd_pr__nfet_01v8 W=0.84 L=0.15
Xn_58_n2 n_58_x n_31 vss vss sky130_fd_pr__nfet_01v8 W=0.84 L=0.15
Xn_59_n n_59 n_58 vss vss sky130_fd_pr__nfet_01v8 W=0.42 L=0.15
Xn_59_p n_59 n_58 vdd vdd sky130_fd_pr__pfet_01v8 W=0.7 L=0.15
Xn_60_p1 n_60 n_1 n_60_x vdd sky130_fd_pr__pfet_01v8 W=1.4 L=0.15
Xn_60_p2 n_60_x n_59 vdd vdd sky130_fd_pr__pfet_01v8 W=1.4 L=0.15
Xn_60_n1 n_60 n_1 vss vss sky130_fd_pr__nfet_01v8 W=0.42 L=0.15
Xn_60_n2 n_60 n_59 vss vss sky130_fd_pr__nfet_01v8 W=0.42 L=0.15
Xn_61_n n_61 n_60 vss vss sky130_fd_pr__nfet_01v8 W=0.42 L=0.15
Xn_61_p n_61 n_60 vdd vdd sky130_fd_pr__pfet_01v8 W=0.7 L=0.15
Xn_62_p1 n_62 n_57 n_62_x vdd sky130_fd_pr__pfet_01v8 W=1.4 L=0.15
Xn_62_p2 n_62_x c_got vdd vdd sky130_fd_pr__pfet_01v8 W=1.4 L=0.15
Xn_62_n1 n_62 n_57 vss vss sky130_fd_pr__nfet_01v8 W=0.42 L=0.15
Xn_62_n2 n_62 c_got vss vss sky130_fd_pr__nfet_01v8 W=0.42 L=0.15
Xc_got_p1 c_got n_61 c_got_x vdd sky130_fd_pr__pfet_01v8 W=1.4 L=0.15
Xc_got_p2 c_got_x n_62 vdd vdd sky130_fd_pr__pfet_01v8 W=1.4 L=0.15
Xc_got_n1 c_got n_61 vss vss sky130_fd_pr__nfet_01v8 W=0.42 L=0.15
Xc_got_n2 c_got n_62 vss vss sky130_fd_pr__nfet_01v8 W=0.42 L=0.15
Xn_63_p1 n_63 cb_ack vdd vdd sky130_fd_pr__pfet_01v8 W=0.7 L=0.15
Xn_63_p2 n_63 c_got vdd vdd sky130_fd_pr__pfet_01v8 W=0.7 L=0.15
Xn_63_n1 n_63 cb_ack n_63_x vss sky130_fd_pr__nfet_01v8 W=0.84 L=0.15
Xn_63_n2 n_63_x c_got vss vss sky130_fd_pr__nfet_01v8 W=0.84 L=0.15
Xn_64_n n_64 n_63 vss vss sky130_fd_pr__nfet_01v8 W=0.42 L=0.15
Xn_64_p n_64 n_63 vdd vdd sky130_fd_pr__pfet_01v8 W=0.7 L=0.15
Xn_65_p1 n_65 n_64 n_65_x vdd sky130_fd_pr__pfet_01v8 W=1.4 L=0.15
Xn_65_p2 n_65_x acked vdd vdd sky130_fd_pr__pfet_01v8 W=1.4 L=0.15
Xn_65_n1 n_65 n_64 vss vss sky130_fd_pr__nfet_01v8 W=0.42 L=0.15
Xn_65_n2 n_65 acked vss vss sky130_fd_pr__nfet_01v8 W=0.42 L=0.15
Xacked_p1 acked n_25 acked_x vdd sky130_fd_pr__pfet_01v8 W=1.4 L=0.15
Xacked_p2 acked_x n_65 vdd vdd sky130_fd_pr__pfet_01v8 W=1.4 L=0.15
Xacked_n1 acked n_25 vss vss sky130_fd_pr__nfet_01v8 W=0.42 L=0.15
Xacked_n2 acked n_65 vss vss sky130_fd_pr__nfet_01v8 W=0.42 L=0.15
Xn_66_p1 n_66 n_20 n_66_x vdd sky130_fd_pr__pfet_01v8 W=1.4 L=0.15
Xn_66_p2 n_66_x n_40 vdd vdd sky130_fd_pr__pfet_01v8 W=1.4 L=0.15
Xn_66_n1 n_66 n_20 vss vss sky130_fd_pr__nfet_01v8 W=0.42 L=0.15
Xn_66_n2 n_66 n_40 vss vss sky130_fd_pr__nfet_01v8 W=0.42 L=0.15
Xn_67_n n_67 n_66 vss vss sky130_fd_pr__nfet_01v8 W=0.42 L=0.15
Xn_67_p n_67 n_66 vdd vdd sky130_fd_pr__pfet_01v8 W=0.7 L=0.15
Xn_68_n n_68 phi1 vss vss sky130_fd_pr__nfet_01v8 W=0.42 L=0.15
Xn_68_p n_68 phi1 vdd vdd sky130_fd_pr__pfet_01v8 W=0.7 L=0.15
Xn_69_p1 n_69 n_67 vdd vdd sky130_fd_pr__pfet_01v8 W=0.7 L=0.15
Xn_69_p2 n_69 n_68 vdd vdd sky130_fd_pr__pfet_01v8 W=0.7 L=0.15
Xn_69_n1 n_69 n_67 n_69_x vss sky130_fd_pr__nfet_01v8 W=0.84 L=0.15
Xn_69_n2 n_69_x n_68 vss vss sky130_fd_pr__nfet_01v8 W=0.84 L=0.15
Xn_70_n n_70 n_69 vss vss sky130_fd_pr__nfet_01v8 W=0.42 L=0.15
Xn_70_p n_70 n_69 vdd vdd sky130_fd_pr__pfet_01v8 W=0.7 L=0.15
Xn_71_n n_71 n_67 vss vss sky130_fd_pr__nfet_01v8 W=0.42 L=0.15
Xn_71_p n_71 n_67 vdd vdd sky130_fd_pr__pfet_01v8 W=0.7 L=0.15
Xn_72_p1 n_72 n_71 n_72_x vdd sky130_fd_pr__pfet_01v8 W=1.4 L=0.15
Xn_72_p2 n_72_x n_1 vdd vdd sky130_fd_pr__pfet_01v8 W=1.4 L=0.15
Xn_72_n1 n_72 n_71 vss vss sky130_fd_pr__nfet_01v8 W=0.42 L=0.15
Xn_72_n2 n_72 n_1 vss vss sky130_fd_pr__nfet_01v8 W=0.42 L=0.15
Xn_73_n n_73 n_72 vss vss sky130_fd_pr__nfet_01v8 W=0.42 L=0.15
Xn_73_p n_73 n_72 vdd vdd sky130_fd_pr__pfet_01v8 W=0.7 L=0.15
Xn_75_p1 n_75 n_70 n_75_x vdd sky130_fd_pr__pfet_01v8 W=1.4 L=0.15
Xn_75_p2 n_75_x n_74 vdd vdd sky130_fd_pr__pfet_01v8 W=1.4 L=0.15
Xn_75_n1 n_75 n_70 vss vss sky130_fd_pr__nfet_01v8 W=0.42 L=0.15
Xn_75_n2 n_75 n_74 vss vss sky130_fd_pr__nfet_01v8 W=0.42 L=0.15
Xn_74_p1 n_74 n_73 n_74_x vdd sky130_fd_pr__pfet_01v8 W=1.4 L=0.15
Xn_74_p2 n_74_x n_75 vdd vdd sky130_fd_pr__pfet_01v8 W=1.4 L=0.15
Xn_74_n1 n_74 n_73 vss vss sky130_fd_pr__nfet_01v8 W=0.42 L=0.15
Xn_74_n2 n_74 n_75 vss vss sky130_fd_pr__nfet_01v8 W=0.42 L=0.15
Xn_76_p1 n_76 n_74 vdd vdd sky130_fd_pr__pfet_01v8 W=0.7 L=0.15
Xn_76_p2 n_76 phi1 vdd vdd sky130_fd_pr__pfet_01v8 W=0.7 L=0.15
Xn_76_n1 n_76 n_74 n_76_x vss sky130_fd_pr__nfet_01v8 W=0.84 L=0.15
Xn_76_n2 n_76_x phi1 vss vss sky130_fd_pr__nfet_01v8 W=0.84 L=0.15
Xn_77_n n_77 n_76 vss vss sky130_fd_pr__nfet_01v8 W=0.42 L=0.15
Xn_77_p n_77 n_76 vdd vdd sky130_fd_pr__pfet_01v8 W=0.7 L=0.15
Xn_78_p1 n_78 n_74 n_78_x vdd sky130_fd_pr__pfet_01v8 W=1.4 L=0.15
Xn_78_p2 n_78_x phi1 vdd vdd sky130_fd_pr__pfet_01v8 W=1.4 L=0.15
Xn_78_n1 n_78 n_74 vss vss sky130_fd_pr__nfet_01v8 W=0.42 L=0.15
Xn_78_n2 n_78 phi1 vss vss sky130_fd_pr__nfet_01v8 W=0.42 L=0.15
Xn_79_p1 n_79 n_78 n_79_x vdd sky130_fd_pr__pfet_01v8 W=1.4 L=0.15
Xn_79_p2 n_79_x n_1 vdd vdd sky130_fd_pr__pfet_01v8 W=1.4 L=0.15
Xn_79_n1 n_79 n_78 vss vss sky130_fd_pr__nfet_01v8 W=0.42 L=0.15
Xn_79_n2 n_79 n_1 vss vss sky130_fd_pr__nfet_01v8 W=0.42 L=0.15
Xn_80_n n_80 n_79 vss vss sky130_fd_pr__nfet_01v8 W=0.42 L=0.15
Xn_80_p n_80 n_79 vdd vdd sky130_fd_pr__pfet_01v8 W=0.7 L=0.15
Xn_82_p1 n_82 n_77 n_82_x vdd sky130_fd_pr__pfet_01v8 W=1.4 L=0.15
Xn_82_p2 n_82_x n_81 vdd vdd sky130_fd_pr__pfet_01v8 W=1.4 L=0.15
Xn_82_n1 n_82 n_77 vss vss sky130_fd_pr__nfet_01v8 W=0.42 L=0.15
Xn_82_n2 n_82 n_81 vss vss sky130_fd_pr__nfet_01v8 W=0.42 L=0.15
Xn_81_p1 n_81 n_80 n_81_x vdd sky130_fd_pr__pfet_01v8 W=1.4 L=0.15
Xn_81_p2 n_81_x n_82 vdd vdd sky130_fd_pr__pfet_01v8 W=1.4 L=0.15
Xn_81_n1 n_81 n_80 vss vss sky130_fd_pr__nfet_01v8 W=0.42 L=0.15
Xn_81_n2 n_81 n_82 vss vss sky130_fd_pr__nfet_01v8 W=0.42 L=0.15
Xn_83_n n_83 n_81 vss vss sky130_fd_pr__nfet_01v8 W=0.42 L=0.15
Xn_83_p n_83 n_81 vdd vdd sky130_fd_pr__pfet_01v8 W=0.7 L=0.15
Xclk_c_n clk_c n_83 vss vss sky130_fd_pr__nfet_01v8 W=0.42 L=0.15
Xclk_c_p clk_c n_83 vdd vdd sky130_fd_pr__pfet_01v8 W=0.7 L=0.15
Xn_84_p1 n_84 c_got vdd vdd sky130_fd_pr__pfet_01v8 W=0.7 L=0.15
Xn_84_p2 n_84 n_21 vdd vdd sky130_fd_pr__pfet_01v8 W=0.7 L=0.15
Xn_84_n1 n_84 c_got n_84_x vss sky130_fd_pr__nfet_01v8 W=0.84 L=0.15
Xn_84_n2 n_84_x n_21 vss vss sky130_fd_pr__nfet_01v8 W=0.84 L=0.15
Xn_85_n n_85 n_84 vss vss sky130_fd_pr__nfet_01v8 W=0.42 L=0.15
Xn_85_p n_85 n_84 vdd vdd sky130_fd_pr__pfet_01v8 W=0.7 L=0.15
Xn_87_p1 n_87 n_85 vdd vdd sky130_fd_pr__pfet_01v8 W=0.7 L=0.15
Xn_87_p2 n_87 n_86 vdd vdd sky130_fd_pr__pfet_01v8 W=0.7 L=0.15
Xn_87_n1 n_87 n_85 n_87_x vss sky130_fd_pr__nfet_01v8 W=0.84 L=0.15
Xn_87_n2 n_87_x n_86 vss vss sky130_fd_pr__nfet_01v8 W=0.84 L=0.15
Xn_88_n n_88 n_87 vss vss sky130_fd_pr__nfet_01v8 W=0.42 L=0.15
Xn_88_p n_88 n_87 vdd vdd sky130_fd_pr__pfet_01v8 W=0.7 L=0.15
Xn_89_n n_89 n_88 vss vss sky130_fd_pr__nfet_01v8 W=0.42 L=0.15
Xn_89_p n_89 n_88 vdd vdd sky130_fd_pr__pfet_01v8 W=0.7 L=0.15
Xn_90_n n_90 cb_cross vss vss sky130_fd_pr__nfet_01v8 W=0.42 L=0.15
Xn_90_p n_90 cb_cross vdd vdd sky130_fd_pr__pfet_01v8 W=0.7 L=0.15
Xn_91_p1 n_91 cb_ack vdd vdd sky130_fd_pr__pfet_01v8 W=0.7 L=0.15
Xn_91_p2 n_91 cb_cross vdd vdd sky130_fd_pr__pfet_01v8 W=0.7 L=0.15
Xn_91_n1 n_91 cb_ack n_91_x vss sky130_fd_pr__nfet_01v8 W=0.84 L=0.15
Xn_91_n2 n_91_x cb_cross vss vss sky130_fd_pr__nfet_01v8 W=0.84 L=0.15
Xn_92_n n_92 n_91 vss vss sky130_fd_pr__nfet_01v8 W=0.42 L=0.15
Xn_92_p n_92 n_91 vdd vdd sky130_fd_pr__pfet_01v8 W=0.7 L=0.15
Xn_93_p1 n_93 n_92 vdd vdd sky130_fd_pr__pfet_01v8 W=0.7 L=0.15
Xn_93_p2 n_93 c_got vdd vdd sky130_fd_pr__pfet_01v8 W=0.7 L=0.15
Xn_93_n1 n_93 n_92 n_93_x vss sky130_fd_pr__nfet_01v8 W=0.84 L=0.15
Xn_93_n2 n_93_x c_got vss vss sky130_fd_pr__nfet_01v8 W=0.84 L=0.15
Xn_94_n n_94 n_93 vss vss sky130_fd_pr__nfet_01v8 W=0.42 L=0.15
Xn_94_p n_94 n_93 vdd vdd sky130_fd_pr__pfet_01v8 W=0.7 L=0.15
Xn_95_n n_95 phi2 vss vss sky130_fd_pr__nfet_01v8 W=0.42 L=0.15
Xn_95_p n_95 phi2 vdd vdd sky130_fd_pr__pfet_01v8 W=0.7 L=0.15
Xn_96_n n_96 n_95 vss vss sky130_fd_pr__nfet_01v8 W=0.42 L=0.15
Xn_96_p n_96 n_95 vdd vdd sky130_fd_pr__pfet_01v8 W=0.7 L=0.15
Xn_97_n n_97 n_96 vss vss sky130_fd_pr__nfet_01v8 W=0.42 L=0.15
Xn_97_p n_97 n_96 vdd vdd sky130_fd_pr__pfet_01v8 W=0.7 L=0.15
Xn_98_n n_98 n_97 vss vss sky130_fd_pr__nfet_01v8 W=0.42 L=0.15
Xn_98_p n_98 n_97 vdd vdd sky130_fd_pr__pfet_01v8 W=0.7 L=0.15
Xn_99_n n_99 n_98 vss vss sky130_fd_pr__nfet_01v8 W=0.42 L=0.15
Xn_99_p n_99 n_98 vdd vdd sky130_fd_pr__pfet_01v8 W=0.7 L=0.15
Xn_100_p1 n_100 n_95 n_100_x vdd sky130_fd_pr__pfet_01v8 W=1.4 L=0.15
Xn_100_p2 n_100_x n_99 vdd vdd sky130_fd_pr__pfet_01v8 W=1.4 L=0.15
Xn_100_n1 n_100 n_95 vss vss sky130_fd_pr__nfet_01v8 W=0.42 L=0.15
Xn_100_n2 n_100 n_99 vss vss sky130_fd_pr__nfet_01v8 W=0.42 L=0.15
Xn_101_n n_101 n_100 vss vss sky130_fd_pr__nfet_01v8 W=0.84 L=0.15
Xn_101_p n_101 n_100 vdd vdd sky130_fd_pr__pfet_01v8 W=1.4 L=0.15
Xn_102_p1 n_102 n_95 vdd vdd sky130_fd_pr__pfet_01v8 W=0.7 L=0.15
Xn_102_p2 n_102 n_99 vdd vdd sky130_fd_pr__pfet_01v8 W=0.7 L=0.15
Xn_102_n1 n_102 n_95 n_102_x vss sky130_fd_pr__nfet_01v8 W=0.84 L=0.15
Xn_102_n2 n_102_x n_99 vss vss sky130_fd_pr__nfet_01v8 W=0.84 L=0.15
Xn_103_n n_103 n_102 vss vss sky130_fd_pr__nfet_01v8 W=0.42 L=0.15
Xn_103_p n_103 n_102 vdd vdd sky130_fd_pr__pfet_01v8 W=0.7 L=0.15
Xn_104_n n_104 n_103 vss vss sky130_fd_pr__nfet_01v8 W=0.84 L=0.15
Xn_104_p n_104 n_103 vdd vdd sky130_fd_pr__pfet_01v8 W=1.4 L=0.15
Xn_105_p1 n_105 pkt_d0 n_105_x vdd sky130_fd_pr__pfet_01v8 W=1.4 L=0.15
Xn_105_p2 n_105_x pkt_d1 vdd vdd sky130_fd_pr__pfet_01v8 W=1.4 L=0.15
Xn_105_n1 n_105 pkt_d0 vss vss sky130_fd_pr__nfet_01v8 W=0.42 L=0.15
Xn_105_n2 n_105 pkt_d1 vss vss sky130_fd_pr__nfet_01v8 W=0.42 L=0.15
Xn_106_n n_106 n_105 vss vss sky130_fd_pr__nfet_01v8 W=0.42 L=0.15
Xn_106_p n_106 n_105 vdd vdd sky130_fd_pr__pfet_01v8 W=0.7 L=0.15
Xn_107_p1 n_107 n_106 n_107_x vdd sky130_fd_pr__pfet_01v8 W=1.4 L=0.15
Xn_107_p2 n_107_x pkt_d2 vdd vdd sky130_fd_pr__pfet_01v8 W=1.4 L=0.15
Xn_107_n1 n_107 n_106 vss vss sky130_fd_pr__nfet_01v8 W=0.42 L=0.15
Xn_107_n2 n_107 pkt_d2 vss vss sky130_fd_pr__nfet_01v8 W=0.42 L=0.15
Xn_108_p1 n_108 pkt_d0 n_108_x vdd sky130_fd_pr__pfet_01v8 W=1.4 L=0.15
Xn_108_p2 n_108_x n_107 vdd vdd sky130_fd_pr__pfet_01v8 W=1.4 L=0.15
Xn_108_n1 n_108 pkt_d0 vss vss sky130_fd_pr__nfet_01v8 W=0.42 L=0.15
Xn_108_n2 n_108 n_107 vss vss sky130_fd_pr__nfet_01v8 W=0.42 L=0.15
Xn_109_n n_109 n_108 vss vss sky130_fd_pr__nfet_01v8 W=0.42 L=0.15
Xn_109_p n_109 n_108 vdd vdd sky130_fd_pr__pfet_01v8 W=0.7 L=0.15
Xn_110_n n_110 fn0 vss vss sky130_fd_pr__nfet_01v8 W=0.42 L=0.15
Xn_110_p n_110 fn0 vdd vdd sky130_fd_pr__pfet_01v8 W=0.7 L=0.15
Xn_111_p1 n_111 n_110 vdd vdd sky130_fd_pr__pfet_01v8 W=0.7 L=0.15
Xn_111_p2 n_111 n_109 vdd vdd sky130_fd_pr__pfet_01v8 W=0.7 L=0.15
Xn_111_n1 n_111 n_110 n_111_x vss sky130_fd_pr__nfet_01v8 W=0.84 L=0.15
Xn_111_n2 n_111_x n_109 vss vss sky130_fd_pr__nfet_01v8 W=0.84 L=0.15
Xn_112_n n_112 n_111 vss vss sky130_fd_pr__nfet_01v8 W=0.42 L=0.15
Xn_112_p n_112 n_111 vdd vdd sky130_fd_pr__pfet_01v8 W=0.7 L=0.15
Xn_113_n n_113 fn1 vss vss sky130_fd_pr__nfet_01v8 W=0.42 L=0.15
Xn_113_p n_113 fn1 vdd vdd sky130_fd_pr__pfet_01v8 W=0.7 L=0.15
Xn_114_p1 n_114 n_113 vdd vdd sky130_fd_pr__pfet_01v8 W=0.7 L=0.15
Xn_114_p2 n_114 pkt_d1 vdd vdd sky130_fd_pr__pfet_01v8 W=0.7 L=0.15
Xn_114_n1 n_114 n_113 n_114_x vss sky130_fd_pr__nfet_01v8 W=0.84 L=0.15
Xn_114_n2 n_114_x pkt_d1 vss vss sky130_fd_pr__nfet_01v8 W=0.84 L=0.15
Xn_115_p1 n_115 n_113 n_115_x vdd sky130_fd_pr__pfet_01v8 W=1.4 L=0.15
Xn_115_p2 n_115_x pkt_d1 vdd vdd sky130_fd_pr__pfet_01v8 W=1.4 L=0.15
Xn_115_n1 n_115 n_113 vss vss sky130_fd_pr__nfet_01v8 W=0.42 L=0.15
Xn_115_n2 n_115 pkt_d1 vss vss sky130_fd_pr__nfet_01v8 W=0.42 L=0.15
Xn_116_n n_116 n_115 vss vss sky130_fd_pr__nfet_01v8 W=0.42 L=0.15
Xn_116_p n_116 n_115 vdd vdd sky130_fd_pr__pfet_01v8 W=0.7 L=0.15
Xn_117_p1 n_117 n_112 vdd vdd sky130_fd_pr__pfet_01v8 W=0.7 L=0.15
Xn_117_p2 n_117 n_116 vdd vdd sky130_fd_pr__pfet_01v8 W=0.7 L=0.15
Xn_117_n1 n_117 n_112 n_117_x vss sky130_fd_pr__nfet_01v8 W=0.84 L=0.15
Xn_117_n2 n_117_x n_116 vss vss sky130_fd_pr__nfet_01v8 W=0.84 L=0.15
Xn_118_p1 n_118 n_114 vdd vdd sky130_fd_pr__pfet_01v8 W=0.7 L=0.15
Xn_118_p2 n_118 n_117 vdd vdd sky130_fd_pr__pfet_01v8 W=0.7 L=0.15
Xn_118_n1 n_118 n_114 n_118_x vss sky130_fd_pr__nfet_01v8 W=0.84 L=0.15
Xn_118_n2 n_118_x n_117 vss vss sky130_fd_pr__nfet_01v8 W=0.84 L=0.15
Xn_119_n n_119 fn2 vss vss sky130_fd_pr__nfet_01v8 W=0.42 L=0.15
Xn_119_p n_119 fn2 vdd vdd sky130_fd_pr__pfet_01v8 W=0.7 L=0.15
Xn_120_p1 n_120 n_119 vdd vdd sky130_fd_pr__pfet_01v8 W=0.7 L=0.15
Xn_120_p2 n_120 pkt_d2 vdd vdd sky130_fd_pr__pfet_01v8 W=0.7 L=0.15
Xn_120_n1 n_120 n_119 n_120_x vss sky130_fd_pr__nfet_01v8 W=0.84 L=0.15
Xn_120_n2 n_120_x pkt_d2 vss vss sky130_fd_pr__nfet_01v8 W=0.84 L=0.15
Xn_121_p1 n_121 n_119 n_121_x vdd sky130_fd_pr__pfet_01v8 W=1.4 L=0.15
Xn_121_p2 n_121_x pkt_d2 vdd vdd sky130_fd_pr__pfet_01v8 W=1.4 L=0.15
Xn_121_n1 n_121 n_119 vss vss sky130_fd_pr__nfet_01v8 W=0.42 L=0.15
Xn_121_n2 n_121 pkt_d2 vss vss sky130_fd_pr__nfet_01v8 W=0.42 L=0.15
Xn_122_n n_122 n_121 vss vss sky130_fd_pr__nfet_01v8 W=0.42 L=0.15
Xn_122_p n_122 n_121 vdd vdd sky130_fd_pr__pfet_01v8 W=0.7 L=0.15
Xn_123_p1 n_123 n_118 vdd vdd sky130_fd_pr__pfet_01v8 W=0.7 L=0.15
Xn_123_p2 n_123 n_122 vdd vdd sky130_fd_pr__pfet_01v8 W=0.7 L=0.15
Xn_123_n1 n_123 n_118 n_123_x vss sky130_fd_pr__nfet_01v8 W=0.84 L=0.15
Xn_123_n2 n_123_x n_122 vss vss sky130_fd_pr__nfet_01v8 W=0.84 L=0.15
Xn_124_p1 n_124 n_120 vdd vdd sky130_fd_pr__pfet_01v8 W=0.7 L=0.15
Xn_124_p2 n_124 n_123 vdd vdd sky130_fd_pr__pfet_01v8 W=0.7 L=0.15
Xn_124_n1 n_124 n_120 n_124_x vss sky130_fd_pr__nfet_01v8 W=0.84 L=0.15
Xn_124_n2 n_124_x n_123 vss vss sky130_fd_pr__nfet_01v8 W=0.84 L=0.15
Xn_125_p1 n_125 n_94 vdd vdd sky130_fd_pr__pfet_01v8 W=0.7 L=0.15
Xn_125_p2 n_125 n_124 vdd vdd sky130_fd_pr__pfet_01v8 W=0.7 L=0.15
Xn_125_n1 n_125 n_94 n_125_x vss sky130_fd_pr__nfet_01v8 W=0.84 L=0.15
Xn_125_n2 n_125_x n_124 vss vss sky130_fd_pr__nfet_01v8 W=0.84 L=0.15
Xn_126_n n_126 n_125 vss vss sky130_fd_pr__nfet_01v8 W=0.42 L=0.15
Xn_126_p n_126 n_125 vdd vdd sky130_fd_pr__pfet_01v8 W=0.7 L=0.15
Xn_127_n n_127 n_126 vss vss sky130_fd_pr__nfet_01v8 W=0.42 L=0.15
Xn_127_p n_127 n_126 vdd vdd sky130_fd_pr__pfet_01v8 W=0.7 L=0.15
Xn_128_p1 n_128 n_126 n_128_x vdd sky130_fd_pr__pfet_01v8 W=1.4 L=0.15
Xn_128_p2 n_128_x n_101 vdd vdd sky130_fd_pr__pfet_01v8 W=1.4 L=0.15
Xn_128_n1 n_128 n_126 vss vss sky130_fd_pr__nfet_01v8 W=0.42 L=0.15
Xn_128_n2 n_128 n_101 vss vss sky130_fd_pr__nfet_01v8 W=0.42 L=0.15
Xn_129_p1 n_129 n_128 n_129_x vdd sky130_fd_pr__pfet_01v8 W=1.4 L=0.15
Xn_129_p2 n_129_x n_25 vdd vdd sky130_fd_pr__pfet_01v8 W=1.4 L=0.15
Xn_129_n1 n_129 n_128 vss vss sky130_fd_pr__nfet_01v8 W=0.42 L=0.15
Xn_129_n2 n_129 n_25 vss vss sky130_fd_pr__nfet_01v8 W=0.42 L=0.15
Xn_130_n n_130 n_129 vss vss sky130_fd_pr__nfet_01v8 W=0.42 L=0.15
Xn_130_p n_130 n_129 vdd vdd sky130_fd_pr__pfet_01v8 W=0.7 L=0.15
Xn_133_p1 n_133 n_127 n_133_x vdd sky130_fd_pr__pfet_01v8 W=1.4 L=0.15
Xn_133_p2 n_133_x n_101 vdd vdd sky130_fd_pr__pfet_01v8 W=1.4 L=0.15
Xn_133_n1 n_133 n_127 vss vss sky130_fd_pr__nfet_01v8 W=0.42 L=0.15
Xn_133_n2 n_133 n_101 vss vss sky130_fd_pr__nfet_01v8 W=0.42 L=0.15
Xn_132_p1 n_132 n_133 n_132_x vdd sky130_fd_pr__pfet_01v8 W=1.4 L=0.15
Xn_132_p2 n_132_x n_131 vdd vdd sky130_fd_pr__pfet_01v8 W=1.4 L=0.15
Xn_132_n1 n_132 n_133 vss vss sky130_fd_pr__nfet_01v8 W=0.42 L=0.15
Xn_132_n2 n_132 n_131 vss vss sky130_fd_pr__nfet_01v8 W=0.42 L=0.15
Xn_131_p1 n_131 n_130 n_131_x vdd sky130_fd_pr__pfet_01v8 W=1.4 L=0.15
Xn_131_p2 n_131_x n_132 vdd vdd sky130_fd_pr__pfet_01v8 W=1.4 L=0.15
Xn_131_n1 n_131 n_130 vss vss sky130_fd_pr__nfet_01v8 W=0.42 L=0.15
Xn_131_n2 n_131 n_132 vss vss sky130_fd_pr__nfet_01v8 W=0.42 L=0.15
Xn_134_p1 n_134 n_131 n_134_x vdd sky130_fd_pr__pfet_01v8 W=1.4 L=0.15
Xn_134_p2 n_134_x n_104 vdd vdd sky130_fd_pr__pfet_01v8 W=1.4 L=0.15
Xn_134_n1 n_134 n_131 vss vss sky130_fd_pr__nfet_01v8 W=0.42 L=0.15
Xn_134_n2 n_134 n_104 vss vss sky130_fd_pr__nfet_01v8 W=0.42 L=0.15
Xn_135_p1 n_135 n_134 n_135_x vdd sky130_fd_pr__pfet_01v8 W=1.4 L=0.15
Xn_135_p2 n_135_x n_25 vdd vdd sky130_fd_pr__pfet_01v8 W=1.4 L=0.15
Xn_135_n1 n_135 n_134 vss vss sky130_fd_pr__nfet_01v8 W=0.42 L=0.15
Xn_135_n2 n_135 n_25 vss vss sky130_fd_pr__nfet_01v8 W=0.42 L=0.15
Xn_136_n n_136 n_135 vss vss sky130_fd_pr__nfet_01v8 W=0.42 L=0.15
Xn_136_p n_136 n_135 vdd vdd sky130_fd_pr__pfet_01v8 W=0.7 L=0.15
Xn_138_p1 n_138 n_132 n_138_x vdd sky130_fd_pr__pfet_01v8 W=1.4 L=0.15
Xn_138_p2 n_138_x n_104 vdd vdd sky130_fd_pr__pfet_01v8 W=1.4 L=0.15
Xn_138_n1 n_138 n_132 vss vss sky130_fd_pr__nfet_01v8 W=0.42 L=0.15
Xn_138_n2 n_138 n_104 vss vss sky130_fd_pr__nfet_01v8 W=0.42 L=0.15
Xn_137_p1 n_137 n_138 n_137_x vdd sky130_fd_pr__pfet_01v8 W=1.4 L=0.15
Xn_137_p2 n_137_x fire vdd vdd sky130_fd_pr__pfet_01v8 W=1.4 L=0.15
Xn_137_n1 n_137 n_138 vss vss sky130_fd_pr__nfet_01v8 W=0.42 L=0.15
Xn_137_n2 n_137 fire vss vss sky130_fd_pr__nfet_01v8 W=0.42 L=0.15
Xfire_p1 fire n_136 fire_x vdd sky130_fd_pr__pfet_01v8 W=1.4 L=0.15
Xfire_p2 fire_x n_137 vdd vdd sky130_fd_pr__pfet_01v8 W=1.4 L=0.15
Xfire_n1 fire n_136 vss vss sky130_fd_pr__nfet_01v8 W=0.42 L=0.15
Xfire_n2 fire n_137 vss vss sky130_fd_pr__nfet_01v8 W=0.42 L=0.15
Xn_139_p1 n_139 fn0 vdd vdd sky130_fd_pr__pfet_01v8 W=0.7 L=0.15
Xn_139_p2 n_139 n_126 vdd vdd sky130_fd_pr__pfet_01v8 W=0.7 L=0.15
Xn_139_n1 n_139 fn0 n_139_x vss sky130_fd_pr__nfet_01v8 W=0.84 L=0.15
Xn_139_n2 n_139_x n_126 vss vss sky130_fd_pr__nfet_01v8 W=0.84 L=0.15
Xn_140_p1 n_140 fn0 vdd vdd sky130_fd_pr__pfet_01v8 W=0.7 L=0.15
Xn_140_p2 n_140 n_139 vdd vdd sky130_fd_pr__pfet_01v8 W=0.7 L=0.15
Xn_140_n1 n_140 fn0 n_140_x vss sky130_fd_pr__nfet_01v8 W=0.84 L=0.15
Xn_140_n2 n_140_x n_139 vss vss sky130_fd_pr__nfet_01v8 W=0.84 L=0.15
Xn_141_p1 n_141 n_126 vdd vdd sky130_fd_pr__pfet_01v8 W=0.7 L=0.15
Xn_141_p2 n_141 n_139 vdd vdd sky130_fd_pr__pfet_01v8 W=0.7 L=0.15
Xn_141_n1 n_141 n_126 n_141_x vss sky130_fd_pr__nfet_01v8 W=0.84 L=0.15
Xn_141_n2 n_141_x n_139 vss vss sky130_fd_pr__nfet_01v8 W=0.84 L=0.15
Xn_142_p1 n_142 n_140 vdd vdd sky130_fd_pr__pfet_01v8 W=0.7 L=0.15
Xn_142_p2 n_142 n_141 vdd vdd sky130_fd_pr__pfet_01v8 W=0.7 L=0.15
Xn_142_n1 n_142 n_140 n_142_x vss sky130_fd_pr__nfet_01v8 W=0.84 L=0.15
Xn_142_n2 n_142_x n_141 vss vss sky130_fd_pr__nfet_01v8 W=0.84 L=0.15
Xn_143_n n_143 n_142 vss vss sky130_fd_pr__nfet_01v8 W=0.42 L=0.15
Xn_143_p n_143 n_142 vdd vdd sky130_fd_pr__pfet_01v8 W=0.7 L=0.15
Xn_144_p1 n_144 n_142 n_144_x vdd sky130_fd_pr__pfet_01v8 W=1.4 L=0.15
Xn_144_p2 n_144_x n_101 vdd vdd sky130_fd_pr__pfet_01v8 W=1.4 L=0.15
Xn_144_n1 n_144 n_142 vss vss sky130_fd_pr__nfet_01v8 W=0.42 L=0.15
Xn_144_n2 n_144 n_101 vss vss sky130_fd_pr__nfet_01v8 W=0.42 L=0.15
Xn_145_p1 n_145 n_144 n_145_x vdd sky130_fd_pr__pfet_01v8 W=1.4 L=0.15
Xn_145_p2 n_145_x n_25 vdd vdd sky130_fd_pr__pfet_01v8 W=1.4 L=0.15
Xn_145_n1 n_145 n_144 vss vss sky130_fd_pr__nfet_01v8 W=0.42 L=0.15
Xn_145_n2 n_145 n_25 vss vss sky130_fd_pr__nfet_01v8 W=0.42 L=0.15
Xn_146_n n_146 n_145 vss vss sky130_fd_pr__nfet_01v8 W=0.42 L=0.15
Xn_146_p n_146 n_145 vdd vdd sky130_fd_pr__pfet_01v8 W=0.7 L=0.15
Xn_149_p1 n_149 n_143 n_149_x vdd sky130_fd_pr__pfet_01v8 W=1.4 L=0.15
Xn_149_p2 n_149_x n_101 vdd vdd sky130_fd_pr__pfet_01v8 W=1.4 L=0.15
Xn_149_n1 n_149 n_143 vss vss sky130_fd_pr__nfet_01v8 W=0.42 L=0.15
Xn_149_n2 n_149 n_101 vss vss sky130_fd_pr__nfet_01v8 W=0.42 L=0.15
Xn_148_p1 n_148 n_149 n_148_x vdd sky130_fd_pr__pfet_01v8 W=1.4 L=0.15
Xn_148_p2 n_148_x n_147 vdd vdd sky130_fd_pr__pfet_01v8 W=1.4 L=0.15
Xn_148_n1 n_148 n_149 vss vss sky130_fd_pr__nfet_01v8 W=0.42 L=0.15
Xn_148_n2 n_148 n_147 vss vss sky130_fd_pr__nfet_01v8 W=0.42 L=0.15
Xn_147_p1 n_147 n_146 n_147_x vdd sky130_fd_pr__pfet_01v8 W=1.4 L=0.15
Xn_147_p2 n_147_x n_148 vdd vdd sky130_fd_pr__pfet_01v8 W=1.4 L=0.15
Xn_147_n1 n_147 n_146 vss vss sky130_fd_pr__nfet_01v8 W=0.42 L=0.15
Xn_147_n2 n_147 n_148 vss vss sky130_fd_pr__nfet_01v8 W=0.42 L=0.15
Xn_150_p1 n_150 n_147 n_150_x vdd sky130_fd_pr__pfet_01v8 W=1.4 L=0.15
Xn_150_p2 n_150_x n_104 vdd vdd sky130_fd_pr__pfet_01v8 W=1.4 L=0.15
Xn_150_n1 n_150 n_147 vss vss sky130_fd_pr__nfet_01v8 W=0.42 L=0.15
Xn_150_n2 n_150 n_104 vss vss sky130_fd_pr__nfet_01v8 W=0.42 L=0.15
Xn_151_p1 n_151 n_150 n_151_x vdd sky130_fd_pr__pfet_01v8 W=1.4 L=0.15
Xn_151_p2 n_151_x n_25 vdd vdd sky130_fd_pr__pfet_01v8 W=1.4 L=0.15
Xn_151_n1 n_151 n_150 vss vss sky130_fd_pr__nfet_01v8 W=0.42 L=0.15
Xn_151_n2 n_151 n_25 vss vss sky130_fd_pr__nfet_01v8 W=0.42 L=0.15
Xn_152_n n_152 n_151 vss vss sky130_fd_pr__nfet_01v8 W=0.42 L=0.15
Xn_152_p n_152 n_151 vdd vdd sky130_fd_pr__pfet_01v8 W=0.7 L=0.15
Xn_154_p1 n_154 n_148 n_154_x vdd sky130_fd_pr__pfet_01v8 W=1.4 L=0.15
Xn_154_p2 n_154_x n_104 vdd vdd sky130_fd_pr__pfet_01v8 W=1.4 L=0.15
Xn_154_n1 n_154 n_148 vss vss sky130_fd_pr__nfet_01v8 W=0.42 L=0.15
Xn_154_n2 n_154 n_104 vss vss sky130_fd_pr__nfet_01v8 W=0.42 L=0.15
Xn_153_p1 n_153 n_154 n_153_x vdd sky130_fd_pr__pfet_01v8 W=1.4 L=0.15
Xn_153_p2 n_153_x fn0 vdd vdd sky130_fd_pr__pfet_01v8 W=1.4 L=0.15
Xn_153_n1 n_153 n_154 vss vss sky130_fd_pr__nfet_01v8 W=0.42 L=0.15
Xn_153_n2 n_153 fn0 vss vss sky130_fd_pr__nfet_01v8 W=0.42 L=0.15
Xfn0_p1 fn0 n_152 fn0_x vdd sky130_fd_pr__pfet_01v8 W=1.4 L=0.15
Xfn0_p2 fn0_x n_153 vdd vdd sky130_fd_pr__pfet_01v8 W=1.4 L=0.15
Xfn0_n1 fn0 n_152 vss vss sky130_fd_pr__nfet_01v8 W=0.42 L=0.15
Xfn0_n2 fn0 n_153 vss vss sky130_fd_pr__nfet_01v8 W=0.42 L=0.15
Xn_155_p1 n_155 fn0 vdd vdd sky130_fd_pr__pfet_01v8 W=0.7 L=0.15
Xn_155_p2 n_155 n_126 vdd vdd sky130_fd_pr__pfet_01v8 W=0.7 L=0.15
Xn_155_n1 n_155 fn0 n_155_x vss sky130_fd_pr__nfet_01v8 W=0.84 L=0.15
Xn_155_n2 n_155_x n_126 vss vss sky130_fd_pr__nfet_01v8 W=0.84 L=0.15
Xn_156_n n_156 n_155 vss vss sky130_fd_pr__nfet_01v8 W=0.42 L=0.15
Xn_156_p n_156 n_155 vdd vdd sky130_fd_pr__pfet_01v8 W=0.7 L=0.15
Xn_157_p1 n_157 fn1 vdd vdd sky130_fd_pr__pfet_01v8 W=0.7 L=0.15
Xn_157_p2 n_157 n_156 vdd vdd sky130_fd_pr__pfet_01v8 W=0.7 L=0.15
Xn_157_n1 n_157 fn1 n_157_x vss sky130_fd_pr__nfet_01v8 W=0.84 L=0.15
Xn_157_n2 n_157_x n_156 vss vss sky130_fd_pr__nfet_01v8 W=0.84 L=0.15
Xn_158_p1 n_158 fn1 vdd vdd sky130_fd_pr__pfet_01v8 W=0.7 L=0.15
Xn_158_p2 n_158 n_157 vdd vdd sky130_fd_pr__pfet_01v8 W=0.7 L=0.15
Xn_158_n1 n_158 fn1 n_158_x vss sky130_fd_pr__nfet_01v8 W=0.84 L=0.15
Xn_158_n2 n_158_x n_157 vss vss sky130_fd_pr__nfet_01v8 W=0.84 L=0.15
Xn_159_p1 n_159 n_156 vdd vdd sky130_fd_pr__pfet_01v8 W=0.7 L=0.15
Xn_159_p2 n_159 n_157 vdd vdd sky130_fd_pr__pfet_01v8 W=0.7 L=0.15
Xn_159_n1 n_159 n_156 n_159_x vss sky130_fd_pr__nfet_01v8 W=0.84 L=0.15
Xn_159_n2 n_159_x n_157 vss vss sky130_fd_pr__nfet_01v8 W=0.84 L=0.15
Xn_160_p1 n_160 n_158 vdd vdd sky130_fd_pr__pfet_01v8 W=0.7 L=0.15
Xn_160_p2 n_160 n_159 vdd vdd sky130_fd_pr__pfet_01v8 W=0.7 L=0.15
Xn_160_n1 n_160 n_158 n_160_x vss sky130_fd_pr__nfet_01v8 W=0.84 L=0.15
Xn_160_n2 n_160_x n_159 vss vss sky130_fd_pr__nfet_01v8 W=0.84 L=0.15
Xn_161_n n_161 n_160 vss vss sky130_fd_pr__nfet_01v8 W=0.42 L=0.15
Xn_161_p n_161 n_160 vdd vdd sky130_fd_pr__pfet_01v8 W=0.7 L=0.15
Xn_162_p1 n_162 n_160 n_162_x vdd sky130_fd_pr__pfet_01v8 W=1.4 L=0.15
Xn_162_p2 n_162_x n_101 vdd vdd sky130_fd_pr__pfet_01v8 W=1.4 L=0.15
Xn_162_n1 n_162 n_160 vss vss sky130_fd_pr__nfet_01v8 W=0.42 L=0.15
Xn_162_n2 n_162 n_101 vss vss sky130_fd_pr__nfet_01v8 W=0.42 L=0.15
Xn_163_p1 n_163 n_162 n_163_x vdd sky130_fd_pr__pfet_01v8 W=1.4 L=0.15
Xn_163_p2 n_163_x n_25 vdd vdd sky130_fd_pr__pfet_01v8 W=1.4 L=0.15
Xn_163_n1 n_163 n_162 vss vss sky130_fd_pr__nfet_01v8 W=0.42 L=0.15
Xn_163_n2 n_163 n_25 vss vss sky130_fd_pr__nfet_01v8 W=0.42 L=0.15
Xn_164_n n_164 n_163 vss vss sky130_fd_pr__nfet_01v8 W=0.42 L=0.15
Xn_164_p n_164 n_163 vdd vdd sky130_fd_pr__pfet_01v8 W=0.7 L=0.15
Xn_167_p1 n_167 n_161 n_167_x vdd sky130_fd_pr__pfet_01v8 W=1.4 L=0.15
Xn_167_p2 n_167_x n_101 vdd vdd sky130_fd_pr__pfet_01v8 W=1.4 L=0.15
Xn_167_n1 n_167 n_161 vss vss sky130_fd_pr__nfet_01v8 W=0.42 L=0.15
Xn_167_n2 n_167 n_101 vss vss sky130_fd_pr__nfet_01v8 W=0.42 L=0.15
Xn_166_p1 n_166 n_167 n_166_x vdd sky130_fd_pr__pfet_01v8 W=1.4 L=0.15
Xn_166_p2 n_166_x n_165 vdd vdd sky130_fd_pr__pfet_01v8 W=1.4 L=0.15
Xn_166_n1 n_166 n_167 vss vss sky130_fd_pr__nfet_01v8 W=0.42 L=0.15
Xn_166_n2 n_166 n_165 vss vss sky130_fd_pr__nfet_01v8 W=0.42 L=0.15
Xn_165_p1 n_165 n_164 n_165_x vdd sky130_fd_pr__pfet_01v8 W=1.4 L=0.15
Xn_165_p2 n_165_x n_166 vdd vdd sky130_fd_pr__pfet_01v8 W=1.4 L=0.15
Xn_165_n1 n_165 n_164 vss vss sky130_fd_pr__nfet_01v8 W=0.42 L=0.15
Xn_165_n2 n_165 n_166 vss vss sky130_fd_pr__nfet_01v8 W=0.42 L=0.15
Xn_168_p1 n_168 n_165 n_168_x vdd sky130_fd_pr__pfet_01v8 W=1.4 L=0.15
Xn_168_p2 n_168_x n_104 vdd vdd sky130_fd_pr__pfet_01v8 W=1.4 L=0.15
Xn_168_n1 n_168 n_165 vss vss sky130_fd_pr__nfet_01v8 W=0.42 L=0.15
Xn_168_n2 n_168 n_104 vss vss sky130_fd_pr__nfet_01v8 W=0.42 L=0.15
Xn_169_p1 n_169 n_168 n_169_x vdd sky130_fd_pr__pfet_01v8 W=1.4 L=0.15
Xn_169_p2 n_169_x n_25 vdd vdd sky130_fd_pr__pfet_01v8 W=1.4 L=0.15
Xn_169_n1 n_169 n_168 vss vss sky130_fd_pr__nfet_01v8 W=0.42 L=0.15
Xn_169_n2 n_169 n_25 vss vss sky130_fd_pr__nfet_01v8 W=0.42 L=0.15
Xn_170_n n_170 n_169 vss vss sky130_fd_pr__nfet_01v8 W=0.42 L=0.15
Xn_170_p n_170 n_169 vdd vdd sky130_fd_pr__pfet_01v8 W=0.7 L=0.15
Xn_172_p1 n_172 n_166 n_172_x vdd sky130_fd_pr__pfet_01v8 W=1.4 L=0.15
Xn_172_p2 n_172_x n_104 vdd vdd sky130_fd_pr__pfet_01v8 W=1.4 L=0.15
Xn_172_n1 n_172 n_166 vss vss sky130_fd_pr__nfet_01v8 W=0.42 L=0.15
Xn_172_n2 n_172 n_104 vss vss sky130_fd_pr__nfet_01v8 W=0.42 L=0.15
Xn_171_p1 n_171 n_172 n_171_x vdd sky130_fd_pr__pfet_01v8 W=1.4 L=0.15
Xn_171_p2 n_171_x fn1 vdd vdd sky130_fd_pr__pfet_01v8 W=1.4 L=0.15
Xn_171_n1 n_171 n_172 vss vss sky130_fd_pr__nfet_01v8 W=0.42 L=0.15
Xn_171_n2 n_171 fn1 vss vss sky130_fd_pr__nfet_01v8 W=0.42 L=0.15
Xfn1_p1 fn1 n_170 fn1_x vdd sky130_fd_pr__pfet_01v8 W=1.4 L=0.15
Xfn1_p2 fn1_x n_171 vdd vdd sky130_fd_pr__pfet_01v8 W=1.4 L=0.15
Xfn1_n1 fn1 n_170 vss vss sky130_fd_pr__nfet_01v8 W=0.42 L=0.15
Xfn1_n2 fn1 n_171 vss vss sky130_fd_pr__nfet_01v8 W=0.42 L=0.15
Xn_173_p1 n_173 fn1 vdd vdd sky130_fd_pr__pfet_01v8 W=0.7 L=0.15
Xn_173_p2 n_173 n_156 vdd vdd sky130_fd_pr__pfet_01v8 W=0.7 L=0.15
Xn_173_n1 n_173 fn1 n_173_x vss sky130_fd_pr__nfet_01v8 W=0.84 L=0.15
Xn_173_n2 n_173_x n_156 vss vss sky130_fd_pr__nfet_01v8 W=0.84 L=0.15
Xn_174_n n_174 n_173 vss vss sky130_fd_pr__nfet_01v8 W=0.42 L=0.15
Xn_174_p n_174 n_173 vdd vdd sky130_fd_pr__pfet_01v8 W=0.7 L=0.15
Xn_175_p1 n_175 fn2 vdd vdd sky130_fd_pr__pfet_01v8 W=0.7 L=0.15
Xn_175_p2 n_175 n_174 vdd vdd sky130_fd_pr__pfet_01v8 W=0.7 L=0.15
Xn_175_n1 n_175 fn2 n_175_x vss sky130_fd_pr__nfet_01v8 W=0.84 L=0.15
Xn_175_n2 n_175_x n_174 vss vss sky130_fd_pr__nfet_01v8 W=0.84 L=0.15
Xn_176_p1 n_176 fn2 vdd vdd sky130_fd_pr__pfet_01v8 W=0.7 L=0.15
Xn_176_p2 n_176 n_175 vdd vdd sky130_fd_pr__pfet_01v8 W=0.7 L=0.15
Xn_176_n1 n_176 fn2 n_176_x vss sky130_fd_pr__nfet_01v8 W=0.84 L=0.15
Xn_176_n2 n_176_x n_175 vss vss sky130_fd_pr__nfet_01v8 W=0.84 L=0.15
Xn_177_p1 n_177 n_174 vdd vdd sky130_fd_pr__pfet_01v8 W=0.7 L=0.15
Xn_177_p2 n_177 n_175 vdd vdd sky130_fd_pr__pfet_01v8 W=0.7 L=0.15
Xn_177_n1 n_177 n_174 n_177_x vss sky130_fd_pr__nfet_01v8 W=0.84 L=0.15
Xn_177_n2 n_177_x n_175 vss vss sky130_fd_pr__nfet_01v8 W=0.84 L=0.15
Xn_178_p1 n_178 n_176 vdd vdd sky130_fd_pr__pfet_01v8 W=0.7 L=0.15
Xn_178_p2 n_178 n_177 vdd vdd sky130_fd_pr__pfet_01v8 W=0.7 L=0.15
Xn_178_n1 n_178 n_176 n_178_x vss sky130_fd_pr__nfet_01v8 W=0.84 L=0.15
Xn_178_n2 n_178_x n_177 vss vss sky130_fd_pr__nfet_01v8 W=0.84 L=0.15
Xn_179_n n_179 n_178 vss vss sky130_fd_pr__nfet_01v8 W=0.42 L=0.15
Xn_179_p n_179 n_178 vdd vdd sky130_fd_pr__pfet_01v8 W=0.7 L=0.15
Xn_180_p1 n_180 n_178 n_180_x vdd sky130_fd_pr__pfet_01v8 W=1.4 L=0.15
Xn_180_p2 n_180_x n_101 vdd vdd sky130_fd_pr__pfet_01v8 W=1.4 L=0.15
Xn_180_n1 n_180 n_178 vss vss sky130_fd_pr__nfet_01v8 W=0.42 L=0.15
Xn_180_n2 n_180 n_101 vss vss sky130_fd_pr__nfet_01v8 W=0.42 L=0.15
Xn_181_p1 n_181 n_180 n_181_x vdd sky130_fd_pr__pfet_01v8 W=1.4 L=0.15
Xn_181_p2 n_181_x n_25 vdd vdd sky130_fd_pr__pfet_01v8 W=1.4 L=0.15
Xn_181_n1 n_181 n_180 vss vss sky130_fd_pr__nfet_01v8 W=0.42 L=0.15
Xn_181_n2 n_181 n_25 vss vss sky130_fd_pr__nfet_01v8 W=0.42 L=0.15
Xn_182_n n_182 n_181 vss vss sky130_fd_pr__nfet_01v8 W=0.42 L=0.15
Xn_182_p n_182 n_181 vdd vdd sky130_fd_pr__pfet_01v8 W=0.7 L=0.15
Xn_185_p1 n_185 n_179 n_185_x vdd sky130_fd_pr__pfet_01v8 W=1.4 L=0.15
Xn_185_p2 n_185_x n_101 vdd vdd sky130_fd_pr__pfet_01v8 W=1.4 L=0.15
Xn_185_n1 n_185 n_179 vss vss sky130_fd_pr__nfet_01v8 W=0.42 L=0.15
Xn_185_n2 n_185 n_101 vss vss sky130_fd_pr__nfet_01v8 W=0.42 L=0.15
Xn_184_p1 n_184 n_185 n_184_x vdd sky130_fd_pr__pfet_01v8 W=1.4 L=0.15
Xn_184_p2 n_184_x n_183 vdd vdd sky130_fd_pr__pfet_01v8 W=1.4 L=0.15
Xn_184_n1 n_184 n_185 vss vss sky130_fd_pr__nfet_01v8 W=0.42 L=0.15
Xn_184_n2 n_184 n_183 vss vss sky130_fd_pr__nfet_01v8 W=0.42 L=0.15
Xn_183_p1 n_183 n_182 n_183_x vdd sky130_fd_pr__pfet_01v8 W=1.4 L=0.15
Xn_183_p2 n_183_x n_184 vdd vdd sky130_fd_pr__pfet_01v8 W=1.4 L=0.15
Xn_183_n1 n_183 n_182 vss vss sky130_fd_pr__nfet_01v8 W=0.42 L=0.15
Xn_183_n2 n_183 n_184 vss vss sky130_fd_pr__nfet_01v8 W=0.42 L=0.15
Xn_186_p1 n_186 n_183 n_186_x vdd sky130_fd_pr__pfet_01v8 W=1.4 L=0.15
Xn_186_p2 n_186_x n_104 vdd vdd sky130_fd_pr__pfet_01v8 W=1.4 L=0.15
Xn_186_n1 n_186 n_183 vss vss sky130_fd_pr__nfet_01v8 W=0.42 L=0.15
Xn_186_n2 n_186 n_104 vss vss sky130_fd_pr__nfet_01v8 W=0.42 L=0.15
Xn_187_p1 n_187 n_186 n_187_x vdd sky130_fd_pr__pfet_01v8 W=1.4 L=0.15
Xn_187_p2 n_187_x n_25 vdd vdd sky130_fd_pr__pfet_01v8 W=1.4 L=0.15
Xn_187_n1 n_187 n_186 vss vss sky130_fd_pr__nfet_01v8 W=0.42 L=0.15
Xn_187_n2 n_187 n_25 vss vss sky130_fd_pr__nfet_01v8 W=0.42 L=0.15
Xn_188_n n_188 n_187 vss vss sky130_fd_pr__nfet_01v8 W=0.42 L=0.15
Xn_188_p n_188 n_187 vdd vdd sky130_fd_pr__pfet_01v8 W=0.7 L=0.15
Xn_190_p1 n_190 n_184 n_190_x vdd sky130_fd_pr__pfet_01v8 W=1.4 L=0.15
Xn_190_p2 n_190_x n_104 vdd vdd sky130_fd_pr__pfet_01v8 W=1.4 L=0.15
Xn_190_n1 n_190 n_184 vss vss sky130_fd_pr__nfet_01v8 W=0.42 L=0.15
Xn_190_n2 n_190 n_104 vss vss sky130_fd_pr__nfet_01v8 W=0.42 L=0.15
Xn_189_p1 n_189 n_190 n_189_x vdd sky130_fd_pr__pfet_01v8 W=1.4 L=0.15
Xn_189_p2 n_189_x fn2 vdd vdd sky130_fd_pr__pfet_01v8 W=1.4 L=0.15
Xn_189_n1 n_189 n_190 vss vss sky130_fd_pr__nfet_01v8 W=0.42 L=0.15
Xn_189_n2 n_189 fn2 vss vss sky130_fd_pr__nfet_01v8 W=0.42 L=0.15
Xfn2_p1 fn2 n_188 fn2_x vdd sky130_fd_pr__pfet_01v8 W=1.4 L=0.15
Xfn2_p2 fn2_x n_189 vdd vdd sky130_fd_pr__pfet_01v8 W=1.4 L=0.15
Xfn2_n1 fn2 n_188 vss vss sky130_fd_pr__nfet_01v8 W=0.42 L=0.15
Xfn2_n2 fn2 n_189 vss vss sky130_fd_pr__nfet_01v8 W=0.42 L=0.15
Xn_191_n n_191 n_124 vss vss sky130_fd_pr__nfet_01v8 W=0.42 L=0.15
Xn_191_p n_191 n_124 vdd vdd sky130_fd_pr__pfet_01v8 W=0.7 L=0.15
Xn_192_p1 n_192 n_94 vdd vdd sky130_fd_pr__pfet_01v8 W=0.7 L=0.15
Xn_192_p2 n_192 n_191 vdd vdd sky130_fd_pr__pfet_01v8 W=0.7 L=0.15
Xn_192_n1 n_192 n_94 n_192_x vss sky130_fd_pr__nfet_01v8 W=0.84 L=0.15
Xn_192_n2 n_192_x n_191 vss vss sky130_fd_pr__nfet_01v8 W=0.84 L=0.15
Xn_193_n n_193 n_192 vss vss sky130_fd_pr__nfet_01v8 W=0.42 L=0.15
Xn_193_p n_193 n_192 vdd vdd sky130_fd_pr__pfet_01v8 W=0.7 L=0.15
Xn_194_p1 n_194 cb_ack vdd vdd sky130_fd_pr__pfet_01v8 W=0.7 L=0.15
Xn_194_p2 n_194 n_90 vdd vdd sky130_fd_pr__pfet_01v8 W=0.7 L=0.15
Xn_194_n1 n_194 cb_ack n_194_x vss sky130_fd_pr__nfet_01v8 W=0.84 L=0.15
Xn_194_n2 n_194_x n_90 vss vss sky130_fd_pr__nfet_01v8 W=0.84 L=0.15
Xn_195_n n_195 n_194 vss vss sky130_fd_pr__nfet_01v8 W=0.42 L=0.15
Xn_195_p n_195 n_194 vdd vdd sky130_fd_pr__pfet_01v8 W=0.7 L=0.15
Xn_196_p1 n_196 n_195 n_196_x vdd sky130_fd_pr__pfet_01v8 W=1.4 L=0.15
Xn_196_p2 n_196_x n_193 vdd vdd sky130_fd_pr__pfet_01v8 W=1.4 L=0.15
Xn_196_n1 n_196 n_195 vss vss sky130_fd_pr__nfet_01v8 W=0.42 L=0.15
Xn_196_n2 n_196 n_193 vss vss sky130_fd_pr__nfet_01v8 W=0.42 L=0.15
Xn_197_n n_197 n_196 vss vss sky130_fd_pr__nfet_01v8 W=0.42 L=0.15
Xn_197_p n_197 n_196 vdd vdd sky130_fd_pr__pfet_01v8 W=0.7 L=0.15
Xn_198_p1 n_198 c_got vdd vdd sky130_fd_pr__pfet_01v8 W=0.7 L=0.15
Xn_198_p2 n_198 n_197 vdd vdd sky130_fd_pr__pfet_01v8 W=0.7 L=0.15
Xn_198_n1 n_198 c_got n_198_x vss sky130_fd_pr__nfet_01v8 W=0.84 L=0.15
Xn_198_n2 n_198_x n_197 vss vss sky130_fd_pr__nfet_01v8 W=0.84 L=0.15
Xn_199_n n_199 n_198 vss vss sky130_fd_pr__nfet_01v8 W=0.42 L=0.15
Xn_199_p n_199 n_198 vdd vdd sky130_fd_pr__pfet_01v8 W=0.7 L=0.15
Xn_201_p1 n_201 n_199 n_201_x vdd sky130_fd_pr__pfet_01v8 W=1.4 L=0.15
Xn_201_p2 n_201_x n_200 vdd vdd sky130_fd_pr__pfet_01v8 W=1.4 L=0.15
Xn_201_n1 n_201 n_199 vss vss sky130_fd_pr__nfet_01v8 W=0.42 L=0.15
Xn_201_n2 n_201 n_200 vss vss sky130_fd_pr__nfet_01v8 W=0.42 L=0.15
Xn_200_p1 n_200 n_89 n_200_x vdd sky130_fd_pr__pfet_01v8 W=1.4 L=0.15
Xn_200_p2 n_200_x n_201 vdd vdd sky130_fd_pr__pfet_01v8 W=1.4 L=0.15
Xn_200_n1 n_200 n_89 vss vss sky130_fd_pr__nfet_01v8 W=0.42 L=0.15
Xn_200_n2 n_200 n_201 vss vss sky130_fd_pr__nfet_01v8 W=0.42 L=0.15
Xcb_req_p1 cb_req n_89 cb_req_x vdd sky130_fd_pr__pfet_01v8 W=1.4 L=0.15
Xcb_req_p2 cb_req_x n_200 vdd vdd sky130_fd_pr__pfet_01v8 W=1.4 L=0.15
Xcb_req_n1 cb_req n_89 vss vss sky130_fd_pr__nfet_01v8 W=0.42 L=0.15
Xcb_req_n2 cb_req n_200 vss vss sky130_fd_pr__nfet_01v8 W=0.42 L=0.15
Xn_202_p1 n_202 cb_ack vdd vdd sky130_fd_pr__pfet_01v8 W=0.7 L=0.15
Xn_202_p2 n_202 c_got vdd vdd sky130_fd_pr__pfet_01v8 W=0.7 L=0.15
Xn_202_n1 n_202 cb_ack n_202_x vss sky130_fd_pr__nfet_01v8 W=0.84 L=0.15
Xn_202_n2 n_202_x c_got vss vss sky130_fd_pr__nfet_01v8 W=0.84 L=0.15
Xn_203_n n_203 n_202 vss vss sky130_fd_pr__nfet_01v8 W=0.42 L=0.15
Xn_203_p n_203 n_202 vdd vdd sky130_fd_pr__pfet_01v8 W=0.7 L=0.15
Xn_204_p1 n_204 n_203 vdd vdd sky130_fd_pr__pfet_01v8 W=0.7 L=0.15
Xn_204_p2 n_204 n_90 vdd vdd sky130_fd_pr__pfet_01v8 W=0.7 L=0.15
Xn_204_n1 n_204 n_203 n_204_x vss sky130_fd_pr__nfet_01v8 W=0.84 L=0.15
Xn_204_n2 n_204_x n_90 vss vss sky130_fd_pr__nfet_01v8 W=0.84 L=0.15
Xn_205_n n_205 n_204 vss vss sky130_fd_pr__nfet_01v8 W=0.42 L=0.15
Xn_205_p n_205 n_204 vdd vdd sky130_fd_pr__pfet_01v8 W=0.7 L=0.15
Xn_206_n n_206 coarse_en vss vss sky130_fd_pr__nfet_01v8 W=0.42 L=0.15
Xn_206_p n_206 coarse_en vdd vdd sky130_fd_pr__pfet_01v8 W=0.7 L=0.15
Xn_207_p1 n_207 n_30 vdd vdd sky130_fd_pr__pfet_01v8 W=0.7 L=0.15
Xn_207_p2 n_207 n_206 vdd vdd sky130_fd_pr__pfet_01v8 W=0.7 L=0.15
Xn_207_n1 n_207 n_30 n_207_x vss sky130_fd_pr__nfet_01v8 W=0.84 L=0.15
Xn_207_n2 n_207_x n_206 vss vss sky130_fd_pr__nfet_01v8 W=0.84 L=0.15
Xn_208_n n_208 n_207 vss vss sky130_fd_pr__nfet_01v8 W=0.42 L=0.15
Xn_208_p n_208 n_207 vdd vdd sky130_fd_pr__pfet_01v8 W=0.7 L=0.15
Xn_209_p1 n_209 n_205 n_209_x vdd sky130_fd_pr__pfet_01v8 W=1.4 L=0.15
Xn_209_p2 n_209_x n_208 vdd vdd sky130_fd_pr__pfet_01v8 W=1.4 L=0.15
Xn_209_n1 n_209 n_205 vss vss sky130_fd_pr__nfet_01v8 W=0.42 L=0.15
Xn_209_n2 n_209 n_208 vss vss sky130_fd_pr__nfet_01v8 W=0.42 L=0.15
Xn_210_n n_210 n_209 vss vss sky130_fd_pr__nfet_01v8 W=0.42 L=0.15
Xn_210_p n_210 n_209 vdd vdd sky130_fd_pr__pfet_01v8 W=0.7 L=0.15
Xn_211_p1 n_211 n_1 n_211_x vdd sky130_fd_pr__pfet_01v8 W=1.4 L=0.15
Xn_211_p2 n_211_x n_210 vdd vdd sky130_fd_pr__pfet_01v8 W=1.4 L=0.15
Xn_211_n1 n_211 n_1 vss vss sky130_fd_pr__nfet_01v8 W=0.42 L=0.15
Xn_211_n2 n_211 n_210 vss vss sky130_fd_pr__nfet_01v8 W=0.42 L=0.15
Xn_212_n n_212 n_211 vss vss sky130_fd_pr__nfet_01v8 W=0.42 L=0.15
Xn_212_p n_212 n_211 vdd vdd sky130_fd_pr__pfet_01v8 W=0.7 L=0.15
Xn_213_p1 n_213 n_40 n_213_x vdd sky130_fd_pr__pfet_01v8 W=1.4 L=0.15
Xn_213_p2 n_213_x run vdd vdd sky130_fd_pr__pfet_01v8 W=1.4 L=0.15
Xn_213_n1 n_213 n_40 vss vss sky130_fd_pr__nfet_01v8 W=0.42 L=0.15
Xn_213_n2 n_213 run vss vss sky130_fd_pr__nfet_01v8 W=0.42 L=0.15
Xrun_p1 run n_212 run_x vdd sky130_fd_pr__pfet_01v8 W=1.4 L=0.15
Xrun_p2 run_x n_213 vdd vdd sky130_fd_pr__pfet_01v8 W=1.4 L=0.15
Xrun_n1 run n_212 vss vss sky130_fd_pr__nfet_01v8 W=0.42 L=0.15
Xrun_n2 run n_213 vss vss sky130_fd_pr__nfet_01v8 W=0.42 L=0.15
Xn_215_p1 n_215 cmp_ack n_215_x vdd sky130_fd_pr__pfet_01v8 W=1.4 L=0.15
Xn_215_p2 n_215_x n_214 vdd vdd sky130_fd_pr__pfet_01v8 W=1.4 L=0.15
Xn_215_n1 n_215 cmp_ack vss vss sky130_fd_pr__nfet_01v8 W=0.42 L=0.15
Xn_215_n2 n_215 n_214 vss vss sky130_fd_pr__nfet_01v8 W=0.42 L=0.15
Xn_214_p1 n_214 n_1 n_214_x vdd sky130_fd_pr__pfet_01v8 W=1.4 L=0.15
Xn_214_p2 n_214_x n_215 vdd vdd sky130_fd_pr__pfet_01v8 W=1.4 L=0.15
Xn_214_n1 n_214 n_1 vss vss sky130_fd_pr__nfet_01v8 W=0.42 L=0.15
Xn_214_n2 n_214 n_215 vss vss sky130_fd_pr__nfet_01v8 W=0.42 L=0.15
Xn_218_n n_218 n_214 vss vss sky130_fd_pr__nfet_01v8 W=0.42 L=0.15
Xn_218_p n_218 n_214 vdd vdd sky130_fd_pr__pfet_01v8 W=0.7 L=0.15
Xn_219_p1 n_219 n_214 vdd vdd sky130_fd_pr__pfet_01v8 W=0.7 L=0.15
Xn_219_p2 n_219 n_216 vdd vdd sky130_fd_pr__pfet_01v8 W=0.7 L=0.15
Xn_219_n1 n_219 n_214 n_219_x vss sky130_fd_pr__nfet_01v8 W=0.84 L=0.15
Xn_219_n2 n_219_x n_216 vss vss sky130_fd_pr__nfet_01v8 W=0.84 L=0.15
Xn_220_p1 n_220 n_218 vdd vdd sky130_fd_pr__pfet_01v8 W=0.7 L=0.15
Xn_220_p2 n_220 n_217 vdd vdd sky130_fd_pr__pfet_01v8 W=0.7 L=0.15
Xn_220_n1 n_220 n_218 n_220_x vss sky130_fd_pr__nfet_01v8 W=0.84 L=0.15
Xn_220_n2 n_220_x n_217 vss vss sky130_fd_pr__nfet_01v8 W=0.84 L=0.15
Xn_221_p1 n_221 n_219 vdd vdd sky130_fd_pr__pfet_01v8 W=0.7 L=0.15
Xn_221_p2 n_221 n_220 vdd vdd sky130_fd_pr__pfet_01v8 W=0.7 L=0.15
Xn_221_n1 n_221 n_219 n_221_x vss sky130_fd_pr__nfet_01v8 W=0.84 L=0.15
Xn_221_n2 n_221_x n_220 vss vss sky130_fd_pr__nfet_01v8 W=0.84 L=0.15
Xn_222_p1 n_222 cmp_req vdd vdd sky130_fd_pr__pfet_01v8 W=0.7 L=0.15
Xn_222_p2 n_222 n_221 vdd vdd sky130_fd_pr__pfet_01v8 W=0.7 L=0.15
Xn_222_n1 n_222 cmp_req n_222_x vss sky130_fd_pr__nfet_01v8 W=0.84 L=0.15
Xn_222_n2 n_222_x n_221 vss vss sky130_fd_pr__nfet_01v8 W=0.84 L=0.15
Xn_223_n n_223 n_222 vss vss sky130_fd_pr__nfet_01v8 W=0.42 L=0.15
Xn_223_p n_223 n_222 vdd vdd sky130_fd_pr__pfet_01v8 W=0.7 L=0.15
Xn_224_n n_224 cmp_req vss vss sky130_fd_pr__nfet_01v8 W=0.42 L=0.15
Xn_224_p n_224 cmp_req vdd vdd sky130_fd_pr__pfet_01v8 W=0.7 L=0.15
Xacq_p1 acq n_224 acq_x vdd sky130_fd_pr__pfet_01v8 W=1.4 L=0.15
Xacq_p2 acq_x n_223 vdd vdd sky130_fd_pr__pfet_01v8 W=1.4 L=0.15
Xacq_n1 acq n_224 vss vss sky130_fd_pr__nfet_01v8 W=0.42 L=0.15
Xacq_n2 acq n_223 vss vss sky130_fd_pr__nfet_01v8 W=0.42 L=0.15
Xn_226_p1 n_226 n_223 vdd vdd sky130_fd_pr__pfet_01v8 W=0.7 L=0.15
Xn_226_p2 n_226 n_225 vdd vdd sky130_fd_pr__pfet_01v8 W=0.7 L=0.15
Xn_226_n1 n_226 n_223 n_226_x vss sky130_fd_pr__nfet_01v8 W=0.84 L=0.15
Xn_226_n2 n_226_x n_225 vss vss sky130_fd_pr__nfet_01v8 W=0.84 L=0.15
Xn_227_n n_227 n_226 vss vss sky130_fd_pr__nfet_01v8 W=0.42 L=0.15
Xn_227_p n_227 n_226 vdd vdd sky130_fd_pr__pfet_01v8 W=0.7 L=0.15
Xn_228_n n_228 c2n vss vss sky130_fd_pr__nfet_01v8 W=0.42 L=0.15
Xn_228_p n_228 c2n vdd vdd sky130_fd_pr__pfet_01v8 W=0.7 L=0.15
Xn_229_p1 n_229 c2p n_229_x vdd sky130_fd_pr__pfet_01v8 W=1.4 L=0.15
Xn_229_p2 n_229_x n_228 vdd vdd sky130_fd_pr__pfet_01v8 W=1.4 L=0.15
Xn_229_n1 n_229 c2p vss vss sky130_fd_pr__nfet_01v8 W=0.42 L=0.15
Xn_229_n2 n_229 n_228 vss vss sky130_fd_pr__nfet_01v8 W=0.42 L=0.15
Xn_230_n n_230 c2p vss vss sky130_fd_pr__nfet_01v8 W=0.42 L=0.15
Xn_230_p n_230 c2p vdd vdd sky130_fd_pr__pfet_01v8 W=0.7 L=0.15
Xn_231_p1 n_231 c2n n_231_x vdd sky130_fd_pr__pfet_01v8 W=1.4 L=0.15
Xn_231_p2 n_231_x n_230 vdd vdd sky130_fd_pr__pfet_01v8 W=1.4 L=0.15
Xn_231_n1 n_231 c2n vss vss sky130_fd_pr__nfet_01v8 W=0.42 L=0.15
Xn_231_n2 n_231 n_230 vss vss sky130_fd_pr__nfet_01v8 W=0.42 L=0.15
Xn_232_p1 n_232 n_229 n_232_x vdd sky130_fd_pr__pfet_01v8 W=1.4 L=0.15
Xn_232_p2 n_232_x n_231 vdd vdd sky130_fd_pr__pfet_01v8 W=1.4 L=0.15
Xn_232_n1 n_232 n_229 vss vss sky130_fd_pr__nfet_01v8 W=0.42 L=0.15
Xn_232_n2 n_232 n_231 vss vss sky130_fd_pr__nfet_01v8 W=0.42 L=0.15
Xn_233_n n_233 n_232 vss vss sky130_fd_pr__nfet_01v8 W=0.42 L=0.15
Xn_233_p n_233 n_232 vdd vdd sky130_fd_pr__pfet_01v8 W=0.7 L=0.15
Xn_234_p1 n_234 n_233 vdd vdd sky130_fd_pr__pfet_01v8 W=0.7 L=0.15
Xn_234_p2 n_234 n_227 vdd vdd sky130_fd_pr__pfet_01v8 W=0.7 L=0.15
Xn_234_n1 n_234 n_233 n_234_x vss sky130_fd_pr__nfet_01v8 W=0.84 L=0.15
Xn_234_n2 n_234_x n_227 vss vss sky130_fd_pr__nfet_01v8 W=0.84 L=0.15
Xn_235_n n_235 n_234 vss vss sky130_fd_pr__nfet_01v8 W=0.42 L=0.15
Xn_235_p n_235 n_234 vdd vdd sky130_fd_pr__pfet_01v8 W=0.7 L=0.15
Xn_236_n n_236 cmp_req vss vss sky130_fd_pr__nfet_01v8 W=0.42 L=0.15
Xn_236_p n_236 cmp_req vdd vdd sky130_fd_pr__pfet_01v8 W=0.7 L=0.15
Xn_238_p1 n_238 n_235 n_238_x vdd sky130_fd_pr__pfet_01v8 W=1.4 L=0.15
Xn_238_p2 n_238_x n_237 vdd vdd sky130_fd_pr__pfet_01v8 W=1.4 L=0.15
Xn_238_n1 n_238 n_235 vss vss sky130_fd_pr__nfet_01v8 W=0.42 L=0.15
Xn_238_n2 n_238 n_237 vss vss sky130_fd_pr__nfet_01v8 W=0.42 L=0.15
Xn_237_p1 n_237 n_236 n_237_x vdd sky130_fd_pr__pfet_01v8 W=1.4 L=0.15
Xn_237_p2 n_237_x n_238 vdd vdd sky130_fd_pr__pfet_01v8 W=1.4 L=0.15
Xn_237_n1 n_237 n_236 vss vss sky130_fd_pr__nfet_01v8 W=0.42 L=0.15
Xn_237_n2 n_237 n_238 vss vss sky130_fd_pr__nfet_01v8 W=0.42 L=0.15
Xn_239_n n_239 clk_f vss vss sky130_fd_pr__nfet_01v8 W=0.42 L=0.15
Xn_239_p n_239 clk_f vdd vdd sky130_fd_pr__pfet_01v8 W=0.7 L=0.15
Xn_240_n n_240 n_239 vss vss sky130_fd_pr__nfet_01v8 W=0.42 L=0.15
Xn_240_p n_240 n_239 vdd vdd sky130_fd_pr__pfet_01v8 W=0.7 L=0.15
Xn_242_n n_242 cmp_req vss vss sky130_fd_pr__nfet_01v8 W=0.42 L=0.15
Xn_242_p n_242 cmp_req vdd vdd sky130_fd_pr__pfet_01v8 W=0.7 L=0.15
Xn_244_p1 n_244 n_241 n_244_x vdd sky130_fd_pr__pfet_01v8 W=1.4 L=0.15
Xn_244_p2 n_244_x n_243 vdd vdd sky130_fd_pr__pfet_01v8 W=1.4 L=0.15
Xn_244_n1 n_244 n_241 vss vss sky130_fd_pr__nfet_01v8 W=0.42 L=0.15
Xn_244_n2 n_244 n_243 vss vss sky130_fd_pr__nfet_01v8 W=0.42 L=0.15
Xn_243_p1 n_243 n_242 n_243_x vdd sky130_fd_pr__pfet_01v8 W=1.4 L=0.15
Xn_243_p2 n_243_x n_244 vdd vdd sky130_fd_pr__pfet_01v8 W=1.4 L=0.15
Xn_243_n1 n_243 n_242 vss vss sky130_fd_pr__nfet_01v8 W=0.42 L=0.15
Xn_243_n2 n_243 n_244 vss vss sky130_fd_pr__nfet_01v8 W=0.42 L=0.15
Xn_245_p1 n_245 n_237 vdd vdd sky130_fd_pr__pfet_01v8 W=0.7 L=0.15
Xn_245_p2 n_245 n_243 vdd vdd sky130_fd_pr__pfet_01v8 W=0.7 L=0.15
Xn_245_n1 n_245 n_237 n_245_x vss sky130_fd_pr__nfet_01v8 W=0.84 L=0.15
Xn_245_n2 n_245_x n_243 vss vss sky130_fd_pr__nfet_01v8 W=0.84 L=0.15
Xn_246_p1 n_246 n_227 vdd vdd sky130_fd_pr__pfet_01v8 W=0.7 L=0.15
Xn_246_p2 n_246 n_245 vdd vdd sky130_fd_pr__pfet_01v8 W=0.7 L=0.15
Xn_246_n1 n_246 n_227 n_246_x vss sky130_fd_pr__nfet_01v8 W=0.84 L=0.15
Xn_246_n2 n_246_x n_245 vss vss sky130_fd_pr__nfet_01v8 W=0.84 L=0.15
Xn_247_n n_247 n_246 vss vss sky130_fd_pr__nfet_01v8 W=0.42 L=0.15
Xn_247_p n_247 n_246 vdd vdd sky130_fd_pr__pfet_01v8 W=0.7 L=0.15
Xn_248_n n_248 n_247 vss vss sky130_fd_pr__nfet_01v8 W=0.42 L=0.15
Xn_248_p n_248 n_247 vdd vdd sky130_fd_pr__pfet_01v8 W=0.7 L=0.15
Xclk_f_n clk_f n_248 vss vss sky130_fd_pr__nfet_01v8 W=0.42 L=0.15
Xclk_f_p clk_f n_248 vdd vdd sky130_fd_pr__pfet_01v8 W=0.7 L=0.15
Xclk_f_c clk_f vss sky130_fd_pr__cap_mim_m3_1 W=13.42 L=13.42
Xn_249_p1 n_249 sign vdd vdd sky130_fd_pr__pfet_01v8 W=0.7 L=0.15
Xn_249_p2 n_249 n_231 vdd vdd sky130_fd_pr__pfet_01v8 W=0.7 L=0.15
Xn_249_n1 n_249 sign n_249_x vss sky130_fd_pr__nfet_01v8 W=0.84 L=0.15
Xn_249_n2 n_249_x n_231 vss vss sky130_fd_pr__nfet_01v8 W=0.84 L=0.15
Xn_250_p1 n_250 n_42 vdd vdd sky130_fd_pr__pfet_01v8 W=0.7 L=0.15
Xn_250_p2 n_250 n_229 vdd vdd sky130_fd_pr__pfet_01v8 W=0.7 L=0.15
Xn_250_n1 n_250 n_42 n_250_x vss sky130_fd_pr__nfet_01v8 W=0.84 L=0.15
Xn_250_n2 n_250_x n_229 vss vss sky130_fd_pr__nfet_01v8 W=0.84 L=0.15
Xn_251_p1 n_251 n_249 vdd vdd sky130_fd_pr__pfet_01v8 W=0.7 L=0.15
Xn_251_p2 n_251 n_250 vdd vdd sky130_fd_pr__pfet_01v8 W=0.7 L=0.15
Xn_251_n1 n_251 n_249 n_251_x vss sky130_fd_pr__nfet_01v8 W=0.84 L=0.15
Xn_251_n2 n_251_x n_250 vss vss sky130_fd_pr__nfet_01v8 W=0.84 L=0.15
Xn_252_p1 n_252 sign vdd vdd sky130_fd_pr__pfet_01v8 W=0.7 L=0.15
Xn_252_p2 n_252 n_229 vdd vdd sky130_fd_pr__pfet_01v8 W=0.7 L=0.15
Xn_252_n1 n_252 sign n_252_x vss sky130_fd_pr__nfet_01v8 W=0.84 L=0.15
Xn_252_n2 n_252_x n_229 vss vss sky130_fd_pr__nfet_01v8 W=0.84 L=0.15
Xn_253_p1 n_253 n_42 vdd vdd sky130_fd_pr__pfet_01v8 W=0.7 L=0.15
Xn_253_p2 n_253 n_231 vdd vdd sky130_fd_pr__pfet_01v8 W=0.7 L=0.15
Xn_253_n1 n_253 n_42 n_253_x vss sky130_fd_pr__nfet_01v8 W=0.84 L=0.15
Xn_253_n2 n_253_x n_231 vss vss sky130_fd_pr__nfet_01v8 W=0.84 L=0.15
Xn_254_p1 n_254 n_252 vdd vdd sky130_fd_pr__pfet_01v8 W=0.7 L=0.15
Xn_254_p2 n_254 n_253 vdd vdd sky130_fd_pr__pfet_01v8 W=0.7 L=0.15
Xn_254_n1 n_254 n_252 n_254_x vss sky130_fd_pr__nfet_01v8 W=0.84 L=0.15
Xn_254_n2 n_254_x n_253 vss vss sky130_fd_pr__nfet_01v8 W=0.84 L=0.15
Xn_255_p1 n_255 n_254 n_255_x vdd sky130_fd_pr__pfet_01v8 W=1.4 L=0.15
Xn_255_p2 n_255_x n_1 vdd vdd sky130_fd_pr__pfet_01v8 W=1.4 L=0.15
Xn_255_n1 n_255 n_254 vss vss sky130_fd_pr__nfet_01v8 W=0.42 L=0.15
Xn_255_n2 n_255 n_1 vss vss sky130_fd_pr__nfet_01v8 W=0.42 L=0.15
Xn_256_n n_256 n_255 vss vss sky130_fd_pr__nfet_01v8 W=0.42 L=0.15
Xn_256_p n_256 n_255 vdd vdd sky130_fd_pr__pfet_01v8 W=0.7 L=0.15
Xn_257_p1 n_257 n_251 n_257_x vdd sky130_fd_pr__pfet_01v8 W=1.4 L=0.15
Xn_257_p2 n_257_x cmp_result vdd vdd sky130_fd_pr__pfet_01v8 W=1.4 L=0.15
Xn_257_n1 n_257 n_251 vss vss sky130_fd_pr__nfet_01v8 W=0.42 L=0.15
Xn_257_n2 n_257 cmp_result vss vss sky130_fd_pr__nfet_01v8 W=0.42 L=0.15
Xcmp_result_p1 cmp_result n_256 cmp_result_x vdd sky130_fd_pr__pfet_01v8 W=1.4 L=0.15
Xcmp_result_p2 cmp_result_x n_257 vdd vdd sky130_fd_pr__pfet_01v8 W=1.4 L=0.15
Xcmp_result_n1 cmp_result n_256 vss vss sky130_fd_pr__nfet_01v8 W=0.42 L=0.15
Xcmp_result_n2 cmp_result n_257 vss vss sky130_fd_pr__nfet_01v8 W=0.42 L=0.15
Xn_258_p1 n_258 n_233 n_258_x vdd sky130_fd_pr__pfet_01v8 W=1.4 L=0.15
Xn_258_p2 n_258_x n_247 vdd vdd sky130_fd_pr__pfet_01v8 W=1.4 L=0.15
Xn_258_n1 n_258 n_233 vss vss sky130_fd_pr__nfet_01v8 W=0.42 L=0.15
Xn_258_n2 n_258 n_247 vss vss sky130_fd_pr__nfet_01v8 W=0.42 L=0.15
Xn_259_p1 n_259 n_237 vdd vdd sky130_fd_pr__pfet_01v8 W=0.7 L=0.15
Xn_259_p2 n_259 n_258 vdd vdd sky130_fd_pr__pfet_01v8 W=0.7 L=0.15
Xn_259_n1 n_259 n_237 n_259_x vss sky130_fd_pr__nfet_01v8 W=0.84 L=0.15
Xn_259_n2 n_259_x n_258 vss vss sky130_fd_pr__nfet_01v8 W=0.84 L=0.15
Xn_260_n n_260 n_259 vss vss sky130_fd_pr__nfet_01v8 W=0.42 L=0.15
Xn_260_p n_260 n_259 vdd vdd sky130_fd_pr__pfet_01v8 W=0.7 L=0.15
Xn_262_p1 n_262 n_260 vdd vdd sky130_fd_pr__pfet_01v8 W=0.7 L=0.15
Xn_262_p2 n_262 n_261 vdd vdd sky130_fd_pr__pfet_01v8 W=0.7 L=0.15
Xn_262_n1 n_262 n_260 n_262_x vss sky130_fd_pr__nfet_01v8 W=0.84 L=0.15
Xn_262_n2 n_262_x n_261 vss vss sky130_fd_pr__nfet_01v8 W=0.84 L=0.15
Xn_263_n n_263 n_262 vss vss sky130_fd_pr__nfet_01v8 W=0.42 L=0.15
Xn_263_p n_263 n_262 vdd vdd sky130_fd_pr__pfet_01v8 W=0.7 L=0.15
Xn_264_p1 n_264 n_263 vdd vdd sky130_fd_pr__pfet_01v8 W=0.7 L=0.15
Xn_264_p2 n_264 cmp_req vdd vdd sky130_fd_pr__pfet_01v8 W=0.7 L=0.15
Xn_264_n1 n_264 n_263 n_264_x vss sky130_fd_pr__nfet_01v8 W=0.84 L=0.15
Xn_264_n2 n_264_x cmp_req vss vss sky130_fd_pr__nfet_01v8 W=0.84 L=0.15
Xcmp_ack_n cmp_ack n_264 vss vss sky130_fd_pr__nfet_01v8 W=0.42 L=0.15
Xcmp_ack_p cmp_ack n_264 vdd vdd sky130_fd_pr__pfet_01v8 W=0.7 L=0.15
Xn_265_p1 n_265 ota_en n_265_x vdd sky130_fd_pr__pfet_01v8 W=1.4 L=0.15
Xn_265_p2 n_265_x acq vdd vdd sky130_fd_pr__pfet_01v8 W=1.4 L=0.15
Xn_265_n1 n_265 ota_en vss vss sky130_fd_pr__nfet_01v8 W=0.42 L=0.15
Xn_265_n2 n_265 acq vss vss sky130_fd_pr__nfet_01v8 W=0.42 L=0.15
Xawake_n awake n_265 vss vss sky130_fd_pr__nfet_01v8 W=0.42 L=0.15
Xawake_p awake n_265 vdd vdd sky130_fd_pr__pfet_01v8 W=0.7 L=0.15
Xn_266_p1 n_266 coarse_en n_266_x vdd sky130_fd_pr__pfet_01v8 W=1.4 L=0.15
Xn_266_p2 n_266_x cmp_req vdd vdd sky130_fd_pr__pfet_01v8 W=1.4 L=0.15
Xn_266_n1 n_266 coarse_en vss vss sky130_fd_pr__nfet_01v8 W=0.42 L=0.15
Xn_266_n2 n_266 cmp_req vss vss sky130_fd_pr__nfet_01v8 W=0.42 L=0.15
Xbusy_n busy n_266 vss vss sky130_fd_pr__nfet_01v8 W=0.42 L=0.15
Xbusy_p busy n_266 vdd vdd sky130_fd_pr__pfet_01v8 W=0.7 L=0.15
.ends conv_seq

.subckt tile_seq seq_rst_n integ_req integ_ack win_hi lora_en x_mag0 x_mag1 x_mag2 x_mag3 x_mag4 x_mag5 x_mag6 x_mag7 x_mag8 x_mag9 x_mag10 x_mag11 x_mag12 x_mag13 x_mag14 x_mag15 x_mag16 x_mag17 x_mag18 x_mag19 x_mag20 x_mag21 x_mag22 x_mag23 x_mag24 x_mag25 x_mag26 x_mag27 x_mag28 x_mag29 x_mag30 x_mag31 x_mag32 x_mag33 x_mag34 x_mag35 x_mag36 x_mag37 x_mag38 x_mag39 x_mag40 x_mag41 x_mag42 x_mag43 x_mag44 x_mag45 x_mag46 x_mag47 x_mag48 x_mag49 x_mag50 x_mag51 x_mag52 x_mag53 x_mag54 x_mag55 x_mag56 x_mag57 x_mag58 x_mag59 x_mag60 x_mag61 x_mag62 x_mag63 x_neg0 x_neg1 x_neg2 x_neg3 x_neg4 x_neg5 x_neg6 x_neg7 x_neg8 x_neg9 x_neg10 x_neg11 x_neg12 x_neg13 x_neg14 x_neg15 sdone0 sdone1 sdone2 sdone3 sdone4 sdone5 sdone6 sdone7 sdone8 sdone9 sdone10 sdone11 sdone12 sdone13 sdone14 sdone15 sdone16 busy0 busy1 busy2 busy3 busy4 busy5 busy6 busy7 busy8 busy9 busy10 busy11 busy12 busy13 busy14 busy15 busy16 sgo rst phi1 phi1e phi2 tphi1 tphi1e tphi2 xin_p_r0 xin_n_r0 xin_p_r1 xin_n_r1 xin_p_r2 xin_n_r2 xin_p_r3 xin_n_r3 xin_p_r4 xin_n_r4 xin_p_r5 xin_n_r5 xin_p_r6 xin_n_r6 xin_p_r7 xin_n_r7 xin_p_r8 xin_n_r8 xin_p_r9 xin_n_r9 xin_p_r10 xin_n_r10 xin_p_r11 xin_n_r11 xin_p_r12 xin_n_r12 xin_p_r13 xin_n_r13 xin_p_r14 xin_n_r14 xin_p_r15 xin_n_r15 xrd_en0 xrd_en1 xrd_en2 xrd_en3 xrd_en4 xrd_en5 xrd_en6 xrd_en7 xrd_en8 xrd_en9 xrd_en10 xrd_en11 xrd_en12 xrd_en13 xrd_en14 xrd_en15 ramp_en vdd vss
Xseq n_3 adc_done xbar_rst adc_go latch_out integ_ack vdd vss async_ctrl
Xxn_130 n_128 n_130 vdd vss dly_bundle
Xring in tap1 tap2 tap3 tap4 vdd vss tq_chain
Xcchop p c_phi1 c_phi1e c_phi2 c_ck vdd vss chop_gen
Xtchop p_tile t_phi1 t_phi1e t_phi2 t_ck vdd vss chop_gen
Xn_1_n n_1 seq_rst_n vss vss sky130_fd_pr__nfet_01v8 W=0.42 L=0.15
Xn_1_p n_1 seq_rst_n vdd vdd sky130_fd_pr__pfet_01v8 W=0.7 L=0.15
Xn_2_p1 n_2 integ_req vdd vdd sky130_fd_pr__pfet_01v8 W=0.7 L=0.15
Xn_2_p2 n_2 seq_rst_n vdd vdd sky130_fd_pr__pfet_01v8 W=0.7 L=0.15
Xn_2_n1 n_2 integ_req n_2_x vss sky130_fd_pr__nfet_01v8 W=0.84 L=0.15
Xn_2_n2 n_2_x seq_rst_n vss vss sky130_fd_pr__nfet_01v8 W=0.84 L=0.15
Xn_3_n n_3 n_2 vss vss sky130_fd_pr__nfet_01v8 W=0.42 L=0.15
Xn_3_p n_3 n_2 vdd vdd sky130_fd_pr__pfet_01v8 W=0.7 L=0.15
Xn_4_n n_4 n_3 vss vss sky130_fd_pr__nfet_01v8 W=0.42 L=0.15
Xn_4_p n_4 n_3 vdd vdd sky130_fd_pr__pfet_01v8 W=0.7 L=0.15
Xn_6_p1 n_6 xbar_rst n_6_x vdd sky130_fd_pr__pfet_01v8 W=1.4 L=0.15
Xn_6_p2 n_6_x n_5 vdd vdd sky130_fd_pr__pfet_01v8 W=1.4 L=0.15
Xn_6_n1 n_6 xbar_rst vss vss sky130_fd_pr__nfet_01v8 W=0.42 L=0.15
Xn_6_n2 n_6 n_5 vss vss sky130_fd_pr__nfet_01v8 W=0.42 L=0.15
Xn_5_p1 n_5 n_1 n_5_x vdd sky130_fd_pr__pfet_01v8 W=1.4 L=0.15
Xn_5_p2 n_5_x n_6 vdd vdd sky130_fd_pr__pfet_01v8 W=1.4 L=0.15
Xn_5_n1 n_5 n_1 vss vss sky130_fd_pr__nfet_01v8 W=0.42 L=0.15
Xn_5_n2 n_5 n_6 vss vss sky130_fd_pr__nfet_01v8 W=0.42 L=0.15
Xn_7_n n_7 n_5 vss vss sky130_fd_pr__nfet_01v8 W=0.42 L=0.15
Xn_7_p n_7 n_5 vdd vdd sky130_fd_pr__pfet_01v8 W=0.7 L=0.15
Xn_8_p1 n_8 xbar_rst n_8_x vdd sky130_fd_pr__pfet_01v8 W=1.4 L=0.15
Xn_8_p2 n_8_x n_7 vdd vdd sky130_fd_pr__pfet_01v8 W=1.4 L=0.15
Xn_8_n1 n_8 xbar_rst vss vss sky130_fd_pr__nfet_01v8 W=0.42 L=0.15
Xn_8_n2 n_8 n_7 vss vss sky130_fd_pr__nfet_01v8 W=0.42 L=0.15
Xn_9_n n_9 n_8 vss vss sky130_fd_pr__nfet_01v8 W=0.42 L=0.15
Xn_9_p n_9 n_8 vdd vdd sky130_fd_pr__pfet_01v8 W=0.7 L=0.15
Xn_10_n n_10 n_9 vss vss sky130_fd_pr__nfet_01v8 W=1.26 L=0.15
Xn_10_p n_10 n_9 vdd vdd sky130_fd_pr__pfet_01v8 W=2.1 L=0.15
Xrst_n rst n_10 vss vss sky130_fd_pr__nfet_01v8 W=4.2 L=0.15
Xrst_p rst n_10 vdd vdd sky130_fd_pr__pfet_01v8 W=7 L=0.15
Xn_11_p1 n_11 xbar_rst n_11_x vdd sky130_fd_pr__pfet_01v8 W=1.4 L=0.15
Xn_11_p2 n_11_x n_1 vdd vdd sky130_fd_pr__pfet_01v8 W=1.4 L=0.15
Xn_11_n1 n_11 xbar_rst vss vss sky130_fd_pr__nfet_01v8 W=0.42 L=0.15
Xn_11_n2 n_11 n_1 vss vss sky130_fd_pr__nfet_01v8 W=0.42 L=0.15
Xn_12_n n_12 n_11 vss vss sky130_fd_pr__nfet_01v8 W=0.42 L=0.15
Xn_12_p n_12 n_11 vdd vdd sky130_fd_pr__pfet_01v8 W=0.7 L=0.15
Xn_14_p1 n_14 sg n_14_x vdd sky130_fd_pr__pfet_01v8 W=1.4 L=0.15
Xn_14_p2 n_14_x n_13 vdd vdd sky130_fd_pr__pfet_01v8 W=1.4 L=0.15
Xn_14_n1 n_14 sg vss vss sky130_fd_pr__nfet_01v8 W=0.42 L=0.15
Xn_14_n2 n_14 n_13 vss vss sky130_fd_pr__nfet_01v8 W=0.42 L=0.15
Xn_13_p1 n_13 n_12 n_13_x vdd sky130_fd_pr__pfet_01v8 W=1.4 L=0.15
Xn_13_p2 n_13_x n_14 vdd vdd sky130_fd_pr__pfet_01v8 W=1.4 L=0.15
Xn_13_n1 n_13 n_12 vss vss sky130_fd_pr__nfet_01v8 W=0.42 L=0.15
Xn_13_n2 n_13 n_14 vss vss sky130_fd_pr__nfet_01v8 W=0.42 L=0.15
Xn_15_n n_15 n_13 vss vss sky130_fd_pr__nfet_01v8 W=1.26 L=0.15
Xn_15_p n_15 n_13 vdd vdd sky130_fd_pr__pfet_01v8 W=2.1 L=0.15
Xsgo_n sgo n_15 vss vss sky130_fd_pr__nfet_01v8 W=3.36 L=0.15
Xsgo_p sgo n_15 vdd vdd sky130_fd_pr__pfet_01v8 W=5.6 L=0.15
Xn_17_p1 n_17 sg n_17_x vdd sky130_fd_pr__pfet_01v8 W=1.4 L=0.15
Xn_17_p2 n_17_x n_16 vdd vdd sky130_fd_pr__pfet_01v8 W=1.4 L=0.15
Xn_17_n1 n_17 sg vss vss sky130_fd_pr__nfet_01v8 W=0.42 L=0.15
Xn_17_n2 n_17 n_16 vss vss sky130_fd_pr__nfet_01v8 W=0.42 L=0.15
Xn_16_p1 n_16 n_4 n_16_x vdd sky130_fd_pr__pfet_01v8 W=1.4 L=0.15
Xn_16_p2 n_16_x n_17 vdd vdd sky130_fd_pr__pfet_01v8 W=1.4 L=0.15
Xn_16_n1 n_16 n_4 vss vss sky130_fd_pr__nfet_01v8 W=0.42 L=0.15
Xn_16_n2 n_16 n_17 vss vss sky130_fd_pr__nfet_01v8 W=0.42 L=0.15
Xn_18_p1 n_18 sdone0 vdd vdd sky130_fd_pr__pfet_01v8 W=0.7 L=0.15
Xn_18_p2 n_18 sdone1 vdd vdd sky130_fd_pr__pfet_01v8 W=0.7 L=0.15
Xn_18_n1 n_18 sdone0 n_18_x vss sky130_fd_pr__nfet_01v8 W=0.84 L=0.15
Xn_18_n2 n_18_x sdone1 vss vss sky130_fd_pr__nfet_01v8 W=0.84 L=0.15
Xn_19_n n_19 n_18 vss vss sky130_fd_pr__nfet_01v8 W=0.42 L=0.15
Xn_19_p n_19 n_18 vdd vdd sky130_fd_pr__pfet_01v8 W=0.7 L=0.15
Xn_20_p1 n_20 sdone0 n_20_x vdd sky130_fd_pr__pfet_01v8 W=1.4 L=0.15
Xn_20_p2 n_20_x sdone1 vdd vdd sky130_fd_pr__pfet_01v8 W=1.4 L=0.15
Xn_20_n1 n_20 sdone0 vss vss sky130_fd_pr__nfet_01v8 W=0.42 L=0.15
Xn_20_n2 n_20 sdone1 vss vss sky130_fd_pr__nfet_01v8 W=0.42 L=0.15
Xn_21_p1 n_21 n_20 n_21_x vdd sky130_fd_pr__pfet_01v8 W=1.4 L=0.15
Xn_21_p2 n_21_x n_1 vdd vdd sky130_fd_pr__pfet_01v8 W=1.4 L=0.15
Xn_21_n1 n_21 n_20 vss vss sky130_fd_pr__nfet_01v8 W=0.42 L=0.15
Xn_21_n2 n_21 n_1 vss vss sky130_fd_pr__nfet_01v8 W=0.42 L=0.15
Xn_22_n n_22 n_21 vss vss sky130_fd_pr__nfet_01v8 W=0.42 L=0.15
Xn_22_p n_22 n_21 vdd vdd sky130_fd_pr__pfet_01v8 W=0.7 L=0.15
Xn_24_p1 n_24 n_19 n_24_x vdd sky130_fd_pr__pfet_01v8 W=1.4 L=0.15
Xn_24_p2 n_24_x n_23 vdd vdd sky130_fd_pr__pfet_01v8 W=1.4 L=0.15
Xn_24_n1 n_24 n_19 vss vss sky130_fd_pr__nfet_01v8 W=0.42 L=0.15
Xn_24_n2 n_24 n_23 vss vss sky130_fd_pr__nfet_01v8 W=0.42 L=0.15
Xn_23_p1 n_23 n_22 n_23_x vdd sky130_fd_pr__pfet_01v8 W=1.4 L=0.15
Xn_23_p2 n_23_x n_24 vdd vdd sky130_fd_pr__pfet_01v8 W=1.4 L=0.15
Xn_23_n1 n_23 n_22 vss vss sky130_fd_pr__nfet_01v8 W=0.42 L=0.15
Xn_23_n2 n_23 n_24 vss vss sky130_fd_pr__nfet_01v8 W=0.42 L=0.15
Xn_25_p1 n_25 sdone2 vdd vdd sky130_fd_pr__pfet_01v8 W=0.7 L=0.15
Xn_25_p2 n_25 sdone3 vdd vdd sky130_fd_pr__pfet_01v8 W=0.7 L=0.15
Xn_25_n1 n_25 sdone2 n_25_x vss sky130_fd_pr__nfet_01v8 W=0.84 L=0.15
Xn_25_n2 n_25_x sdone3 vss vss sky130_fd_pr__nfet_01v8 W=0.84 L=0.15
Xn_26_n n_26 n_25 vss vss sky130_fd_pr__nfet_01v8 W=0.42 L=0.15
Xn_26_p n_26 n_25 vdd vdd sky130_fd_pr__pfet_01v8 W=0.7 L=0.15
Xn_27_p1 n_27 sdone2 n_27_x vdd sky130_fd_pr__pfet_01v8 W=1.4 L=0.15
Xn_27_p2 n_27_x sdone3 vdd vdd sky130_fd_pr__pfet_01v8 W=1.4 L=0.15
Xn_27_n1 n_27 sdone2 vss vss sky130_fd_pr__nfet_01v8 W=0.42 L=0.15
Xn_27_n2 n_27 sdone3 vss vss sky130_fd_pr__nfet_01v8 W=0.42 L=0.15
Xn_28_p1 n_28 n_27 n_28_x vdd sky130_fd_pr__pfet_01v8 W=1.4 L=0.15
Xn_28_p2 n_28_x n_1 vdd vdd sky130_fd_pr__pfet_01v8 W=1.4 L=0.15
Xn_28_n1 n_28 n_27 vss vss sky130_fd_pr__nfet_01v8 W=0.42 L=0.15
Xn_28_n2 n_28 n_1 vss vss sky130_fd_pr__nfet_01v8 W=0.42 L=0.15
Xn_29_n n_29 n_28 vss vss sky130_fd_pr__nfet_01v8 W=0.42 L=0.15
Xn_29_p n_29 n_28 vdd vdd sky130_fd_pr__pfet_01v8 W=0.7 L=0.15
Xn_31_p1 n_31 n_26 n_31_x vdd sky130_fd_pr__pfet_01v8 W=1.4 L=0.15
Xn_31_p2 n_31_x n_30 vdd vdd sky130_fd_pr__pfet_01v8 W=1.4 L=0.15
Xn_31_n1 n_31 n_26 vss vss sky130_fd_pr__nfet_01v8 W=0.42 L=0.15
Xn_31_n2 n_31 n_30 vss vss sky130_fd_pr__nfet_01v8 W=0.42 L=0.15
Xn_30_p1 n_30 n_29 n_30_x vdd sky130_fd_pr__pfet_01v8 W=1.4 L=0.15
Xn_30_p2 n_30_x n_31 vdd vdd sky130_fd_pr__pfet_01v8 W=1.4 L=0.15
Xn_30_n1 n_30 n_29 vss vss sky130_fd_pr__nfet_01v8 W=0.42 L=0.15
Xn_30_n2 n_30 n_31 vss vss sky130_fd_pr__nfet_01v8 W=0.42 L=0.15
Xn_32_p1 n_32 sdone4 vdd vdd sky130_fd_pr__pfet_01v8 W=0.7 L=0.15
Xn_32_p2 n_32 sdone5 vdd vdd sky130_fd_pr__pfet_01v8 W=0.7 L=0.15
Xn_32_n1 n_32 sdone4 n_32_x vss sky130_fd_pr__nfet_01v8 W=0.84 L=0.15
Xn_32_n2 n_32_x sdone5 vss vss sky130_fd_pr__nfet_01v8 W=0.84 L=0.15
Xn_33_n n_33 n_32 vss vss sky130_fd_pr__nfet_01v8 W=0.42 L=0.15
Xn_33_p n_33 n_32 vdd vdd sky130_fd_pr__pfet_01v8 W=0.7 L=0.15
Xn_34_p1 n_34 sdone4 n_34_x vdd sky130_fd_pr__pfet_01v8 W=1.4 L=0.15
Xn_34_p2 n_34_x sdone5 vdd vdd sky130_fd_pr__pfet_01v8 W=1.4 L=0.15
Xn_34_n1 n_34 sdone4 vss vss sky130_fd_pr__nfet_01v8 W=0.42 L=0.15
Xn_34_n2 n_34 sdone5 vss vss sky130_fd_pr__nfet_01v8 W=0.42 L=0.15
Xn_35_p1 n_35 n_34 n_35_x vdd sky130_fd_pr__pfet_01v8 W=1.4 L=0.15
Xn_35_p2 n_35_x n_1 vdd vdd sky130_fd_pr__pfet_01v8 W=1.4 L=0.15
Xn_35_n1 n_35 n_34 vss vss sky130_fd_pr__nfet_01v8 W=0.42 L=0.15
Xn_35_n2 n_35 n_1 vss vss sky130_fd_pr__nfet_01v8 W=0.42 L=0.15
Xn_36_n n_36 n_35 vss vss sky130_fd_pr__nfet_01v8 W=0.42 L=0.15
Xn_36_p n_36 n_35 vdd vdd sky130_fd_pr__pfet_01v8 W=0.7 L=0.15
Xn_38_p1 n_38 n_33 n_38_x vdd sky130_fd_pr__pfet_01v8 W=1.4 L=0.15
Xn_38_p2 n_38_x n_37 vdd vdd sky130_fd_pr__pfet_01v8 W=1.4 L=0.15
Xn_38_n1 n_38 n_33 vss vss sky130_fd_pr__nfet_01v8 W=0.42 L=0.15
Xn_38_n2 n_38 n_37 vss vss sky130_fd_pr__nfet_01v8 W=0.42 L=0.15
Xn_37_p1 n_37 n_36 n_37_x vdd sky130_fd_pr__pfet_01v8 W=1.4 L=0.15
Xn_37_p2 n_37_x n_38 vdd vdd sky130_fd_pr__pfet_01v8 W=1.4 L=0.15
Xn_37_n1 n_37 n_36 vss vss sky130_fd_pr__nfet_01v8 W=0.42 L=0.15
Xn_37_n2 n_37 n_38 vss vss sky130_fd_pr__nfet_01v8 W=0.42 L=0.15
Xn_39_p1 n_39 sdone6 vdd vdd sky130_fd_pr__pfet_01v8 W=0.7 L=0.15
Xn_39_p2 n_39 sdone7 vdd vdd sky130_fd_pr__pfet_01v8 W=0.7 L=0.15
Xn_39_n1 n_39 sdone6 n_39_x vss sky130_fd_pr__nfet_01v8 W=0.84 L=0.15
Xn_39_n2 n_39_x sdone7 vss vss sky130_fd_pr__nfet_01v8 W=0.84 L=0.15
Xn_40_n n_40 n_39 vss vss sky130_fd_pr__nfet_01v8 W=0.42 L=0.15
Xn_40_p n_40 n_39 vdd vdd sky130_fd_pr__pfet_01v8 W=0.7 L=0.15
Xn_41_p1 n_41 sdone6 n_41_x vdd sky130_fd_pr__pfet_01v8 W=1.4 L=0.15
Xn_41_p2 n_41_x sdone7 vdd vdd sky130_fd_pr__pfet_01v8 W=1.4 L=0.15
Xn_41_n1 n_41 sdone6 vss vss sky130_fd_pr__nfet_01v8 W=0.42 L=0.15
Xn_41_n2 n_41 sdone7 vss vss sky130_fd_pr__nfet_01v8 W=0.42 L=0.15
Xn_42_p1 n_42 n_41 n_42_x vdd sky130_fd_pr__pfet_01v8 W=1.4 L=0.15
Xn_42_p2 n_42_x n_1 vdd vdd sky130_fd_pr__pfet_01v8 W=1.4 L=0.15
Xn_42_n1 n_42 n_41 vss vss sky130_fd_pr__nfet_01v8 W=0.42 L=0.15
Xn_42_n2 n_42 n_1 vss vss sky130_fd_pr__nfet_01v8 W=0.42 L=0.15
Xn_43_n n_43 n_42 vss vss sky130_fd_pr__nfet_01v8 W=0.42 L=0.15
Xn_43_p n_43 n_42 vdd vdd sky130_fd_pr__pfet_01v8 W=0.7 L=0.15
Xn_45_p1 n_45 n_40 n_45_x vdd sky130_fd_pr__pfet_01v8 W=1.4 L=0.15
Xn_45_p2 n_45_x n_44 vdd vdd sky130_fd_pr__pfet_01v8 W=1.4 L=0.15
Xn_45_n1 n_45 n_40 vss vss sky130_fd_pr__nfet_01v8 W=0.42 L=0.15
Xn_45_n2 n_45 n_44 vss vss sky130_fd_pr__nfet_01v8 W=0.42 L=0.15
Xn_44_p1 n_44 n_43 n_44_x vdd sky130_fd_pr__pfet_01v8 W=1.4 L=0.15
Xn_44_p2 n_44_x n_45 vdd vdd sky130_fd_pr__pfet_01v8 W=1.4 L=0.15
Xn_44_n1 n_44 n_43 vss vss sky130_fd_pr__nfet_01v8 W=0.42 L=0.15
Xn_44_n2 n_44 n_45 vss vss sky130_fd_pr__nfet_01v8 W=0.42 L=0.15
Xn_46_p1 n_46 sdone8 vdd vdd sky130_fd_pr__pfet_01v8 W=0.7 L=0.15
Xn_46_p2 n_46 sdone9 vdd vdd sky130_fd_pr__pfet_01v8 W=0.7 L=0.15
Xn_46_n1 n_46 sdone8 n_46_x vss sky130_fd_pr__nfet_01v8 W=0.84 L=0.15
Xn_46_n2 n_46_x sdone9 vss vss sky130_fd_pr__nfet_01v8 W=0.84 L=0.15
Xn_47_n n_47 n_46 vss vss sky130_fd_pr__nfet_01v8 W=0.42 L=0.15
Xn_47_p n_47 n_46 vdd vdd sky130_fd_pr__pfet_01v8 W=0.7 L=0.15
Xn_48_p1 n_48 sdone8 n_48_x vdd sky130_fd_pr__pfet_01v8 W=1.4 L=0.15
Xn_48_p2 n_48_x sdone9 vdd vdd sky130_fd_pr__pfet_01v8 W=1.4 L=0.15
Xn_48_n1 n_48 sdone8 vss vss sky130_fd_pr__nfet_01v8 W=0.42 L=0.15
Xn_48_n2 n_48 sdone9 vss vss sky130_fd_pr__nfet_01v8 W=0.42 L=0.15
Xn_49_p1 n_49 n_48 n_49_x vdd sky130_fd_pr__pfet_01v8 W=1.4 L=0.15
Xn_49_p2 n_49_x n_1 vdd vdd sky130_fd_pr__pfet_01v8 W=1.4 L=0.15
Xn_49_n1 n_49 n_48 vss vss sky130_fd_pr__nfet_01v8 W=0.42 L=0.15
Xn_49_n2 n_49 n_1 vss vss sky130_fd_pr__nfet_01v8 W=0.42 L=0.15
Xn_50_n n_50 n_49 vss vss sky130_fd_pr__nfet_01v8 W=0.42 L=0.15
Xn_50_p n_50 n_49 vdd vdd sky130_fd_pr__pfet_01v8 W=0.7 L=0.15
Xn_52_p1 n_52 n_47 n_52_x vdd sky130_fd_pr__pfet_01v8 W=1.4 L=0.15
Xn_52_p2 n_52_x n_51 vdd vdd sky130_fd_pr__pfet_01v8 W=1.4 L=0.15
Xn_52_n1 n_52 n_47 vss vss sky130_fd_pr__nfet_01v8 W=0.42 L=0.15
Xn_52_n2 n_52 n_51 vss vss sky130_fd_pr__nfet_01v8 W=0.42 L=0.15
Xn_51_p1 n_51 n_50 n_51_x vdd sky130_fd_pr__pfet_01v8 W=1.4 L=0.15
Xn_51_p2 n_51_x n_52 vdd vdd sky130_fd_pr__pfet_01v8 W=1.4 L=0.15
Xn_51_n1 n_51 n_50 vss vss sky130_fd_pr__nfet_01v8 W=0.42 L=0.15
Xn_51_n2 n_51 n_52 vss vss sky130_fd_pr__nfet_01v8 W=0.42 L=0.15
Xn_53_p1 n_53 sdone10 vdd vdd sky130_fd_pr__pfet_01v8 W=0.7 L=0.15
Xn_53_p2 n_53 sdone11 vdd vdd sky130_fd_pr__pfet_01v8 W=0.7 L=0.15
Xn_53_n1 n_53 sdone10 n_53_x vss sky130_fd_pr__nfet_01v8 W=0.84 L=0.15
Xn_53_n2 n_53_x sdone11 vss vss sky130_fd_pr__nfet_01v8 W=0.84 L=0.15
Xn_54_n n_54 n_53 vss vss sky130_fd_pr__nfet_01v8 W=0.42 L=0.15
Xn_54_p n_54 n_53 vdd vdd sky130_fd_pr__pfet_01v8 W=0.7 L=0.15
Xn_55_p1 n_55 sdone10 n_55_x vdd sky130_fd_pr__pfet_01v8 W=1.4 L=0.15
Xn_55_p2 n_55_x sdone11 vdd vdd sky130_fd_pr__pfet_01v8 W=1.4 L=0.15
Xn_55_n1 n_55 sdone10 vss vss sky130_fd_pr__nfet_01v8 W=0.42 L=0.15
Xn_55_n2 n_55 sdone11 vss vss sky130_fd_pr__nfet_01v8 W=0.42 L=0.15
Xn_56_p1 n_56 n_55 n_56_x vdd sky130_fd_pr__pfet_01v8 W=1.4 L=0.15
Xn_56_p2 n_56_x n_1 vdd vdd sky130_fd_pr__pfet_01v8 W=1.4 L=0.15
Xn_56_n1 n_56 n_55 vss vss sky130_fd_pr__nfet_01v8 W=0.42 L=0.15
Xn_56_n2 n_56 n_1 vss vss sky130_fd_pr__nfet_01v8 W=0.42 L=0.15
Xn_57_n n_57 n_56 vss vss sky130_fd_pr__nfet_01v8 W=0.42 L=0.15
Xn_57_p n_57 n_56 vdd vdd sky130_fd_pr__pfet_01v8 W=0.7 L=0.15
Xn_59_p1 n_59 n_54 n_59_x vdd sky130_fd_pr__pfet_01v8 W=1.4 L=0.15
Xn_59_p2 n_59_x n_58 vdd vdd sky130_fd_pr__pfet_01v8 W=1.4 L=0.15
Xn_59_n1 n_59 n_54 vss vss sky130_fd_pr__nfet_01v8 W=0.42 L=0.15
Xn_59_n2 n_59 n_58 vss vss sky130_fd_pr__nfet_01v8 W=0.42 L=0.15
Xn_58_p1 n_58 n_57 n_58_x vdd sky130_fd_pr__pfet_01v8 W=1.4 L=0.15
Xn_58_p2 n_58_x n_59 vdd vdd sky130_fd_pr__pfet_01v8 W=1.4 L=0.15
Xn_58_n1 n_58 n_57 vss vss sky130_fd_pr__nfet_01v8 W=0.42 L=0.15
Xn_58_n2 n_58 n_59 vss vss sky130_fd_pr__nfet_01v8 W=0.42 L=0.15
Xn_60_p1 n_60 sdone12 vdd vdd sky130_fd_pr__pfet_01v8 W=0.7 L=0.15
Xn_60_p2 n_60 sdone13 vdd vdd sky130_fd_pr__pfet_01v8 W=0.7 L=0.15
Xn_60_n1 n_60 sdone12 n_60_x vss sky130_fd_pr__nfet_01v8 W=0.84 L=0.15
Xn_60_n2 n_60_x sdone13 vss vss sky130_fd_pr__nfet_01v8 W=0.84 L=0.15
Xn_61_n n_61 n_60 vss vss sky130_fd_pr__nfet_01v8 W=0.42 L=0.15
Xn_61_p n_61 n_60 vdd vdd sky130_fd_pr__pfet_01v8 W=0.7 L=0.15
Xn_62_p1 n_62 sdone12 n_62_x vdd sky130_fd_pr__pfet_01v8 W=1.4 L=0.15
Xn_62_p2 n_62_x sdone13 vdd vdd sky130_fd_pr__pfet_01v8 W=1.4 L=0.15
Xn_62_n1 n_62 sdone12 vss vss sky130_fd_pr__nfet_01v8 W=0.42 L=0.15
Xn_62_n2 n_62 sdone13 vss vss sky130_fd_pr__nfet_01v8 W=0.42 L=0.15
Xn_63_p1 n_63 n_62 n_63_x vdd sky130_fd_pr__pfet_01v8 W=1.4 L=0.15
Xn_63_p2 n_63_x n_1 vdd vdd sky130_fd_pr__pfet_01v8 W=1.4 L=0.15
Xn_63_n1 n_63 n_62 vss vss sky130_fd_pr__nfet_01v8 W=0.42 L=0.15
Xn_63_n2 n_63 n_1 vss vss sky130_fd_pr__nfet_01v8 W=0.42 L=0.15
Xn_64_n n_64 n_63 vss vss sky130_fd_pr__nfet_01v8 W=0.42 L=0.15
Xn_64_p n_64 n_63 vdd vdd sky130_fd_pr__pfet_01v8 W=0.7 L=0.15
Xn_66_p1 n_66 n_61 n_66_x vdd sky130_fd_pr__pfet_01v8 W=1.4 L=0.15
Xn_66_p2 n_66_x n_65 vdd vdd sky130_fd_pr__pfet_01v8 W=1.4 L=0.15
Xn_66_n1 n_66 n_61 vss vss sky130_fd_pr__nfet_01v8 W=0.42 L=0.15
Xn_66_n2 n_66 n_65 vss vss sky130_fd_pr__nfet_01v8 W=0.42 L=0.15
Xn_65_p1 n_65 n_64 n_65_x vdd sky130_fd_pr__pfet_01v8 W=1.4 L=0.15
Xn_65_p2 n_65_x n_66 vdd vdd sky130_fd_pr__pfet_01v8 W=1.4 L=0.15
Xn_65_n1 n_65 n_64 vss vss sky130_fd_pr__nfet_01v8 W=0.42 L=0.15
Xn_65_n2 n_65 n_66 vss vss sky130_fd_pr__nfet_01v8 W=0.42 L=0.15
Xn_67_p1 n_67 sdone14 vdd vdd sky130_fd_pr__pfet_01v8 W=0.7 L=0.15
Xn_67_p2 n_67 sdone15 vdd vdd sky130_fd_pr__pfet_01v8 W=0.7 L=0.15
Xn_67_n1 n_67 sdone14 n_67_x vss sky130_fd_pr__nfet_01v8 W=0.84 L=0.15
Xn_67_n2 n_67_x sdone15 vss vss sky130_fd_pr__nfet_01v8 W=0.84 L=0.15
Xn_68_n n_68 n_67 vss vss sky130_fd_pr__nfet_01v8 W=0.42 L=0.15
Xn_68_p n_68 n_67 vdd vdd sky130_fd_pr__pfet_01v8 W=0.7 L=0.15
Xn_69_p1 n_69 sdone14 n_69_x vdd sky130_fd_pr__pfet_01v8 W=1.4 L=0.15
Xn_69_p2 n_69_x sdone15 vdd vdd sky130_fd_pr__pfet_01v8 W=1.4 L=0.15
Xn_69_n1 n_69 sdone14 vss vss sky130_fd_pr__nfet_01v8 W=0.42 L=0.15
Xn_69_n2 n_69 sdone15 vss vss sky130_fd_pr__nfet_01v8 W=0.42 L=0.15
Xn_70_p1 n_70 n_69 n_70_x vdd sky130_fd_pr__pfet_01v8 W=1.4 L=0.15
Xn_70_p2 n_70_x n_1 vdd vdd sky130_fd_pr__pfet_01v8 W=1.4 L=0.15
Xn_70_n1 n_70 n_69 vss vss sky130_fd_pr__nfet_01v8 W=0.42 L=0.15
Xn_70_n2 n_70 n_1 vss vss sky130_fd_pr__nfet_01v8 W=0.42 L=0.15
Xn_71_n n_71 n_70 vss vss sky130_fd_pr__nfet_01v8 W=0.42 L=0.15
Xn_71_p n_71 n_70 vdd vdd sky130_fd_pr__pfet_01v8 W=0.7 L=0.15
Xn_73_p1 n_73 n_68 n_73_x vdd sky130_fd_pr__pfet_01v8 W=1.4 L=0.15
Xn_73_p2 n_73_x n_72 vdd vdd sky130_fd_pr__pfet_01v8 W=1.4 L=0.15
Xn_73_n1 n_73 n_68 vss vss sky130_fd_pr__nfet_01v8 W=0.42 L=0.15
Xn_73_n2 n_73 n_72 vss vss sky130_fd_pr__nfet_01v8 W=0.42 L=0.15
Xn_72_p1 n_72 n_71 n_72_x vdd sky130_fd_pr__pfet_01v8 W=1.4 L=0.15
Xn_72_p2 n_72_x n_73 vdd vdd sky130_fd_pr__pfet_01v8 W=1.4 L=0.15
Xn_72_n1 n_72 n_71 vss vss sky130_fd_pr__nfet_01v8 W=0.42 L=0.15
Xn_72_n2 n_72 n_73 vss vss sky130_fd_pr__nfet_01v8 W=0.42 L=0.15
Xn_74_p1 n_74 n_23 vdd vdd sky130_fd_pr__pfet_01v8 W=0.7 L=0.15
Xn_74_p2 n_74 n_30 vdd vdd sky130_fd_pr__pfet_01v8 W=0.7 L=0.15
Xn_74_n1 n_74 n_23 n_74_x vss sky130_fd_pr__nfet_01v8 W=0.84 L=0.15
Xn_74_n2 n_74_x n_30 vss vss sky130_fd_pr__nfet_01v8 W=0.84 L=0.15
Xn_75_n n_75 n_74 vss vss sky130_fd_pr__nfet_01v8 W=0.42 L=0.15
Xn_75_p n_75 n_74 vdd vdd sky130_fd_pr__pfet_01v8 W=0.7 L=0.15
Xn_76_p1 n_76 n_23 n_76_x vdd sky130_fd_pr__pfet_01v8 W=1.4 L=0.15
Xn_76_p2 n_76_x n_30 vdd vdd sky130_fd_pr__pfet_01v8 W=1.4 L=0.15
Xn_76_n1 n_76 n_23 vss vss sky130_fd_pr__nfet_01v8 W=0.42 L=0.15
Xn_76_n2 n_76 n_30 vss vss sky130_fd_pr__nfet_01v8 W=0.42 L=0.15
Xn_77_p1 n_77 n_76 n_77_x vdd sky130_fd_pr__pfet_01v8 W=1.4 L=0.15
Xn_77_p2 n_77_x n_1 vdd vdd sky130_fd_pr__pfet_01v8 W=1.4 L=0.15
Xn_77_n1 n_77 n_76 vss vss sky130_fd_pr__nfet_01v8 W=0.42 L=0.15
Xn_77_n2 n_77 n_1 vss vss sky130_fd_pr__nfet_01v8 W=0.42 L=0.15
Xn_78_n n_78 n_77 vss vss sky130_fd_pr__nfet_01v8 W=0.42 L=0.15
Xn_78_p n_78 n_77 vdd vdd sky130_fd_pr__pfet_01v8 W=0.7 L=0.15
Xn_80_p1 n_80 n_75 n_80_x vdd sky130_fd_pr__pfet_01v8 W=1.4 L=0.15
Xn_80_p2 n_80_x n_79 vdd vdd sky130_fd_pr__pfet_01v8 W=1.4 L=0.15
Xn_80_n1 n_80 n_75 vss vss sky130_fd_pr__nfet_01v8 W=0.42 L=0.15
Xn_80_n2 n_80 n_79 vss vss sky130_fd_pr__nfet_01v8 W=0.42 L=0.15
Xn_79_p1 n_79 n_78 n_79_x vdd sky130_fd_pr__pfet_01v8 W=1.4 L=0.15
Xn_79_p2 n_79_x n_80 vdd vdd sky130_fd_pr__pfet_01v8 W=1.4 L=0.15
Xn_79_n1 n_79 n_78 vss vss sky130_fd_pr__nfet_01v8 W=0.42 L=0.15
Xn_79_n2 n_79 n_80 vss vss sky130_fd_pr__nfet_01v8 W=0.42 L=0.15
Xn_81_p1 n_81 n_37 vdd vdd sky130_fd_pr__pfet_01v8 W=0.7 L=0.15
Xn_81_p2 n_81 n_44 vdd vdd sky130_fd_pr__pfet_01v8 W=0.7 L=0.15
Xn_81_n1 n_81 n_37 n_81_x vss sky130_fd_pr__nfet_01v8 W=0.84 L=0.15
Xn_81_n2 n_81_x n_44 vss vss sky130_fd_pr__nfet_01v8 W=0.84 L=0.15
Xn_82_n n_82 n_81 vss vss sky130_fd_pr__nfet_01v8 W=0.42 L=0.15
Xn_82_p n_82 n_81 vdd vdd sky130_fd_pr__pfet_01v8 W=0.7 L=0.15
Xn_83_p1 n_83 n_37 n_83_x vdd sky130_fd_pr__pfet_01v8 W=1.4 L=0.15
Xn_83_p2 n_83_x n_44 vdd vdd sky130_fd_pr__pfet_01v8 W=1.4 L=0.15
Xn_83_n1 n_83 n_37 vss vss sky130_fd_pr__nfet_01v8 W=0.42 L=0.15
Xn_83_n2 n_83 n_44 vss vss sky130_fd_pr__nfet_01v8 W=0.42 L=0.15
Xn_84_p1 n_84 n_83 n_84_x vdd sky130_fd_pr__pfet_01v8 W=1.4 L=0.15
Xn_84_p2 n_84_x n_1 vdd vdd sky130_fd_pr__pfet_01v8 W=1.4 L=0.15
Xn_84_n1 n_84 n_83 vss vss sky130_fd_pr__nfet_01v8 W=0.42 L=0.15
Xn_84_n2 n_84 n_1 vss vss sky130_fd_pr__nfet_01v8 W=0.42 L=0.15
Xn_85_n n_85 n_84 vss vss sky130_fd_pr__nfet_01v8 W=0.42 L=0.15
Xn_85_p n_85 n_84 vdd vdd sky130_fd_pr__pfet_01v8 W=0.7 L=0.15
Xn_87_p1 n_87 n_82 n_87_x vdd sky130_fd_pr__pfet_01v8 W=1.4 L=0.15
Xn_87_p2 n_87_x n_86 vdd vdd sky130_fd_pr__pfet_01v8 W=1.4 L=0.15
Xn_87_n1 n_87 n_82 vss vss sky130_fd_pr__nfet_01v8 W=0.42 L=0.15
Xn_87_n2 n_87 n_86 vss vss sky130_fd_pr__nfet_01v8 W=0.42 L=0.15
Xn_86_p1 n_86 n_85 n_86_x vdd sky130_fd_pr__pfet_01v8 W=1.4 L=0.15
Xn_86_p2 n_86_x n_87 vdd vdd sky130_fd_pr__pfet_01v8 W=1.4 L=0.15
Xn_86_n1 n_86 n_85 vss vss sky130_fd_pr__nfet_01v8 W=0.42 L=0.15
Xn_86_n2 n_86 n_87 vss vss sky130_fd_pr__nfet_01v8 W=0.42 L=0.15
Xn_88_p1 n_88 n_51 vdd vdd sky130_fd_pr__pfet_01v8 W=0.7 L=0.15
Xn_88_p2 n_88 n_58 vdd vdd sky130_fd_pr__pfet_01v8 W=0.7 L=0.15
Xn_88_n1 n_88 n_51 n_88_x vss sky130_fd_pr__nfet_01v8 W=0.84 L=0.15
Xn_88_n2 n_88_x n_58 vss vss sky130_fd_pr__nfet_01v8 W=0.84 L=0.15
Xn_89_n n_89 n_88 vss vss sky130_fd_pr__nfet_01v8 W=0.42 L=0.15
Xn_89_p n_89 n_88 vdd vdd sky130_fd_pr__pfet_01v8 W=0.7 L=0.15
Xn_90_p1 n_90 n_51 n_90_x vdd sky130_fd_pr__pfet_01v8 W=1.4 L=0.15
Xn_90_p2 n_90_x n_58 vdd vdd sky130_fd_pr__pfet_01v8 W=1.4 L=0.15
Xn_90_n1 n_90 n_51 vss vss sky130_fd_pr__nfet_01v8 W=0.42 L=0.15
Xn_90_n2 n_90 n_58 vss vss sky130_fd_pr__nfet_01v8 W=0.42 L=0.15
Xn_91_p1 n_91 n_90 n_91_x vdd sky130_fd_pr__pfet_01v8 W=1.4 L=0.15
Xn_91_p2 n_91_x n_1 vdd vdd sky130_fd_pr__pfet_01v8 W=1.4 L=0.15
Xn_91_n1 n_91 n_90 vss vss sky130_fd_pr__nfet_01v8 W=0.42 L=0.15
Xn_91_n2 n_91 n_1 vss vss sky130_fd_pr__nfet_01v8 W=0.42 L=0.15
Xn_92_n n_92 n_91 vss vss sky130_fd_pr__nfet_01v8 W=0.42 L=0.15
Xn_92_p n_92 n_91 vdd vdd sky130_fd_pr__pfet_01v8 W=0.7 L=0.15
Xn_94_p1 n_94 n_89 n_94_x vdd sky130_fd_pr__pfet_01v8 W=1.4 L=0.15
Xn_94_p2 n_94_x n_93 vdd vdd sky130_fd_pr__pfet_01v8 W=1.4 L=0.15
Xn_94_n1 n_94 n_89 vss vss sky130_fd_pr__nfet_01v8 W=0.42 L=0.15
Xn_94_n2 n_94 n_93 vss vss sky130_fd_pr__nfet_01v8 W=0.42 L=0.15
Xn_93_p1 n_93 n_92 n_93_x vdd sky130_fd_pr__pfet_01v8 W=1.4 L=0.15
Xn_93_p2 n_93_x n_94 vdd vdd sky130_fd_pr__pfet_01v8 W=1.4 L=0.15
Xn_93_n1 n_93 n_92 vss vss sky130_fd_pr__nfet_01v8 W=0.42 L=0.15
Xn_93_n2 n_93 n_94 vss vss sky130_fd_pr__nfet_01v8 W=0.42 L=0.15
Xn_95_p1 n_95 n_65 vdd vdd sky130_fd_pr__pfet_01v8 W=0.7 L=0.15
Xn_95_p2 n_95 n_72 vdd vdd sky130_fd_pr__pfet_01v8 W=0.7 L=0.15
Xn_95_n1 n_95 n_65 n_95_x vss sky130_fd_pr__nfet_01v8 W=0.84 L=0.15
Xn_95_n2 n_95_x n_72 vss vss sky130_fd_pr__nfet_01v8 W=0.84 L=0.15
Xn_96_n n_96 n_95 vss vss sky130_fd_pr__nfet_01v8 W=0.42 L=0.15
Xn_96_p n_96 n_95 vdd vdd sky130_fd_pr__pfet_01v8 W=0.7 L=0.15
Xn_97_p1 n_97 n_65 n_97_x vdd sky130_fd_pr__pfet_01v8 W=1.4 L=0.15
Xn_97_p2 n_97_x n_72 vdd vdd sky130_fd_pr__pfet_01v8 W=1.4 L=0.15
Xn_97_n1 n_97 n_65 vss vss sky130_fd_pr__nfet_01v8 W=0.42 L=0.15
Xn_97_n2 n_97 n_72 vss vss sky130_fd_pr__nfet_01v8 W=0.42 L=0.15
Xn_98_p1 n_98 n_97 n_98_x vdd sky130_fd_pr__pfet_01v8 W=1.4 L=0.15
Xn_98_p2 n_98_x n_1 vdd vdd sky130_fd_pr__pfet_01v8 W=1.4 L=0.15
Xn_98_n1 n_98 n_97 vss vss sky130_fd_pr__nfet_01v8 W=0.42 L=0.15
Xn_98_n2 n_98 n_1 vss vss sky130_fd_pr__nfet_01v8 W=0.42 L=0.15
Xn_99_n n_99 n_98 vss vss sky130_fd_pr__nfet_01v8 W=0.42 L=0.15
Xn_99_p n_99 n_98 vdd vdd sky130_fd_pr__pfet_01v8 W=0.7 L=0.15
Xn_101_p1 n_101 n_96 n_101_x vdd sky130_fd_pr__pfet_01v8 W=1.4 L=0.15
Xn_101_p2 n_101_x n_100 vdd vdd sky130_fd_pr__pfet_01v8 W=1.4 L=0.15
Xn_101_n1 n_101 n_96 vss vss sky130_fd_pr__nfet_01v8 W=0.42 L=0.15
Xn_101_n2 n_101 n_100 vss vss sky130_fd_pr__nfet_01v8 W=0.42 L=0.15
Xn_100_p1 n_100 n_99 n_100_x vdd sky130_fd_pr__pfet_01v8 W=1.4 L=0.15
Xn_100_p2 n_100_x n_101 vdd vdd sky130_fd_pr__pfet_01v8 W=1.4 L=0.15
Xn_100_n1 n_100 n_99 vss vss sky130_fd_pr__nfet_01v8 W=0.42 L=0.15
Xn_100_n2 n_100 n_101 vss vss sky130_fd_pr__nfet_01v8 W=0.42 L=0.15
Xn_102_p1 n_102 n_79 vdd vdd sky130_fd_pr__pfet_01v8 W=0.7 L=0.15
Xn_102_p2 n_102 n_86 vdd vdd sky130_fd_pr__pfet_01v8 W=0.7 L=0.15
Xn_102_n1 n_102 n_79 n_102_x vss sky130_fd_pr__nfet_01v8 W=0.84 L=0.15
Xn_102_n2 n_102_x n_86 vss vss sky130_fd_pr__nfet_01v8 W=0.84 L=0.15
Xn_103_n n_103 n_102 vss vss sky130_fd_pr__nfet_01v8 W=0.42 L=0.15
Xn_103_p n_103 n_102 vdd vdd sky130_fd_pr__pfet_01v8 W=0.7 L=0.15
Xn_104_p1 n_104 n_79 n_104_x vdd sky130_fd_pr__pfet_01v8 W=1.4 L=0.15
Xn_104_p2 n_104_x n_86 vdd vdd sky130_fd_pr__pfet_01v8 W=1.4 L=0.15
Xn_104_n1 n_104 n_79 vss vss sky130_fd_pr__nfet_01v8 W=0.42 L=0.15
Xn_104_n2 n_104 n_86 vss vss sky130_fd_pr__nfet_01v8 W=0.42 L=0.15
Xn_105_p1 n_105 n_104 n_105_x vdd sky130_fd_pr__pfet_01v8 W=1.4 L=0.15
Xn_105_p2 n_105_x n_1 vdd vdd sky130_fd_pr__pfet_01v8 W=1.4 L=0.15
Xn_105_n1 n_105 n_104 vss vss sky130_fd_pr__nfet_01v8 W=0.42 L=0.15
Xn_105_n2 n_105 n_1 vss vss sky130_fd_pr__nfet_01v8 W=0.42 L=0.15
Xn_106_n n_106 n_105 vss vss sky130_fd_pr__nfet_01v8 W=0.42 L=0.15
Xn_106_p n_106 n_105 vdd vdd sky130_fd_pr__pfet_01v8 W=0.7 L=0.15
Xn_108_p1 n_108 n_103 n_108_x vdd sky130_fd_pr__pfet_01v8 W=1.4 L=0.15
Xn_108_p2 n_108_x n_107 vdd vdd sky130_fd_pr__pfet_01v8 W=1.4 L=0.15
Xn_108_n1 n_108 n_103 vss vss sky130_fd_pr__nfet_01v8 W=0.42 L=0.15
Xn_108_n2 n_108 n_107 vss vss sky130_fd_pr__nfet_01v8 W=0.42 L=0.15
Xn_107_p1 n_107 n_106 n_107_x vdd sky130_fd_pr__pfet_01v8 W=1.4 L=0.15
Xn_107_p2 n_107_x n_108 vdd vdd sky130_fd_pr__pfet_01v8 W=1.4 L=0.15
Xn_107_n1 n_107 n_106 vss vss sky130_fd_pr__nfet_01v8 W=0.42 L=0.15
Xn_107_n2 n_107 n_108 vss vss sky130_fd_pr__nfet_01v8 W=0.42 L=0.15
Xn_109_p1 n_109 n_93 vdd vdd sky130_fd_pr__pfet_01v8 W=0.7 L=0.15
Xn_109_p2 n_109 n_100 vdd vdd sky130_fd_pr__pfet_01v8 W=0.7 L=0.15
Xn_109_n1 n_109 n_93 n_109_x vss sky130_fd_pr__nfet_01v8 W=0.84 L=0.15
Xn_109_n2 n_109_x n_100 vss vss sky130_fd_pr__nfet_01v8 W=0.84 L=0.15
Xn_110_n n_110 n_109 vss vss sky130_fd_pr__nfet_01v8 W=0.42 L=0.15
Xn_110_p n_110 n_109 vdd vdd sky130_fd_pr__pfet_01v8 W=0.7 L=0.15
Xn_111_p1 n_111 n_93 n_111_x vdd sky130_fd_pr__pfet_01v8 W=1.4 L=0.15
Xn_111_p2 n_111_x n_100 vdd vdd sky130_fd_pr__pfet_01v8 W=1.4 L=0.15
Xn_111_n1 n_111 n_93 vss vss sky130_fd_pr__nfet_01v8 W=0.42 L=0.15
Xn_111_n2 n_111 n_100 vss vss sky130_fd_pr__nfet_01v8 W=0.42 L=0.15
Xn_112_p1 n_112 n_111 n_112_x vdd sky130_fd_pr__pfet_01v8 W=1.4 L=0.15
Xn_112_p2 n_112_x n_1 vdd vdd sky130_fd_pr__pfet_01v8 W=1.4 L=0.15
Xn_112_n1 n_112 n_111 vss vss sky130_fd_pr__nfet_01v8 W=0.42 L=0.15
Xn_112_n2 n_112 n_1 vss vss sky130_fd_pr__nfet_01v8 W=0.42 L=0.15
Xn_113_n n_113 n_112 vss vss sky130_fd_pr__nfet_01v8 W=0.42 L=0.15
Xn_113_p n_113 n_112 vdd vdd sky130_fd_pr__pfet_01v8 W=0.7 L=0.15
Xn_115_p1 n_115 n_110 n_115_x vdd sky130_fd_pr__pfet_01v8 W=1.4 L=0.15
Xn_115_p2 n_115_x n_114 vdd vdd sky130_fd_pr__pfet_01v8 W=1.4 L=0.15
Xn_115_n1 n_115 n_110 vss vss sky130_fd_pr__nfet_01v8 W=0.42 L=0.15
Xn_115_n2 n_115 n_114 vss vss sky130_fd_pr__nfet_01v8 W=0.42 L=0.15
Xn_114_p1 n_114 n_113 n_114_x vdd sky130_fd_pr__pfet_01v8 W=1.4 L=0.15
Xn_114_p2 n_114_x n_115 vdd vdd sky130_fd_pr__pfet_01v8 W=1.4 L=0.15
Xn_114_n1 n_114 n_113 vss vss sky130_fd_pr__nfet_01v8 W=0.42 L=0.15
Xn_114_n2 n_114 n_115 vss vss sky130_fd_pr__nfet_01v8 W=0.42 L=0.15
Xn_116_p1 n_116 n_107 vdd vdd sky130_fd_pr__pfet_01v8 W=0.7 L=0.15
Xn_116_p2 n_116 n_114 vdd vdd sky130_fd_pr__pfet_01v8 W=0.7 L=0.15
Xn_116_n1 n_116 n_107 n_116_x vss sky130_fd_pr__nfet_01v8 W=0.84 L=0.15
Xn_116_n2 n_116_x n_114 vss vss sky130_fd_pr__nfet_01v8 W=0.84 L=0.15
Xn_117_n n_117 n_116 vss vss sky130_fd_pr__nfet_01v8 W=0.42 L=0.15
Xn_117_p n_117 n_116 vdd vdd sky130_fd_pr__pfet_01v8 W=0.7 L=0.15
Xn_118_p1 n_118 n_107 n_118_x vdd sky130_fd_pr__pfet_01v8 W=1.4 L=0.15
Xn_118_p2 n_118_x n_114 vdd vdd sky130_fd_pr__pfet_01v8 W=1.4 L=0.15
Xn_118_n1 n_118 n_107 vss vss sky130_fd_pr__nfet_01v8 W=0.42 L=0.15
Xn_118_n2 n_118 n_114 vss vss sky130_fd_pr__nfet_01v8 W=0.42 L=0.15
Xn_119_p1 n_119 n_118 n_119_x vdd sky130_fd_pr__pfet_01v8 W=1.4 L=0.15
Xn_119_p2 n_119_x n_1 vdd vdd sky130_fd_pr__pfet_01v8 W=1.4 L=0.15
Xn_119_n1 n_119 n_118 vss vss sky130_fd_pr__nfet_01v8 W=0.42 L=0.15
Xn_119_n2 n_119 n_1 vss vss sky130_fd_pr__nfet_01v8 W=0.42 L=0.15
Xn_120_n n_120 n_119 vss vss sky130_fd_pr__nfet_01v8 W=0.42 L=0.15
Xn_120_p n_120 n_119 vdd vdd sky130_fd_pr__pfet_01v8 W=0.7 L=0.15
Xn_122_p1 n_122 n_117 n_122_x vdd sky130_fd_pr__pfet_01v8 W=1.4 L=0.15
Xn_122_p2 n_122_x n_121 vdd vdd sky130_fd_pr__pfet_01v8 W=1.4 L=0.15
Xn_122_n1 n_122 n_117 vss vss sky130_fd_pr__nfet_01v8 W=0.42 L=0.15
Xn_122_n2 n_122 n_121 vss vss sky130_fd_pr__nfet_01v8 W=0.42 L=0.15
Xn_121_p1 n_121 n_120 n_121_x vdd sky130_fd_pr__pfet_01v8 W=1.4 L=0.15
Xn_121_p2 n_121_x n_122 vdd vdd sky130_fd_pr__pfet_01v8 W=1.4 L=0.15
Xn_121_n1 n_121 n_120 vss vss sky130_fd_pr__nfet_01v8 W=0.42 L=0.15
Xn_121_n2 n_121 n_122 vss vss sky130_fd_pr__nfet_01v8 W=0.42 L=0.15
Xn_123_p1 n_123 n_121 vdd vdd sky130_fd_pr__pfet_01v8 W=0.7 L=0.15
Xn_123_p2 n_123 sdone16 vdd vdd sky130_fd_pr__pfet_01v8 W=0.7 L=0.15
Xn_123_n1 n_123 n_121 n_123_x vss sky130_fd_pr__nfet_01v8 W=0.84 L=0.15
Xn_123_n2 n_123_x sdone16 vss vss sky130_fd_pr__nfet_01v8 W=0.84 L=0.15
Xn_124_n n_124 n_123 vss vss sky130_fd_pr__nfet_01v8 W=0.42 L=0.15
Xn_124_p n_124 n_123 vdd vdd sky130_fd_pr__pfet_01v8 W=0.7 L=0.15
Xn_125_p1 n_125 n_121 n_125_x vdd sky130_fd_pr__pfet_01v8 W=1.4 L=0.15
Xn_125_p2 n_125_x sdone16 vdd vdd sky130_fd_pr__pfet_01v8 W=1.4 L=0.15
Xn_125_n1 n_125 n_121 vss vss sky130_fd_pr__nfet_01v8 W=0.42 L=0.15
Xn_125_n2 n_125 sdone16 vss vss sky130_fd_pr__nfet_01v8 W=0.42 L=0.15
Xn_126_p1 n_126 n_125 n_126_x vdd sky130_fd_pr__pfet_01v8 W=1.4 L=0.15
Xn_126_p2 n_126_x n_1 vdd vdd sky130_fd_pr__pfet_01v8 W=1.4 L=0.15
Xn_126_n1 n_126 n_125 vss vss sky130_fd_pr__nfet_01v8 W=0.42 L=0.15
Xn_126_n2 n_126 n_1 vss vss sky130_fd_pr__nfet_01v8 W=0.42 L=0.15
Xn_127_n n_127 n_126 vss vss sky130_fd_pr__nfet_01v8 W=0.42 L=0.15
Xn_127_p n_127 n_126 vdd vdd sky130_fd_pr__pfet_01v8 W=0.7 L=0.15
Xn_129_p1 n_129 n_124 n_129_x vdd sky130_fd_pr__pfet_01v8 W=1.4 L=0.15
Xn_129_p2 n_129_x n_128 vdd vdd sky130_fd_pr__pfet_01v8 W=1.4 L=0.15
Xn_129_n1 n_129 n_124 vss vss sky130_fd_pr__nfet_01v8 W=0.42 L=0.15
Xn_129_n2 n_129 n_128 vss vss sky130_fd_pr__nfet_01v8 W=0.42 L=0.15
Xn_128_p1 n_128 n_127 n_128_x vdd sky130_fd_pr__pfet_01v8 W=1.4 L=0.15
Xn_128_p2 n_128_x n_129 vdd vdd sky130_fd_pr__pfet_01v8 W=1.4 L=0.15
Xn_128_n1 n_128 n_127 vss vss sky130_fd_pr__nfet_01v8 W=0.42 L=0.15
Xn_128_n2 n_128 n_129 vss vss sky130_fd_pr__nfet_01v8 W=0.42 L=0.15
Xn_131_p1 n_131 n_128 vdd vdd sky130_fd_pr__pfet_01v8 W=0.7 L=0.15
Xn_131_p2 n_131 n_130 vdd vdd sky130_fd_pr__pfet_01v8 W=0.7 L=0.15
Xn_131_n1 n_131 n_128 n_131_x vss sky130_fd_pr__nfet_01v8 W=0.84 L=0.15
Xn_131_n2 n_131_x n_130 vss vss sky130_fd_pr__nfet_01v8 W=0.84 L=0.15
Xn_132_n n_132 n_131 vss vss sky130_fd_pr__nfet_01v8 W=0.42 L=0.15
Xn_132_p n_132 n_131 vdd vdd sky130_fd_pr__pfet_01v8 W=0.7 L=0.15
Xn_133_p1 n_133 n_16 vdd vdd sky130_fd_pr__pfet_01v8 W=0.7 L=0.15
Xn_133_p2 n_133 n_132 vdd vdd sky130_fd_pr__pfet_01v8 W=0.7 L=0.15
Xn_133_n1 n_133 n_16 n_133_x vss sky130_fd_pr__nfet_01v8 W=0.84 L=0.15
Xn_133_n2 n_133_x n_132 vss vss sky130_fd_pr__nfet_01v8 W=0.84 L=0.15
Xadc_done_n adc_done n_133 vss vss sky130_fd_pr__nfet_01v8 W=0.42 L=0.15
Xadc_done_p adc_done n_133 vdd vdd sky130_fd_pr__pfet_01v8 W=0.7 L=0.15
Xn_134_p1 n_134 integ_req n_134_x vdd sky130_fd_pr__pfet_01v8 W=1.4 L=0.15
Xn_134_p2 n_134_x integ_ack vdd vdd sky130_fd_pr__pfet_01v8 W=1.4 L=0.15
Xn_134_n1 n_134 integ_req vss vss sky130_fd_pr__nfet_01v8 W=0.42 L=0.15
Xn_134_n2 n_134 integ_ack vss vss sky130_fd_pr__nfet_01v8 W=0.42 L=0.15
Xn_135_n n_135 n_134 vss vss sky130_fd_pr__nfet_01v8 W=0.42 L=0.15
Xn_135_p n_135 n_134 vdd vdd sky130_fd_pr__pfet_01v8 W=0.7 L=0.15
Xn_136_p1 n_136 busy0 n_136_x vdd sky130_fd_pr__pfet_01v8 W=1.4 L=0.15
Xn_136_p2 n_136_x busy1 vdd vdd sky130_fd_pr__pfet_01v8 W=1.4 L=0.15
Xn_136_n1 n_136 busy0 vss vss sky130_fd_pr__nfet_01v8 W=0.42 L=0.15
Xn_136_n2 n_136 busy1 vss vss sky130_fd_pr__nfet_01v8 W=0.42 L=0.15
Xn_137_n n_137 n_136 vss vss sky130_fd_pr__nfet_01v8 W=0.42 L=0.15
Xn_137_p n_137 n_136 vdd vdd sky130_fd_pr__pfet_01v8 W=0.7 L=0.15
Xn_138_p1 n_138 busy2 n_138_x vdd sky130_fd_pr__pfet_01v8 W=1.4 L=0.15
Xn_138_p2 n_138_x busy3 vdd vdd sky130_fd_pr__pfet_01v8 W=1.4 L=0.15
Xn_138_n1 n_138 busy2 vss vss sky130_fd_pr__nfet_01v8 W=0.42 L=0.15
Xn_138_n2 n_138 busy3 vss vss sky130_fd_pr__nfet_01v8 W=0.42 L=0.15
Xn_139_n n_139 n_138 vss vss sky130_fd_pr__nfet_01v8 W=0.42 L=0.15
Xn_139_p n_139 n_138 vdd vdd sky130_fd_pr__pfet_01v8 W=0.7 L=0.15
Xn_140_p1 n_140 busy4 n_140_x vdd sky130_fd_pr__pfet_01v8 W=1.4 L=0.15
Xn_140_p2 n_140_x busy5 vdd vdd sky130_fd_pr__pfet_01v8 W=1.4 L=0.15
Xn_140_n1 n_140 busy4 vss vss sky130_fd_pr__nfet_01v8 W=0.42 L=0.15
Xn_140_n2 n_140 busy5 vss vss sky130_fd_pr__nfet_01v8 W=0.42 L=0.15
Xn_141_n n_141 n_140 vss vss sky130_fd_pr__nfet_01v8 W=0.42 L=0.15
Xn_141_p n_141 n_140 vdd vdd sky130_fd_pr__pfet_01v8 W=0.7 L=0.15
Xn_142_p1 n_142 busy6 n_142_x vdd sky130_fd_pr__pfet_01v8 W=1.4 L=0.15
Xn_142_p2 n_142_x busy7 vdd vdd sky130_fd_pr__pfet_01v8 W=1.4 L=0.15
Xn_142_n1 n_142 busy6 vss vss sky130_fd_pr__nfet_01v8 W=0.42 L=0.15
Xn_142_n2 n_142 busy7 vss vss sky130_fd_pr__nfet_01v8 W=0.42 L=0.15
Xn_143_n n_143 n_142 vss vss sky130_fd_pr__nfet_01v8 W=0.42 L=0.15
Xn_143_p n_143 n_142 vdd vdd sky130_fd_pr__pfet_01v8 W=0.7 L=0.15
Xn_144_p1 n_144 busy8 n_144_x vdd sky130_fd_pr__pfet_01v8 W=1.4 L=0.15
Xn_144_p2 n_144_x busy9 vdd vdd sky130_fd_pr__pfet_01v8 W=1.4 L=0.15
Xn_144_n1 n_144 busy8 vss vss sky130_fd_pr__nfet_01v8 W=0.42 L=0.15
Xn_144_n2 n_144 busy9 vss vss sky130_fd_pr__nfet_01v8 W=0.42 L=0.15
Xn_145_n n_145 n_144 vss vss sky130_fd_pr__nfet_01v8 W=0.42 L=0.15
Xn_145_p n_145 n_144 vdd vdd sky130_fd_pr__pfet_01v8 W=0.7 L=0.15
Xn_146_p1 n_146 busy10 n_146_x vdd sky130_fd_pr__pfet_01v8 W=1.4 L=0.15
Xn_146_p2 n_146_x busy11 vdd vdd sky130_fd_pr__pfet_01v8 W=1.4 L=0.15
Xn_146_n1 n_146 busy10 vss vss sky130_fd_pr__nfet_01v8 W=0.42 L=0.15
Xn_146_n2 n_146 busy11 vss vss sky130_fd_pr__nfet_01v8 W=0.42 L=0.15
Xn_147_n n_147 n_146 vss vss sky130_fd_pr__nfet_01v8 W=0.42 L=0.15
Xn_147_p n_147 n_146 vdd vdd sky130_fd_pr__pfet_01v8 W=0.7 L=0.15
Xn_148_p1 n_148 busy12 n_148_x vdd sky130_fd_pr__pfet_01v8 W=1.4 L=0.15
Xn_148_p2 n_148_x busy13 vdd vdd sky130_fd_pr__pfet_01v8 W=1.4 L=0.15
Xn_148_n1 n_148 busy12 vss vss sky130_fd_pr__nfet_01v8 W=0.42 L=0.15
Xn_148_n2 n_148 busy13 vss vss sky130_fd_pr__nfet_01v8 W=0.42 L=0.15
Xn_149_n n_149 n_148 vss vss sky130_fd_pr__nfet_01v8 W=0.42 L=0.15
Xn_149_p n_149 n_148 vdd vdd sky130_fd_pr__pfet_01v8 W=0.7 L=0.15
Xn_150_p1 n_150 busy14 n_150_x vdd sky130_fd_pr__pfet_01v8 W=1.4 L=0.15
Xn_150_p2 n_150_x busy15 vdd vdd sky130_fd_pr__pfet_01v8 W=1.4 L=0.15
Xn_150_n1 n_150 busy14 vss vss sky130_fd_pr__nfet_01v8 W=0.42 L=0.15
Xn_150_n2 n_150 busy15 vss vss sky130_fd_pr__nfet_01v8 W=0.42 L=0.15
Xn_151_n n_151 n_150 vss vss sky130_fd_pr__nfet_01v8 W=0.42 L=0.15
Xn_151_p n_151 n_150 vdd vdd sky130_fd_pr__pfet_01v8 W=0.7 L=0.15
Xn_152_p1 n_152 n_135 n_152_x vdd sky130_fd_pr__pfet_01v8 W=1.4 L=0.15
Xn_152_p2 n_152_x n_137 vdd vdd sky130_fd_pr__pfet_01v8 W=1.4 L=0.15
Xn_152_n1 n_152 n_135 vss vss sky130_fd_pr__nfet_01v8 W=0.42 L=0.15
Xn_152_n2 n_152 n_137 vss vss sky130_fd_pr__nfet_01v8 W=0.42 L=0.15
Xn_153_n n_153 n_152 vss vss sky130_fd_pr__nfet_01v8 W=0.42 L=0.15
Xn_153_p n_153 n_152 vdd vdd sky130_fd_pr__pfet_01v8 W=0.7 L=0.15
Xn_154_p1 n_154 n_139 n_154_x vdd sky130_fd_pr__pfet_01v8 W=1.4 L=0.15
Xn_154_p2 n_154_x n_141 vdd vdd sky130_fd_pr__pfet_01v8 W=1.4 L=0.15
Xn_154_n1 n_154 n_139 vss vss sky130_fd_pr__nfet_01v8 W=0.42 L=0.15
Xn_154_n2 n_154 n_141 vss vss sky130_fd_pr__nfet_01v8 W=0.42 L=0.15
Xn_155_n n_155 n_154 vss vss sky130_fd_pr__nfet_01v8 W=0.42 L=0.15
Xn_155_p n_155 n_154 vdd vdd sky130_fd_pr__pfet_01v8 W=0.7 L=0.15
Xn_156_p1 n_156 n_143 n_156_x vdd sky130_fd_pr__pfet_01v8 W=1.4 L=0.15
Xn_156_p2 n_156_x n_145 vdd vdd sky130_fd_pr__pfet_01v8 W=1.4 L=0.15
Xn_156_n1 n_156 n_143 vss vss sky130_fd_pr__nfet_01v8 W=0.42 L=0.15
Xn_156_n2 n_156 n_145 vss vss sky130_fd_pr__nfet_01v8 W=0.42 L=0.15
Xn_157_n n_157 n_156 vss vss sky130_fd_pr__nfet_01v8 W=0.42 L=0.15
Xn_157_p n_157 n_156 vdd vdd sky130_fd_pr__pfet_01v8 W=0.7 L=0.15
Xn_158_p1 n_158 n_147 n_158_x vdd sky130_fd_pr__pfet_01v8 W=1.4 L=0.15
Xn_158_p2 n_158_x n_149 vdd vdd sky130_fd_pr__pfet_01v8 W=1.4 L=0.15
Xn_158_n1 n_158 n_147 vss vss sky130_fd_pr__nfet_01v8 W=0.42 L=0.15
Xn_158_n2 n_158 n_149 vss vss sky130_fd_pr__nfet_01v8 W=0.42 L=0.15
Xn_159_n n_159 n_158 vss vss sky130_fd_pr__nfet_01v8 W=0.42 L=0.15
Xn_159_p n_159 n_158 vdd vdd sky130_fd_pr__pfet_01v8 W=0.7 L=0.15
Xn_160_p1 n_160 n_151 n_160_x vdd sky130_fd_pr__pfet_01v8 W=1.4 L=0.15
Xn_160_p2 n_160_x busy16 vdd vdd sky130_fd_pr__pfet_01v8 W=1.4 L=0.15
Xn_160_n1 n_160 n_151 vss vss sky130_fd_pr__nfet_01v8 W=0.42 L=0.15
Xn_160_n2 n_160 busy16 vss vss sky130_fd_pr__nfet_01v8 W=0.42 L=0.15
Xn_161_n n_161 n_160 vss vss sky130_fd_pr__nfet_01v8 W=0.42 L=0.15
Xn_161_p n_161 n_160 vdd vdd sky130_fd_pr__pfet_01v8 W=0.7 L=0.15
Xn_162_p1 n_162 n_153 n_162_x vdd sky130_fd_pr__pfet_01v8 W=1.4 L=0.15
Xn_162_p2 n_162_x n_155 vdd vdd sky130_fd_pr__pfet_01v8 W=1.4 L=0.15
Xn_162_n1 n_162 n_153 vss vss sky130_fd_pr__nfet_01v8 W=0.42 L=0.15
Xn_162_n2 n_162 n_155 vss vss sky130_fd_pr__nfet_01v8 W=0.42 L=0.15
Xn_163_n n_163 n_162 vss vss sky130_fd_pr__nfet_01v8 W=0.42 L=0.15
Xn_163_p n_163 n_162 vdd vdd sky130_fd_pr__pfet_01v8 W=0.7 L=0.15
Xn_164_p1 n_164 n_157 n_164_x vdd sky130_fd_pr__pfet_01v8 W=1.4 L=0.15
Xn_164_p2 n_164_x n_159 vdd vdd sky130_fd_pr__pfet_01v8 W=1.4 L=0.15
Xn_164_n1 n_164 n_157 vss vss sky130_fd_pr__nfet_01v8 W=0.42 L=0.15
Xn_164_n2 n_164 n_159 vss vss sky130_fd_pr__nfet_01v8 W=0.42 L=0.15
Xn_165_n n_165 n_164 vss vss sky130_fd_pr__nfet_01v8 W=0.42 L=0.15
Xn_165_p n_165 n_164 vdd vdd sky130_fd_pr__pfet_01v8 W=0.7 L=0.15
Xn_166_p1 n_166 n_163 n_166_x vdd sky130_fd_pr__pfet_01v8 W=1.4 L=0.15
Xn_166_p2 n_166_x n_165 vdd vdd sky130_fd_pr__pfet_01v8 W=1.4 L=0.15
Xn_166_n1 n_166 n_163 vss vss sky130_fd_pr__nfet_01v8 W=0.42 L=0.15
Xn_166_n2 n_166 n_165 vss vss sky130_fd_pr__nfet_01v8 W=0.42 L=0.15
Xn_167_n n_167 n_166 vss vss sky130_fd_pr__nfet_01v8 W=0.42 L=0.15
Xn_167_p n_167 n_166 vdd vdd sky130_fd_pr__pfet_01v8 W=0.7 L=0.15
Xn_168_p1 n_168 n_167 n_168_x vdd sky130_fd_pr__pfet_01v8 W=1.4 L=0.15
Xn_168_p2 n_168_x n_161 vdd vdd sky130_fd_pr__pfet_01v8 W=1.4 L=0.15
Xn_168_n1 n_168 n_167 vss vss sky130_fd_pr__nfet_01v8 W=0.42 L=0.15
Xn_168_n2 n_168 n_161 vss vss sky130_fd_pr__nfet_01v8 W=0.42 L=0.15
Xn_169_n n_169 n_168 vss vss sky130_fd_pr__nfet_01v8 W=0.42 L=0.15
Xn_169_p n_169 n_168 vdd vdd sky130_fd_pr__pfet_01v8 W=0.7 L=0.15
Xclose_p1 in n_169 vdd vdd sky130_fd_pr__pfet_01v8 W=2.32 L=0.15
Xclose_p2 in tap4 vdd vdd sky130_fd_pr__pfet_01v8 W=2.32 L=0.15
Xclose_n1 in n_169 close_x vss sky130_fd_pr__nfet_01v8 W=1.68 L=0.15
Xclose_n2 close_x tap4 vss vss sky130_fd_pr__nfet_01v8 W=1.68 L=0.15
Xclose_c in vss sky130_fd_pr__cap_mim_m3_1 W=35.73 L=35.73
Xn_170_n n_170 in vss vss sky130_fd_pr__nfet_01v8 W=0.42 L=0.15
Xn_170_p n_170 in vdd vdd sky130_fd_pr__pfet_01v8 W=0.7 L=0.15
Xn_171_n n_171 tap1 vss vss sky130_fd_pr__nfet_01v8 W=0.42 L=0.15
Xn_171_p n_171 tap1 vdd vdd sky130_fd_pr__pfet_01v8 W=0.7 L=0.15
Xn_172_n n_172 tap2 vss vss sky130_fd_pr__nfet_01v8 W=0.42 L=0.15
Xn_172_p n_172 tap2 vdd vdd sky130_fd_pr__pfet_01v8 W=0.7 L=0.15
Xn_173_n n_173 tap3 vss vss sky130_fd_pr__nfet_01v8 W=0.42 L=0.15
Xn_173_p n_173 tap3 vdd vdd sky130_fd_pr__pfet_01v8 W=0.7 L=0.15
Xn_174_n n_174 tap4 vss vss sky130_fd_pr__nfet_01v8 W=0.42 L=0.15
Xn_174_p n_174 tap4 vdd vdd sky130_fd_pr__pfet_01v8 W=0.7 L=0.15
Xn_175_p1 n_175 n_170 vdd vdd sky130_fd_pr__pfet_01v8 W=0.7 L=0.15
Xn_175_p2 n_175 n_171 vdd vdd sky130_fd_pr__pfet_01v8 W=0.7 L=0.15
Xn_175_n1 n_175 n_170 n_175_x vss sky130_fd_pr__nfet_01v8 W=0.84 L=0.15
Xn_175_n2 n_175_x n_171 vss vss sky130_fd_pr__nfet_01v8 W=0.84 L=0.15
Xn_176_p1 n_176 n_170 vdd vdd sky130_fd_pr__pfet_01v8 W=0.7 L=0.15
Xn_176_p2 n_176 n_175 vdd vdd sky130_fd_pr__pfet_01v8 W=0.7 L=0.15
Xn_176_n1 n_176 n_170 n_176_x vss sky130_fd_pr__nfet_01v8 W=0.84 L=0.15
Xn_176_n2 n_176_x n_175 vss vss sky130_fd_pr__nfet_01v8 W=0.84 L=0.15
Xn_177_p1 n_177 n_171 vdd vdd sky130_fd_pr__pfet_01v8 W=0.7 L=0.15
Xn_177_p2 n_177 n_175 vdd vdd sky130_fd_pr__pfet_01v8 W=0.7 L=0.15
Xn_177_n1 n_177 n_171 n_177_x vss sky130_fd_pr__nfet_01v8 W=0.84 L=0.15
Xn_177_n2 n_177_x n_175 vss vss sky130_fd_pr__nfet_01v8 W=0.84 L=0.15
Xn_178_p1 n_178 n_176 vdd vdd sky130_fd_pr__pfet_01v8 W=0.7 L=0.15
Xn_178_p2 n_178 n_177 vdd vdd sky130_fd_pr__pfet_01v8 W=0.7 L=0.15
Xn_178_n1 n_178 n_176 n_178_x vss sky130_fd_pr__nfet_01v8 W=0.84 L=0.15
Xn_178_n2 n_178_x n_177 vss vss sky130_fd_pr__nfet_01v8 W=0.84 L=0.15
Xn_179_p1 n_179 n_172 vdd vdd sky130_fd_pr__pfet_01v8 W=0.7 L=0.15
Xn_179_p2 n_179 n_173 vdd vdd sky130_fd_pr__pfet_01v8 W=0.7 L=0.15
Xn_179_n1 n_179 n_172 n_179_x vss sky130_fd_pr__nfet_01v8 W=0.84 L=0.15
Xn_179_n2 n_179_x n_173 vss vss sky130_fd_pr__nfet_01v8 W=0.84 L=0.15
Xn_180_p1 n_180 n_172 vdd vdd sky130_fd_pr__pfet_01v8 W=0.7 L=0.15
Xn_180_p2 n_180 n_179 vdd vdd sky130_fd_pr__pfet_01v8 W=0.7 L=0.15
Xn_180_n1 n_180 n_172 n_180_x vss sky130_fd_pr__nfet_01v8 W=0.84 L=0.15
Xn_180_n2 n_180_x n_179 vss vss sky130_fd_pr__nfet_01v8 W=0.84 L=0.15
Xn_181_p1 n_181 n_173 vdd vdd sky130_fd_pr__pfet_01v8 W=0.7 L=0.15
Xn_181_p2 n_181 n_179 vdd vdd sky130_fd_pr__pfet_01v8 W=0.7 L=0.15
Xn_181_n1 n_181 n_173 n_181_x vss sky130_fd_pr__nfet_01v8 W=0.84 L=0.15
Xn_181_n2 n_181_x n_179 vss vss sky130_fd_pr__nfet_01v8 W=0.84 L=0.15
Xn_182_p1 n_182 n_180 vdd vdd sky130_fd_pr__pfet_01v8 W=0.7 L=0.15
Xn_182_p2 n_182 n_181 vdd vdd sky130_fd_pr__pfet_01v8 W=0.7 L=0.15
Xn_182_n1 n_182 n_180 n_182_x vss sky130_fd_pr__nfet_01v8 W=0.84 L=0.15
Xn_182_n2 n_182_x n_181 vss vss sky130_fd_pr__nfet_01v8 W=0.84 L=0.15
Xn_183_p1 n_183 n_178 vdd vdd sky130_fd_pr__pfet_01v8 W=0.7 L=0.15
Xn_183_p2 n_183 n_182 vdd vdd sky130_fd_pr__pfet_01v8 W=0.7 L=0.15
Xn_183_n1 n_183 n_178 n_183_x vss sky130_fd_pr__nfet_01v8 W=0.84 L=0.15
Xn_183_n2 n_183_x n_182 vss vss sky130_fd_pr__nfet_01v8 W=0.84 L=0.15
Xn_184_p1 n_184 n_178 vdd vdd sky130_fd_pr__pfet_01v8 W=0.7 L=0.15
Xn_184_p2 n_184 n_183 vdd vdd sky130_fd_pr__pfet_01v8 W=0.7 L=0.15
Xn_184_n1 n_184 n_178 n_184_x vss sky130_fd_pr__nfet_01v8 W=0.84 L=0.15
Xn_184_n2 n_184_x n_183 vss vss sky130_fd_pr__nfet_01v8 W=0.84 L=0.15
Xn_185_p1 n_185 n_182 vdd vdd sky130_fd_pr__pfet_01v8 W=0.7 L=0.15
Xn_185_p2 n_185 n_183 vdd vdd sky130_fd_pr__pfet_01v8 W=0.7 L=0.15
Xn_185_n1 n_185 n_182 n_185_x vss sky130_fd_pr__nfet_01v8 W=0.84 L=0.15
Xn_185_n2 n_185_x n_183 vss vss sky130_fd_pr__nfet_01v8 W=0.84 L=0.15
Xn_186_p1 n_186 n_184 vdd vdd sky130_fd_pr__pfet_01v8 W=0.7 L=0.15
Xn_186_p2 n_186 n_185 vdd vdd sky130_fd_pr__pfet_01v8 W=0.7 L=0.15
Xn_186_n1 n_186 n_184 n_186_x vss sky130_fd_pr__nfet_01v8 W=0.84 L=0.15
Xn_186_n2 n_186_x n_185 vss vss sky130_fd_pr__nfet_01v8 W=0.84 L=0.15
Xn_187_p1 n_187 n_186 vdd vdd sky130_fd_pr__pfet_01v8 W=0.7 L=0.15
Xn_187_p2 n_187 n_174 vdd vdd sky130_fd_pr__pfet_01v8 W=0.7 L=0.15
Xn_187_n1 n_187 n_186 n_187_x vss sky130_fd_pr__nfet_01v8 W=0.84 L=0.15
Xn_187_n2 n_187_x n_174 vss vss sky130_fd_pr__nfet_01v8 W=0.84 L=0.15
Xn_188_p1 n_188 n_186 vdd vdd sky130_fd_pr__pfet_01v8 W=0.7 L=0.15
Xn_188_p2 n_188 n_187 vdd vdd sky130_fd_pr__pfet_01v8 W=0.7 L=0.15
Xn_188_n1 n_188 n_186 n_188_x vss sky130_fd_pr__nfet_01v8 W=0.84 L=0.15
Xn_188_n2 n_188_x n_187 vss vss sky130_fd_pr__nfet_01v8 W=0.84 L=0.15
Xn_189_p1 n_189 n_174 vdd vdd sky130_fd_pr__pfet_01v8 W=0.7 L=0.15
Xn_189_p2 n_189 n_187 vdd vdd sky130_fd_pr__pfet_01v8 W=0.7 L=0.15
Xn_189_n1 n_189 n_174 n_189_x vss sky130_fd_pr__nfet_01v8 W=0.84 L=0.15
Xn_189_n2 n_189_x n_187 vss vss sky130_fd_pr__nfet_01v8 W=0.84 L=0.15
Xp_p1 p n_188 vdd vdd sky130_fd_pr__pfet_01v8 W=0.7 L=0.15
Xp_p2 p n_189 vdd vdd sky130_fd_pr__pfet_01v8 W=0.7 L=0.15
Xp_n1 p n_188 p_x vss sky130_fd_pr__nfet_01v8 W=0.84 L=0.15
Xp_n2 p_x n_189 vss vss sky130_fd_pr__nfet_01v8 W=0.84 L=0.15
Xn_190_n n_190 c_phi1 vss vss sky130_fd_pr__nfet_01v8 W=1.68 L=0.15
Xn_190_p n_190 c_phi1 vdd vdd sky130_fd_pr__pfet_01v8 W=2.8 L=0.15
Xphi1_n phi1 n_190 vss vss sky130_fd_pr__nfet_01v8 W=5.46 L=0.15
Xphi1_p phi1 n_190 vdd vdd sky130_fd_pr__pfet_01v8 W=9.1 L=0.15
Xn_191_n n_191 c_phi1e vss vss sky130_fd_pr__nfet_01v8 W=0.84 L=0.15
Xn_191_p n_191 c_phi1e vdd vdd sky130_fd_pr__pfet_01v8 W=1.4 L=0.15
Xphi1e_n phi1e n_191 vss vss sky130_fd_pr__nfet_01v8 W=1.68 L=0.15
Xphi1e_p phi1e n_191 vdd vdd sky130_fd_pr__pfet_01v8 W=2.8 L=0.15
Xn_192_p1 n_192 n_169 vdd vdd sky130_fd_pr__pfet_01v8 W=0.7 L=0.15
Xn_192_p2 n_192 c_phi2 vdd vdd sky130_fd_pr__pfet_01v8 W=0.7 L=0.15
Xn_192_n1 n_192 n_169 n_192_x vss sky130_fd_pr__nfet_01v8 W=0.84 L=0.15
Xn_192_n2 n_192_x c_phi2 vss vss sky130_fd_pr__nfet_01v8 W=0.84 L=0.15
Xn_193_n n_193 n_192 vss vss sky130_fd_pr__nfet_01v8 W=0.42 L=0.15
Xn_193_p n_193 n_192 vdd vdd sky130_fd_pr__pfet_01v8 W=0.7 L=0.15
Xn_194_n n_194 n_193 vss vss sky130_fd_pr__nfet_01v8 W=1.26 L=0.15
Xn_194_p n_194 n_193 vdd vdd sky130_fd_pr__pfet_01v8 W=2.1 L=0.15
Xphi2_n phi2 n_194 vss vss sky130_fd_pr__nfet_01v8 W=3.36 L=0.15
Xphi2_p phi2 n_194 vdd vdd sky130_fd_pr__pfet_01v8 W=5.6 L=0.15
Xn_195_n n_195 c_ck vss vss sky130_fd_pr__nfet_01v8 W=0.42 L=0.15
Xn_195_p n_195 c_ck vdd vdd sky130_fd_pr__pfet_01v8 W=0.7 L=0.15
Xn_196_n n_196 n_195 vss vss sky130_fd_pr__nfet_01v8 W=0.42 L=0.15
Xn_196_p n_196 n_195 vdd vdd sky130_fd_pr__pfet_01v8 W=0.7 L=0.15
Xn_197_n n_197 n_196 vss vss sky130_fd_pr__nfet_01v8 W=0.42 L=0.15
Xn_197_p n_197 n_196 vdd vdd sky130_fd_pr__pfet_01v8 W=0.7 L=0.15
Xn_198_n n_198 n_197 vss vss sky130_fd_pr__nfet_01v8 W=0.42 L=0.15
Xn_198_p n_198 n_197 vdd vdd sky130_fd_pr__pfet_01v8 W=0.7 L=0.15
Xn_199_n n_199 n_198 vss vss sky130_fd_pr__nfet_01v8 W=0.42 L=0.15
Xn_199_p n_199 n_198 vdd vdd sky130_fd_pr__pfet_01v8 W=0.7 L=0.15
Xn_200_n n_200 n_199 vss vss sky130_fd_pr__nfet_01v8 W=0.42 L=0.15
Xn_200_p n_200 n_199 vdd vdd sky130_fd_pr__pfet_01v8 W=0.7 L=0.15
Xn_201_p1 n_201 n_196 n_201_x vdd sky130_fd_pr__pfet_01v8 W=1.4 L=0.15
Xn_201_p2 n_201_x n_200 vdd vdd sky130_fd_pr__pfet_01v8 W=1.4 L=0.15
Xn_201_n1 n_201 n_196 vss vss sky130_fd_pr__nfet_01v8 W=0.42 L=0.15
Xn_201_n2 n_201 n_200 vss vss sky130_fd_pr__nfet_01v8 W=0.42 L=0.15
Xn_202_n n_202 n_201 vss vss sky130_fd_pr__nfet_01v8 W=6.72 L=0.15
Xn_202_p n_202 n_201 vdd vdd sky130_fd_pr__pfet_01v8 W=11.2 L=0.15
Xn_203_p1 n_203 n_196 vdd vdd sky130_fd_pr__pfet_01v8 W=0.7 L=0.15
Xn_203_p2 n_203 n_200 vdd vdd sky130_fd_pr__pfet_01v8 W=0.7 L=0.15
Xn_203_n1 n_203 n_196 n_203_x vss sky130_fd_pr__nfet_01v8 W=0.84 L=0.15
Xn_203_n2 n_203_x n_200 vss vss sky130_fd_pr__nfet_01v8 W=0.84 L=0.15
Xn_204_n n_204 n_203 vss vss sky130_fd_pr__nfet_01v8 W=0.42 L=0.15
Xn_204_p n_204 n_203 vdd vdd sky130_fd_pr__pfet_01v8 W=0.7 L=0.15
Xn_205_n n_205 n_204 vss vss sky130_fd_pr__nfet_01v8 W=6.72 L=0.15
Xn_205_p n_205 n_204 vdd vdd sky130_fd_pr__pfet_01v8 W=11.2 L=0.15
Xn_206_n n_206 adc_go vss vss sky130_fd_pr__nfet_01v8 W=0.42 L=0.15
Xn_206_p n_206 adc_go vdd vdd sky130_fd_pr__pfet_01v8 W=0.7 L=0.15
Xn_207_p1 n_207 adc_go n_207_x vdd sky130_fd_pr__pfet_01v8 W=1.4 L=0.15
Xn_207_p2 n_207_x n_202 vdd vdd sky130_fd_pr__pfet_01v8 W=1.4 L=0.15
Xn_207_n1 n_207 adc_go vss vss sky130_fd_pr__nfet_01v8 W=0.42 L=0.15
Xn_207_n2 n_207 n_202 vss vss sky130_fd_pr__nfet_01v8 W=0.42 L=0.15
Xn_208_p1 n_208 n_207 n_208_x vdd sky130_fd_pr__pfet_01v8 W=1.4 L=0.15
Xn_208_p2 n_208_x n_4 vdd vdd sky130_fd_pr__pfet_01v8 W=1.4 L=0.15
Xn_208_n1 n_208 n_207 vss vss sky130_fd_pr__nfet_01v8 W=0.42 L=0.15
Xn_208_n2 n_208 n_4 vss vss sky130_fd_pr__nfet_01v8 W=0.42 L=0.15
Xn_209_n n_209 n_208 vss vss sky130_fd_pr__nfet_01v8 W=0.42 L=0.15
Xn_209_p n_209 n_208 vdd vdd sky130_fd_pr__pfet_01v8 W=0.7 L=0.15
Xn_212_p1 n_212 n_206 n_212_x vdd sky130_fd_pr__pfet_01v8 W=1.4 L=0.15
Xn_212_p2 n_212_x n_202 vdd vdd sky130_fd_pr__pfet_01v8 W=1.4 L=0.15
Xn_212_n1 n_212 n_206 vss vss sky130_fd_pr__nfet_01v8 W=0.42 L=0.15
Xn_212_n2 n_212 n_202 vss vss sky130_fd_pr__nfet_01v8 W=0.42 L=0.15
Xn_211_p1 n_211 n_212 n_211_x vdd sky130_fd_pr__pfet_01v8 W=1.4 L=0.15
Xn_211_p2 n_211_x n_210 vdd vdd sky130_fd_pr__pfet_01v8 W=1.4 L=0.15
Xn_211_n1 n_211 n_212 vss vss sky130_fd_pr__nfet_01v8 W=0.42 L=0.15
Xn_211_n2 n_211 n_210 vss vss sky130_fd_pr__nfet_01v8 W=0.42 L=0.15
Xn_210_p1 n_210 n_209 n_210_x vdd sky130_fd_pr__pfet_01v8 W=1.4 L=0.15
Xn_210_p2 n_210_x n_211 vdd vdd sky130_fd_pr__pfet_01v8 W=1.4 L=0.15
Xn_210_n1 n_210 n_209 vss vss sky130_fd_pr__nfet_01v8 W=0.42 L=0.15
Xn_210_n2 n_210 n_211 vss vss sky130_fd_pr__nfet_01v8 W=0.42 L=0.15
Xn_213_p1 n_213 n_210 n_213_x vdd sky130_fd_pr__pfet_01v8 W=1.4 L=0.15
Xn_213_p2 n_213_x n_205 vdd vdd sky130_fd_pr__pfet_01v8 W=1.4 L=0.15
Xn_213_n1 n_213 n_210 vss vss sky130_fd_pr__nfet_01v8 W=0.42 L=0.15
Xn_213_n2 n_213 n_205 vss vss sky130_fd_pr__nfet_01v8 W=0.42 L=0.15
Xn_214_p1 n_214 n_213 n_214_x vdd sky130_fd_pr__pfet_01v8 W=1.4 L=0.15
Xn_214_p2 n_214_x n_4 vdd vdd sky130_fd_pr__pfet_01v8 W=1.4 L=0.15
Xn_214_n1 n_214 n_213 vss vss sky130_fd_pr__nfet_01v8 W=0.42 L=0.15
Xn_214_n2 n_214 n_4 vss vss sky130_fd_pr__nfet_01v8 W=0.42 L=0.15
Xn_215_n n_215 n_214 vss vss sky130_fd_pr__nfet_01v8 W=0.42 L=0.15
Xn_215_p n_215 n_214 vdd vdd sky130_fd_pr__pfet_01v8 W=0.7 L=0.15
Xn_218_p1 n_218 n_211 n_218_x vdd sky130_fd_pr__pfet_01v8 W=1.4 L=0.15
Xn_218_p2 n_218_x n_205 vdd vdd sky130_fd_pr__pfet_01v8 W=1.4 L=0.15
Xn_218_n1 n_218 n_211 vss vss sky130_fd_pr__nfet_01v8 W=0.42 L=0.15
Xn_218_n2 n_218 n_205 vss vss sky130_fd_pr__nfet_01v8 W=0.42 L=0.15
Xn_217_p1 n_217 n_218 n_217_x vdd sky130_fd_pr__pfet_01v8 W=1.4 L=0.15
Xn_217_p2 n_217_x n_216 vdd vdd sky130_fd_pr__pfet_01v8 W=1.4 L=0.15
Xn_217_n1 n_217 n_218 vss vss sky130_fd_pr__nfet_01v8 W=0.42 L=0.15
Xn_217_n2 n_217 n_216 vss vss sky130_fd_pr__nfet_01v8 W=0.42 L=0.15
Xn_216_p1 n_216 n_215 n_216_x vdd sky130_fd_pr__pfet_01v8 W=1.4 L=0.15
Xn_216_p2 n_216_x n_217 vdd vdd sky130_fd_pr__pfet_01v8 W=1.4 L=0.15
Xn_216_n1 n_216 n_215 vss vss sky130_fd_pr__nfet_01v8 W=0.42 L=0.15
Xn_216_n2 n_216 n_217 vss vss sky130_fd_pr__nfet_01v8 W=0.42 L=0.15
Xn_219_n n_219 n_216 vss vss sky130_fd_pr__nfet_01v8 W=0.42 L=0.15
Xn_219_p n_219 n_216 vdd vdd sky130_fd_pr__pfet_01v8 W=0.7 L=0.15
Xn_220_p1 n_220 n_216 n_220_x vdd sky130_fd_pr__pfet_01v8 W=1.4 L=0.15
Xn_220_p2 n_220_x n_202 vdd vdd sky130_fd_pr__pfet_01v8 W=1.4 L=0.15
Xn_220_n1 n_220 n_216 vss vss sky130_fd_pr__nfet_01v8 W=0.42 L=0.15
Xn_220_n2 n_220 n_202 vss vss sky130_fd_pr__nfet_01v8 W=0.42 L=0.15
Xn_221_p1 n_221 n_220 n_221_x vdd sky130_fd_pr__pfet_01v8 W=1.4 L=0.15
Xn_221_p2 n_221_x n_4 vdd vdd sky130_fd_pr__pfet_01v8 W=1.4 L=0.15
Xn_221_n1 n_221 n_220 vss vss sky130_fd_pr__nfet_01v8 W=0.42 L=0.15
Xn_221_n2 n_221 n_4 vss vss sky130_fd_pr__nfet_01v8 W=0.42 L=0.15
Xn_222_n n_222 n_221 vss vss sky130_fd_pr__nfet_01v8 W=0.42 L=0.15
Xn_222_p n_222 n_221 vdd vdd sky130_fd_pr__pfet_01v8 W=0.7 L=0.15
Xn_225_p1 n_225 n_219 n_225_x vdd sky130_fd_pr__pfet_01v8 W=1.4 L=0.15
Xn_225_p2 n_225_x n_202 vdd vdd sky130_fd_pr__pfet_01v8 W=1.4 L=0.15
Xn_225_n1 n_225 n_219 vss vss sky130_fd_pr__nfet_01v8 W=0.42 L=0.15
Xn_225_n2 n_225 n_202 vss vss sky130_fd_pr__nfet_01v8 W=0.42 L=0.15
Xn_224_p1 n_224 n_225 n_224_x vdd sky130_fd_pr__pfet_01v8 W=1.4 L=0.15
Xn_224_p2 n_224_x n_223 vdd vdd sky130_fd_pr__pfet_01v8 W=1.4 L=0.15
Xn_224_n1 n_224 n_225 vss vss sky130_fd_pr__nfet_01v8 W=0.42 L=0.15
Xn_224_n2 n_224 n_223 vss vss sky130_fd_pr__nfet_01v8 W=0.42 L=0.15
Xn_223_p1 n_223 n_222 n_223_x vdd sky130_fd_pr__pfet_01v8 W=1.4 L=0.15
Xn_223_p2 n_223_x n_224 vdd vdd sky130_fd_pr__pfet_01v8 W=1.4 L=0.15
Xn_223_n1 n_223 n_222 vss vss sky130_fd_pr__nfet_01v8 W=0.42 L=0.15
Xn_223_n2 n_223 n_224 vss vss sky130_fd_pr__nfet_01v8 W=0.42 L=0.15
Xn_226_p1 n_226 n_223 n_226_x vdd sky130_fd_pr__pfet_01v8 W=1.4 L=0.15
Xn_226_p2 n_226_x n_205 vdd vdd sky130_fd_pr__pfet_01v8 W=1.4 L=0.15
Xn_226_n1 n_226 n_223 vss vss sky130_fd_pr__nfet_01v8 W=0.42 L=0.15
Xn_226_n2 n_226 n_205 vss vss sky130_fd_pr__nfet_01v8 W=0.42 L=0.15
Xn_227_p1 n_227 n_226 n_227_x vdd sky130_fd_pr__pfet_01v8 W=1.4 L=0.15
Xn_227_p2 n_227_x n_4 vdd vdd sky130_fd_pr__pfet_01v8 W=1.4 L=0.15
Xn_227_n1 n_227 n_226 vss vss sky130_fd_pr__nfet_01v8 W=0.42 L=0.15
Xn_227_n2 n_227 n_4 vss vss sky130_fd_pr__nfet_01v8 W=0.42 L=0.15
Xn_228_n n_228 n_227 vss vss sky130_fd_pr__nfet_01v8 W=0.42 L=0.15
Xn_228_p n_228 n_227 vdd vdd sky130_fd_pr__pfet_01v8 W=0.7 L=0.15
Xn_230_p1 n_230 n_224 n_230_x vdd sky130_fd_pr__pfet_01v8 W=1.4 L=0.15
Xn_230_p2 n_230_x n_205 vdd vdd sky130_fd_pr__pfet_01v8 W=1.4 L=0.15
Xn_230_n1 n_230 n_224 vss vss sky130_fd_pr__nfet_01v8 W=0.42 L=0.15
Xn_230_n2 n_230 n_205 vss vss sky130_fd_pr__nfet_01v8 W=0.42 L=0.15
Xn_229_p1 n_229 n_230 n_229_x vdd sky130_fd_pr__pfet_01v8 W=1.4 L=0.15
Xn_229_p2 n_229_x s1 vdd vdd sky130_fd_pr__pfet_01v8 W=1.4 L=0.15
Xn_229_n1 n_229 n_230 vss vss sky130_fd_pr__nfet_01v8 W=0.42 L=0.15
Xn_229_n2 n_229 s1 vss vss sky130_fd_pr__nfet_01v8 W=0.42 L=0.15
Xs1_p1 s1 n_228 s1_x vdd sky130_fd_pr__pfet_01v8 W=1.4 L=0.15
Xs1_p2 s1_x n_229 vdd vdd sky130_fd_pr__pfet_01v8 W=1.4 L=0.15
Xs1_n1 s1 n_228 vss vss sky130_fd_pr__nfet_01v8 W=0.42 L=0.15
Xs1_n2 s1 n_229 vss vss sky130_fd_pr__nfet_01v8 W=0.42 L=0.15
Xn_231_n n_231 win_hi vss vss sky130_fd_pr__nfet_01v8 W=0.42 L=0.15
Xn_231_p n_231 win_hi vdd vdd sky130_fd_pr__pfet_01v8 W=0.7 L=0.15
Xn_232_p1 n_232 win_hi vdd vdd sky130_fd_pr__pfet_01v8 W=0.7 L=0.15
Xn_232_p2 n_232 cnt7 vdd vdd sky130_fd_pr__pfet_01v8 W=0.7 L=0.15
Xn_232_n1 n_232 win_hi n_232_x vss sky130_fd_pr__nfet_01v8 W=0.84 L=0.15
Xn_232_n2 n_232_x cnt7 vss vss sky130_fd_pr__nfet_01v8 W=0.84 L=0.15
Xn_233_p1 n_233 n_231 vdd vdd sky130_fd_pr__pfet_01v8 W=0.7 L=0.15
Xn_233_p2 n_233 cnt4 vdd vdd sky130_fd_pr__pfet_01v8 W=0.7 L=0.15
Xn_233_n1 n_233 n_231 n_233_x vss sky130_fd_pr__nfet_01v8 W=0.84 L=0.15
Xn_233_n2 n_233_x cnt4 vss vss sky130_fd_pr__nfet_01v8 W=0.84 L=0.15
Xn_234_p1 n_234 n_232 vdd vdd sky130_fd_pr__pfet_01v8 W=0.7 L=0.15
Xn_234_p2 n_234 n_233 vdd vdd sky130_fd_pr__pfet_01v8 W=0.7 L=0.15
Xn_234_n1 n_234 n_232 n_234_x vss sky130_fd_pr__nfet_01v8 W=0.84 L=0.15
Xn_234_n2 n_234_x n_233 vss vss sky130_fd_pr__nfet_01v8 W=0.84 L=0.15
Xn_235_n n_235 pw vss vss sky130_fd_pr__nfet_01v8 W=0.42 L=0.15
Xn_235_p n_235 pw vdd vdd sky130_fd_pr__pfet_01v8 W=0.7 L=0.15
Xn_236_p1 n_236 n_234 vdd vdd sky130_fd_pr__pfet_01v8 W=0.7 L=0.15
Xn_236_p2 n_236 n_235 vdd vdd sky130_fd_pr__pfet_01v8 W=0.7 L=0.15
Xn_236_n1 n_236 n_234 n_236_x vss sky130_fd_pr__nfet_01v8 W=0.84 L=0.15
Xn_236_n2 n_236_x n_235 vss vss sky130_fd_pr__nfet_01v8 W=0.84 L=0.15
Xn_237_n n_237 sg vss vss sky130_fd_pr__nfet_01v8 W=0.42 L=0.15
Xn_237_p n_237 sg vdd vdd sky130_fd_pr__pfet_01v8 W=0.7 L=0.15
Xn_238_p1 n_238 s1 vdd vdd sky130_fd_pr__pfet_01v8 W=0.7 L=0.15
Xn_238_p2 n_238 n_237 vdd vdd sky130_fd_pr__pfet_01v8 W=0.7 L=0.15
Xn_238_n1 n_238 s1 n_238_x vss sky130_fd_pr__nfet_01v8 W=0.84 L=0.15
Xn_238_n2 n_238_x n_237 vss vss sky130_fd_pr__nfet_01v8 W=0.84 L=0.15
Xn_239_n n_239 n_238 vss vss sky130_fd_pr__nfet_01v8 W=0.42 L=0.15
Xn_239_p n_239 n_238 vdd vdd sky130_fd_pr__pfet_01v8 W=0.7 L=0.15
Xn_240_p1 n_240 cnt0 vdd vdd sky130_fd_pr__pfet_01v8 W=0.7 L=0.15
Xn_240_p2 n_240 n_239 vdd vdd sky130_fd_pr__pfet_01v8 W=0.7 L=0.15
Xn_240_n1 n_240 cnt0 n_240_x vss sky130_fd_pr__nfet_01v8 W=0.84 L=0.15
Xn_240_n2 n_240_x n_239 vss vss sky130_fd_pr__nfet_01v8 W=0.84 L=0.15
Xn_241_p1 n_241 cnt0 vdd vdd sky130_fd_pr__pfet_01v8 W=0.7 L=0.15
Xn_241_p2 n_241 n_240 vdd vdd sky130_fd_pr__pfet_01v8 W=0.7 L=0.15
Xn_241_n1 n_241 cnt0 n_241_x vss sky130_fd_pr__nfet_01v8 W=0.84 L=0.15
Xn_241_n2 n_241_x n_240 vss vss sky130_fd_pr__nfet_01v8 W=0.84 L=0.15
Xn_242_p1 n_242 n_239 vdd vdd sky130_fd_pr__pfet_01v8 W=0.7 L=0.15
Xn_242_p2 n_242 n_240 vdd vdd sky130_fd_pr__pfet_01v8 W=0.7 L=0.15
Xn_242_n1 n_242 n_239 n_242_x vss sky130_fd_pr__nfet_01v8 W=0.84 L=0.15
Xn_242_n2 n_242_x n_240 vss vss sky130_fd_pr__nfet_01v8 W=0.84 L=0.15
Xn_243_p1 n_243 n_241 vdd vdd sky130_fd_pr__pfet_01v8 W=0.7 L=0.15
Xn_243_p2 n_243 n_242 vdd vdd sky130_fd_pr__pfet_01v8 W=0.7 L=0.15
Xn_243_n1 n_243 n_241 n_243_x vss sky130_fd_pr__nfet_01v8 W=0.84 L=0.15
Xn_243_n2 n_243_x n_242 vss vss sky130_fd_pr__nfet_01v8 W=0.84 L=0.15
Xn_244_p1 n_244 n_236 vdd vdd sky130_fd_pr__pfet_01v8 W=0.7 L=0.15
Xn_244_p2 n_244 n_243 vdd vdd sky130_fd_pr__pfet_01v8 W=0.7 L=0.15
Xn_244_n1 n_244 n_236 n_244_x vss sky130_fd_pr__nfet_01v8 W=0.84 L=0.15
Xn_244_n2 n_244_x n_243 vss vss sky130_fd_pr__nfet_01v8 W=0.84 L=0.15
Xn_245_n n_245 n_244 vss vss sky130_fd_pr__nfet_01v8 W=0.42 L=0.15
Xn_245_p n_245 n_244 vdd vdd sky130_fd_pr__pfet_01v8 W=0.7 L=0.15
Xn_246_n n_246 n_245 vss vss sky130_fd_pr__nfet_01v8 W=0.42 L=0.15
Xn_246_p n_246 n_245 vdd vdd sky130_fd_pr__pfet_01v8 W=0.7 L=0.15
Xn_247_p1 n_247 n_245 n_247_x vdd sky130_fd_pr__pfet_01v8 W=1.4 L=0.15
Xn_247_p2 n_247_x n_202 vdd vdd sky130_fd_pr__pfet_01v8 W=1.4 L=0.15
Xn_247_n1 n_247 n_245 vss vss sky130_fd_pr__nfet_01v8 W=0.42 L=0.15
Xn_247_n2 n_247 n_202 vss vss sky130_fd_pr__nfet_01v8 W=0.42 L=0.15
Xn_248_p1 n_248 n_247 n_248_x vdd sky130_fd_pr__pfet_01v8 W=1.4 L=0.15
Xn_248_p2 n_248_x n_4 vdd vdd sky130_fd_pr__pfet_01v8 W=1.4 L=0.15
Xn_248_n1 n_248 n_247 vss vss sky130_fd_pr__nfet_01v8 W=0.42 L=0.15
Xn_248_n2 n_248 n_4 vss vss sky130_fd_pr__nfet_01v8 W=0.42 L=0.15
Xn_249_n n_249 n_248 vss vss sky130_fd_pr__nfet_01v8 W=0.42 L=0.15
Xn_249_p n_249 n_248 vdd vdd sky130_fd_pr__pfet_01v8 W=0.7 L=0.15
Xn_252_p1 n_252 n_246 n_252_x vdd sky130_fd_pr__pfet_01v8 W=1.4 L=0.15
Xn_252_p2 n_252_x n_202 vdd vdd sky130_fd_pr__pfet_01v8 W=1.4 L=0.15
Xn_252_n1 n_252 n_246 vss vss sky130_fd_pr__nfet_01v8 W=0.42 L=0.15
Xn_252_n2 n_252 n_202 vss vss sky130_fd_pr__nfet_01v8 W=0.42 L=0.15
Xn_251_p1 n_251 n_252 n_251_x vdd sky130_fd_pr__pfet_01v8 W=1.4 L=0.15
Xn_251_p2 n_251_x n_250 vdd vdd sky130_fd_pr__pfet_01v8 W=1.4 L=0.15
Xn_251_n1 n_251 n_252 vss vss sky130_fd_pr__nfet_01v8 W=0.42 L=0.15
Xn_251_n2 n_251 n_250 vss vss sky130_fd_pr__nfet_01v8 W=0.42 L=0.15
Xn_250_p1 n_250 n_249 n_250_x vdd sky130_fd_pr__pfet_01v8 W=1.4 L=0.15
Xn_250_p2 n_250_x n_251 vdd vdd sky130_fd_pr__pfet_01v8 W=1.4 L=0.15
Xn_250_n1 n_250 n_249 vss vss sky130_fd_pr__nfet_01v8 W=0.42 L=0.15
Xn_250_n2 n_250 n_251 vss vss sky130_fd_pr__nfet_01v8 W=0.42 L=0.15
Xn_253_p1 n_253 n_250 n_253_x vdd sky130_fd_pr__pfet_01v8 W=1.4 L=0.15
Xn_253_p2 n_253_x n_205 vdd vdd sky130_fd_pr__pfet_01v8 W=1.4 L=0.15
Xn_253_n1 n_253 n_250 vss vss sky130_fd_pr__nfet_01v8 W=0.42 L=0.15
Xn_253_n2 n_253 n_205 vss vss sky130_fd_pr__nfet_01v8 W=0.42 L=0.15
Xn_254_p1 n_254 n_253 n_254_x vdd sky130_fd_pr__pfet_01v8 W=1.4 L=0.15
Xn_254_p2 n_254_x n_4 vdd vdd sky130_fd_pr__pfet_01v8 W=1.4 L=0.15
Xn_254_n1 n_254 n_253 vss vss sky130_fd_pr__nfet_01v8 W=0.42 L=0.15
Xn_254_n2 n_254 n_4 vss vss sky130_fd_pr__nfet_01v8 W=0.42 L=0.15
Xn_255_n n_255 n_254 vss vss sky130_fd_pr__nfet_01v8 W=0.42 L=0.15
Xn_255_p n_255 n_254 vdd vdd sky130_fd_pr__pfet_01v8 W=0.7 L=0.15
Xn_257_p1 n_257 n_251 n_257_x vdd sky130_fd_pr__pfet_01v8 W=1.4 L=0.15
Xn_257_p2 n_257_x n_205 vdd vdd sky130_fd_pr__pfet_01v8 W=1.4 L=0.15
Xn_257_n1 n_257 n_251 vss vss sky130_fd_pr__nfet_01v8 W=0.42 L=0.15
Xn_257_n2 n_257 n_205 vss vss sky130_fd_pr__nfet_01v8 W=0.42 L=0.15
Xn_256_p1 n_256 n_257 n_256_x vdd sky130_fd_pr__pfet_01v8 W=1.4 L=0.15
Xn_256_p2 n_256_x cnt0 vdd vdd sky130_fd_pr__pfet_01v8 W=1.4 L=0.15
Xn_256_n1 n_256 n_257 vss vss sky130_fd_pr__nfet_01v8 W=0.42 L=0.15
Xn_256_n2 n_256 cnt0 vss vss sky130_fd_pr__nfet_01v8 W=0.42 L=0.15
Xcnt0_p1 cnt0 n_255 cnt0_x vdd sky130_fd_pr__pfet_01v8 W=1.4 L=0.15
Xcnt0_p2 cnt0_x n_256 vdd vdd sky130_fd_pr__pfet_01v8 W=1.4 L=0.15
Xcnt0_n1 cnt0 n_255 vss vss sky130_fd_pr__nfet_01v8 W=0.42 L=0.15
Xcnt0_n2 cnt0 n_256 vss vss sky130_fd_pr__nfet_01v8 W=0.42 L=0.15
Xn_258_p1 n_258 cnt0 vdd vdd sky130_fd_pr__pfet_01v8 W=0.7 L=0.15
Xn_258_p2 n_258 n_239 vdd vdd sky130_fd_pr__pfet_01v8 W=0.7 L=0.15
Xn_258_n1 n_258 cnt0 n_258_x vss sky130_fd_pr__nfet_01v8 W=0.84 L=0.15
Xn_258_n2 n_258_x n_239 vss vss sky130_fd_pr__nfet_01v8 W=0.84 L=0.15
Xn_259_n n_259 n_258 vss vss sky130_fd_pr__nfet_01v8 W=0.42 L=0.15
Xn_259_p n_259 n_258 vdd vdd sky130_fd_pr__pfet_01v8 W=0.7 L=0.15
Xn_260_p1 n_260 cnt1 vdd vdd sky130_fd_pr__pfet_01v8 W=0.7 L=0.15
Xn_260_p2 n_260 n_259 vdd vdd sky130_fd_pr__pfet_01v8 W=0.7 L=0.15
Xn_260_n1 n_260 cnt1 n_260_x vss sky130_fd_pr__nfet_01v8 W=0.84 L=0.15
Xn_260_n2 n_260_x n_259 vss vss sky130_fd_pr__nfet_01v8 W=0.84 L=0.15
Xn_261_p1 n_261 cnt1 vdd vdd sky130_fd_pr__pfet_01v8 W=0.7 L=0.15
Xn_261_p2 n_261 n_260 vdd vdd sky130_fd_pr__pfet_01v8 W=0.7 L=0.15
Xn_261_n1 n_261 cnt1 n_261_x vss sky130_fd_pr__nfet_01v8 W=0.84 L=0.15
Xn_261_n2 n_261_x n_260 vss vss sky130_fd_pr__nfet_01v8 W=0.84 L=0.15
Xn_262_p1 n_262 n_259 vdd vdd sky130_fd_pr__pfet_01v8 W=0.7 L=0.15
Xn_262_p2 n_262 n_260 vdd vdd sky130_fd_pr__pfet_01v8 W=0.7 L=0.15
Xn_262_n1 n_262 n_259 n_262_x vss sky130_fd_pr__nfet_01v8 W=0.84 L=0.15
Xn_262_n2 n_262_x n_260 vss vss sky130_fd_pr__nfet_01v8 W=0.84 L=0.15
Xn_263_p1 n_263 n_261 vdd vdd sky130_fd_pr__pfet_01v8 W=0.7 L=0.15
Xn_263_p2 n_263 n_262 vdd vdd sky130_fd_pr__pfet_01v8 W=0.7 L=0.15
Xn_263_n1 n_263 n_261 n_263_x vss sky130_fd_pr__nfet_01v8 W=0.84 L=0.15
Xn_263_n2 n_263_x n_262 vss vss sky130_fd_pr__nfet_01v8 W=0.84 L=0.15
Xn_264_p1 n_264 n_236 vdd vdd sky130_fd_pr__pfet_01v8 W=0.7 L=0.15
Xn_264_p2 n_264 n_263 vdd vdd sky130_fd_pr__pfet_01v8 W=0.7 L=0.15
Xn_264_n1 n_264 n_236 n_264_x vss sky130_fd_pr__nfet_01v8 W=0.84 L=0.15
Xn_264_n2 n_264_x n_263 vss vss sky130_fd_pr__nfet_01v8 W=0.84 L=0.15
Xn_265_n n_265 n_264 vss vss sky130_fd_pr__nfet_01v8 W=0.42 L=0.15
Xn_265_p n_265 n_264 vdd vdd sky130_fd_pr__pfet_01v8 W=0.7 L=0.15
Xn_266_n n_266 n_265 vss vss sky130_fd_pr__nfet_01v8 W=0.42 L=0.15
Xn_266_p n_266 n_265 vdd vdd sky130_fd_pr__pfet_01v8 W=0.7 L=0.15
Xn_267_p1 n_267 n_265 n_267_x vdd sky130_fd_pr__pfet_01v8 W=1.4 L=0.15
Xn_267_p2 n_267_x n_202 vdd vdd sky130_fd_pr__pfet_01v8 W=1.4 L=0.15
Xn_267_n1 n_267 n_265 vss vss sky130_fd_pr__nfet_01v8 W=0.42 L=0.15
Xn_267_n2 n_267 n_202 vss vss sky130_fd_pr__nfet_01v8 W=0.42 L=0.15
Xn_268_p1 n_268 n_267 n_268_x vdd sky130_fd_pr__pfet_01v8 W=1.4 L=0.15
Xn_268_p2 n_268_x n_4 vdd vdd sky130_fd_pr__pfet_01v8 W=1.4 L=0.15
Xn_268_n1 n_268 n_267 vss vss sky130_fd_pr__nfet_01v8 W=0.42 L=0.15
Xn_268_n2 n_268 n_4 vss vss sky130_fd_pr__nfet_01v8 W=0.42 L=0.15
Xn_269_n n_269 n_268 vss vss sky130_fd_pr__nfet_01v8 W=0.42 L=0.15
Xn_269_p n_269 n_268 vdd vdd sky130_fd_pr__pfet_01v8 W=0.7 L=0.15
Xn_272_p1 n_272 n_266 n_272_x vdd sky130_fd_pr__pfet_01v8 W=1.4 L=0.15
Xn_272_p2 n_272_x n_202 vdd vdd sky130_fd_pr__pfet_01v8 W=1.4 L=0.15
Xn_272_n1 n_272 n_266 vss vss sky130_fd_pr__nfet_01v8 W=0.42 L=0.15
Xn_272_n2 n_272 n_202 vss vss sky130_fd_pr__nfet_01v8 W=0.42 L=0.15
Xn_271_p1 n_271 n_272 n_271_x vdd sky130_fd_pr__pfet_01v8 W=1.4 L=0.15
Xn_271_p2 n_271_x n_270 vdd vdd sky130_fd_pr__pfet_01v8 W=1.4 L=0.15
Xn_271_n1 n_271 n_272 vss vss sky130_fd_pr__nfet_01v8 W=0.42 L=0.15
Xn_271_n2 n_271 n_270 vss vss sky130_fd_pr__nfet_01v8 W=0.42 L=0.15
Xn_270_p1 n_270 n_269 n_270_x vdd sky130_fd_pr__pfet_01v8 W=1.4 L=0.15
Xn_270_p2 n_270_x n_271 vdd vdd sky130_fd_pr__pfet_01v8 W=1.4 L=0.15
Xn_270_n1 n_270 n_269 vss vss sky130_fd_pr__nfet_01v8 W=0.42 L=0.15
Xn_270_n2 n_270 n_271 vss vss sky130_fd_pr__nfet_01v8 W=0.42 L=0.15
Xn_273_p1 n_273 n_270 n_273_x vdd sky130_fd_pr__pfet_01v8 W=1.4 L=0.15
Xn_273_p2 n_273_x n_205 vdd vdd sky130_fd_pr__pfet_01v8 W=1.4 L=0.15
Xn_273_n1 n_273 n_270 vss vss sky130_fd_pr__nfet_01v8 W=0.42 L=0.15
Xn_273_n2 n_273 n_205 vss vss sky130_fd_pr__nfet_01v8 W=0.42 L=0.15
Xn_274_p1 n_274 n_273 n_274_x vdd sky130_fd_pr__pfet_01v8 W=1.4 L=0.15
Xn_274_p2 n_274_x n_4 vdd vdd sky130_fd_pr__pfet_01v8 W=1.4 L=0.15
Xn_274_n1 n_274 n_273 vss vss sky130_fd_pr__nfet_01v8 W=0.42 L=0.15
Xn_274_n2 n_274 n_4 vss vss sky130_fd_pr__nfet_01v8 W=0.42 L=0.15
Xn_275_n n_275 n_274 vss vss sky130_fd_pr__nfet_01v8 W=0.42 L=0.15
Xn_275_p n_275 n_274 vdd vdd sky130_fd_pr__pfet_01v8 W=0.7 L=0.15
Xn_277_p1 n_277 n_271 n_277_x vdd sky130_fd_pr__pfet_01v8 W=1.4 L=0.15
Xn_277_p2 n_277_x n_205 vdd vdd sky130_fd_pr__pfet_01v8 W=1.4 L=0.15
Xn_277_n1 n_277 n_271 vss vss sky130_fd_pr__nfet_01v8 W=0.42 L=0.15
Xn_277_n2 n_277 n_205 vss vss sky130_fd_pr__nfet_01v8 W=0.42 L=0.15
Xn_276_p1 n_276 n_277 n_276_x vdd sky130_fd_pr__pfet_01v8 W=1.4 L=0.15
Xn_276_p2 n_276_x cnt1 vdd vdd sky130_fd_pr__pfet_01v8 W=1.4 L=0.15
Xn_276_n1 n_276 n_277 vss vss sky130_fd_pr__nfet_01v8 W=0.42 L=0.15
Xn_276_n2 n_276 cnt1 vss vss sky130_fd_pr__nfet_01v8 W=0.42 L=0.15
Xcnt1_p1 cnt1 n_275 cnt1_x vdd sky130_fd_pr__pfet_01v8 W=1.4 L=0.15
Xcnt1_p2 cnt1_x n_276 vdd vdd sky130_fd_pr__pfet_01v8 W=1.4 L=0.15
Xcnt1_n1 cnt1 n_275 vss vss sky130_fd_pr__nfet_01v8 W=0.42 L=0.15
Xcnt1_n2 cnt1 n_276 vss vss sky130_fd_pr__nfet_01v8 W=0.42 L=0.15
Xn_278_p1 n_278 cnt1 vdd vdd sky130_fd_pr__pfet_01v8 W=0.7 L=0.15
Xn_278_p2 n_278 n_259 vdd vdd sky130_fd_pr__pfet_01v8 W=0.7 L=0.15
Xn_278_n1 n_278 cnt1 n_278_x vss sky130_fd_pr__nfet_01v8 W=0.84 L=0.15
Xn_278_n2 n_278_x n_259 vss vss sky130_fd_pr__nfet_01v8 W=0.84 L=0.15
Xn_279_n n_279 n_278 vss vss sky130_fd_pr__nfet_01v8 W=0.42 L=0.15
Xn_279_p n_279 n_278 vdd vdd sky130_fd_pr__pfet_01v8 W=0.7 L=0.15
Xn_280_p1 n_280 cnt2 vdd vdd sky130_fd_pr__pfet_01v8 W=0.7 L=0.15
Xn_280_p2 n_280 n_279 vdd vdd sky130_fd_pr__pfet_01v8 W=0.7 L=0.15
Xn_280_n1 n_280 cnt2 n_280_x vss sky130_fd_pr__nfet_01v8 W=0.84 L=0.15
Xn_280_n2 n_280_x n_279 vss vss sky130_fd_pr__nfet_01v8 W=0.84 L=0.15
Xn_281_p1 n_281 cnt2 vdd vdd sky130_fd_pr__pfet_01v8 W=0.7 L=0.15
Xn_281_p2 n_281 n_280 vdd vdd sky130_fd_pr__pfet_01v8 W=0.7 L=0.15
Xn_281_n1 n_281 cnt2 n_281_x vss sky130_fd_pr__nfet_01v8 W=0.84 L=0.15
Xn_281_n2 n_281_x n_280 vss vss sky130_fd_pr__nfet_01v8 W=0.84 L=0.15
Xn_282_p1 n_282 n_279 vdd vdd sky130_fd_pr__pfet_01v8 W=0.7 L=0.15
Xn_282_p2 n_282 n_280 vdd vdd sky130_fd_pr__pfet_01v8 W=0.7 L=0.15
Xn_282_n1 n_282 n_279 n_282_x vss sky130_fd_pr__nfet_01v8 W=0.84 L=0.15
Xn_282_n2 n_282_x n_280 vss vss sky130_fd_pr__nfet_01v8 W=0.84 L=0.15
Xn_283_p1 n_283 n_281 vdd vdd sky130_fd_pr__pfet_01v8 W=0.7 L=0.15
Xn_283_p2 n_283 n_282 vdd vdd sky130_fd_pr__pfet_01v8 W=0.7 L=0.15
Xn_283_n1 n_283 n_281 n_283_x vss sky130_fd_pr__nfet_01v8 W=0.84 L=0.15
Xn_283_n2 n_283_x n_282 vss vss sky130_fd_pr__nfet_01v8 W=0.84 L=0.15
Xn_284_p1 n_284 n_236 vdd vdd sky130_fd_pr__pfet_01v8 W=0.7 L=0.15
Xn_284_p2 n_284 n_283 vdd vdd sky130_fd_pr__pfet_01v8 W=0.7 L=0.15
Xn_284_n1 n_284 n_236 n_284_x vss sky130_fd_pr__nfet_01v8 W=0.84 L=0.15
Xn_284_n2 n_284_x n_283 vss vss sky130_fd_pr__nfet_01v8 W=0.84 L=0.15
Xn_285_n n_285 n_284 vss vss sky130_fd_pr__nfet_01v8 W=0.42 L=0.15
Xn_285_p n_285 n_284 vdd vdd sky130_fd_pr__pfet_01v8 W=0.7 L=0.15
Xn_286_n n_286 n_285 vss vss sky130_fd_pr__nfet_01v8 W=0.42 L=0.15
Xn_286_p n_286 n_285 vdd vdd sky130_fd_pr__pfet_01v8 W=0.7 L=0.15
Xn_287_p1 n_287 n_285 n_287_x vdd sky130_fd_pr__pfet_01v8 W=1.4 L=0.15
Xn_287_p2 n_287_x n_202 vdd vdd sky130_fd_pr__pfet_01v8 W=1.4 L=0.15
Xn_287_n1 n_287 n_285 vss vss sky130_fd_pr__nfet_01v8 W=0.42 L=0.15
Xn_287_n2 n_287 n_202 vss vss sky130_fd_pr__nfet_01v8 W=0.42 L=0.15
Xn_288_p1 n_288 n_287 n_288_x vdd sky130_fd_pr__pfet_01v8 W=1.4 L=0.15
Xn_288_p2 n_288_x n_4 vdd vdd sky130_fd_pr__pfet_01v8 W=1.4 L=0.15
Xn_288_n1 n_288 n_287 vss vss sky130_fd_pr__nfet_01v8 W=0.42 L=0.15
Xn_288_n2 n_288 n_4 vss vss sky130_fd_pr__nfet_01v8 W=0.42 L=0.15
Xn_289_n n_289 n_288 vss vss sky130_fd_pr__nfet_01v8 W=0.42 L=0.15
Xn_289_p n_289 n_288 vdd vdd sky130_fd_pr__pfet_01v8 W=0.7 L=0.15
Xn_292_p1 n_292 n_286 n_292_x vdd sky130_fd_pr__pfet_01v8 W=1.4 L=0.15
Xn_292_p2 n_292_x n_202 vdd vdd sky130_fd_pr__pfet_01v8 W=1.4 L=0.15
Xn_292_n1 n_292 n_286 vss vss sky130_fd_pr__nfet_01v8 W=0.42 L=0.15
Xn_292_n2 n_292 n_202 vss vss sky130_fd_pr__nfet_01v8 W=0.42 L=0.15
Xn_291_p1 n_291 n_292 n_291_x vdd sky130_fd_pr__pfet_01v8 W=1.4 L=0.15
Xn_291_p2 n_291_x n_290 vdd vdd sky130_fd_pr__pfet_01v8 W=1.4 L=0.15
Xn_291_n1 n_291 n_292 vss vss sky130_fd_pr__nfet_01v8 W=0.42 L=0.15
Xn_291_n2 n_291 n_290 vss vss sky130_fd_pr__nfet_01v8 W=0.42 L=0.15
Xn_290_p1 n_290 n_289 n_290_x vdd sky130_fd_pr__pfet_01v8 W=1.4 L=0.15
Xn_290_p2 n_290_x n_291 vdd vdd sky130_fd_pr__pfet_01v8 W=1.4 L=0.15
Xn_290_n1 n_290 n_289 vss vss sky130_fd_pr__nfet_01v8 W=0.42 L=0.15
Xn_290_n2 n_290 n_291 vss vss sky130_fd_pr__nfet_01v8 W=0.42 L=0.15
Xn_293_p1 n_293 n_290 n_293_x vdd sky130_fd_pr__pfet_01v8 W=1.4 L=0.15
Xn_293_p2 n_293_x n_205 vdd vdd sky130_fd_pr__pfet_01v8 W=1.4 L=0.15
Xn_293_n1 n_293 n_290 vss vss sky130_fd_pr__nfet_01v8 W=0.42 L=0.15
Xn_293_n2 n_293 n_205 vss vss sky130_fd_pr__nfet_01v8 W=0.42 L=0.15
Xn_294_p1 n_294 n_293 n_294_x vdd sky130_fd_pr__pfet_01v8 W=1.4 L=0.15
Xn_294_p2 n_294_x n_4 vdd vdd sky130_fd_pr__pfet_01v8 W=1.4 L=0.15
Xn_294_n1 n_294 n_293 vss vss sky130_fd_pr__nfet_01v8 W=0.42 L=0.15
Xn_294_n2 n_294 n_4 vss vss sky130_fd_pr__nfet_01v8 W=0.42 L=0.15
Xn_295_n n_295 n_294 vss vss sky130_fd_pr__nfet_01v8 W=0.42 L=0.15
Xn_295_p n_295 n_294 vdd vdd sky130_fd_pr__pfet_01v8 W=0.7 L=0.15
Xn_297_p1 n_297 n_291 n_297_x vdd sky130_fd_pr__pfet_01v8 W=1.4 L=0.15
Xn_297_p2 n_297_x n_205 vdd vdd sky130_fd_pr__pfet_01v8 W=1.4 L=0.15
Xn_297_n1 n_297 n_291 vss vss sky130_fd_pr__nfet_01v8 W=0.42 L=0.15
Xn_297_n2 n_297 n_205 vss vss sky130_fd_pr__nfet_01v8 W=0.42 L=0.15
Xn_296_p1 n_296 n_297 n_296_x vdd sky130_fd_pr__pfet_01v8 W=1.4 L=0.15
Xn_296_p2 n_296_x cnt2 vdd vdd sky130_fd_pr__pfet_01v8 W=1.4 L=0.15
Xn_296_n1 n_296 n_297 vss vss sky130_fd_pr__nfet_01v8 W=0.42 L=0.15
Xn_296_n2 n_296 cnt2 vss vss sky130_fd_pr__nfet_01v8 W=0.42 L=0.15
Xcnt2_p1 cnt2 n_295 cnt2_x vdd sky130_fd_pr__pfet_01v8 W=1.4 L=0.15
Xcnt2_p2 cnt2_x n_296 vdd vdd sky130_fd_pr__pfet_01v8 W=1.4 L=0.15
Xcnt2_n1 cnt2 n_295 vss vss sky130_fd_pr__nfet_01v8 W=0.42 L=0.15
Xcnt2_n2 cnt2 n_296 vss vss sky130_fd_pr__nfet_01v8 W=0.42 L=0.15
Xn_298_p1 n_298 cnt2 vdd vdd sky130_fd_pr__pfet_01v8 W=0.7 L=0.15
Xn_298_p2 n_298 n_279 vdd vdd sky130_fd_pr__pfet_01v8 W=0.7 L=0.15
Xn_298_n1 n_298 cnt2 n_298_x vss sky130_fd_pr__nfet_01v8 W=0.84 L=0.15
Xn_298_n2 n_298_x n_279 vss vss sky130_fd_pr__nfet_01v8 W=0.84 L=0.15
Xn_299_n n_299 n_298 vss vss sky130_fd_pr__nfet_01v8 W=0.42 L=0.15
Xn_299_p n_299 n_298 vdd vdd sky130_fd_pr__pfet_01v8 W=0.7 L=0.15
Xn_300_p1 n_300 cnt3 vdd vdd sky130_fd_pr__pfet_01v8 W=0.7 L=0.15
Xn_300_p2 n_300 n_299 vdd vdd sky130_fd_pr__pfet_01v8 W=0.7 L=0.15
Xn_300_n1 n_300 cnt3 n_300_x vss sky130_fd_pr__nfet_01v8 W=0.84 L=0.15
Xn_300_n2 n_300_x n_299 vss vss sky130_fd_pr__nfet_01v8 W=0.84 L=0.15
Xn_301_p1 n_301 cnt3 vdd vdd sky130_fd_pr__pfet_01v8 W=0.7 L=0.15
Xn_301_p2 n_301 n_300 vdd vdd sky130_fd_pr__pfet_01v8 W=0.7 L=0.15
Xn_301_n1 n_301 cnt3 n_301_x vss sky130_fd_pr__nfet_01v8 W=0.84 L=0.15
Xn_301_n2 n_301_x n_300 vss vss sky130_fd_pr__nfet_01v8 W=0.84 L=0.15
Xn_302_p1 n_302 n_299 vdd vdd sky130_fd_pr__pfet_01v8 W=0.7 L=0.15
Xn_302_p2 n_302 n_300 vdd vdd sky130_fd_pr__pfet_01v8 W=0.7 L=0.15
Xn_302_n1 n_302 n_299 n_302_x vss sky130_fd_pr__nfet_01v8 W=0.84 L=0.15
Xn_302_n2 n_302_x n_300 vss vss sky130_fd_pr__nfet_01v8 W=0.84 L=0.15
Xn_303_p1 n_303 n_301 vdd vdd sky130_fd_pr__pfet_01v8 W=0.7 L=0.15
Xn_303_p2 n_303 n_302 vdd vdd sky130_fd_pr__pfet_01v8 W=0.7 L=0.15
Xn_303_n1 n_303 n_301 n_303_x vss sky130_fd_pr__nfet_01v8 W=0.84 L=0.15
Xn_303_n2 n_303_x n_302 vss vss sky130_fd_pr__nfet_01v8 W=0.84 L=0.15
Xn_304_p1 n_304 n_236 vdd vdd sky130_fd_pr__pfet_01v8 W=0.7 L=0.15
Xn_304_p2 n_304 n_303 vdd vdd sky130_fd_pr__pfet_01v8 W=0.7 L=0.15
Xn_304_n1 n_304 n_236 n_304_x vss sky130_fd_pr__nfet_01v8 W=0.84 L=0.15
Xn_304_n2 n_304_x n_303 vss vss sky130_fd_pr__nfet_01v8 W=0.84 L=0.15
Xn_305_n n_305 n_304 vss vss sky130_fd_pr__nfet_01v8 W=0.42 L=0.15
Xn_305_p n_305 n_304 vdd vdd sky130_fd_pr__pfet_01v8 W=0.7 L=0.15
Xn_306_n n_306 n_305 vss vss sky130_fd_pr__nfet_01v8 W=0.42 L=0.15
Xn_306_p n_306 n_305 vdd vdd sky130_fd_pr__pfet_01v8 W=0.7 L=0.15
Xn_307_p1 n_307 n_305 n_307_x vdd sky130_fd_pr__pfet_01v8 W=1.4 L=0.15
Xn_307_p2 n_307_x n_202 vdd vdd sky130_fd_pr__pfet_01v8 W=1.4 L=0.15
Xn_307_n1 n_307 n_305 vss vss sky130_fd_pr__nfet_01v8 W=0.42 L=0.15
Xn_307_n2 n_307 n_202 vss vss sky130_fd_pr__nfet_01v8 W=0.42 L=0.15
Xn_308_p1 n_308 n_307 n_308_x vdd sky130_fd_pr__pfet_01v8 W=1.4 L=0.15
Xn_308_p2 n_308_x n_4 vdd vdd sky130_fd_pr__pfet_01v8 W=1.4 L=0.15
Xn_308_n1 n_308 n_307 vss vss sky130_fd_pr__nfet_01v8 W=0.42 L=0.15
Xn_308_n2 n_308 n_4 vss vss sky130_fd_pr__nfet_01v8 W=0.42 L=0.15
Xn_309_n n_309 n_308 vss vss sky130_fd_pr__nfet_01v8 W=0.42 L=0.15
Xn_309_p n_309 n_308 vdd vdd sky130_fd_pr__pfet_01v8 W=0.7 L=0.15
Xn_312_p1 n_312 n_306 n_312_x vdd sky130_fd_pr__pfet_01v8 W=1.4 L=0.15
Xn_312_p2 n_312_x n_202 vdd vdd sky130_fd_pr__pfet_01v8 W=1.4 L=0.15
Xn_312_n1 n_312 n_306 vss vss sky130_fd_pr__nfet_01v8 W=0.42 L=0.15
Xn_312_n2 n_312 n_202 vss vss sky130_fd_pr__nfet_01v8 W=0.42 L=0.15
Xn_311_p1 n_311 n_312 n_311_x vdd sky130_fd_pr__pfet_01v8 W=1.4 L=0.15
Xn_311_p2 n_311_x n_310 vdd vdd sky130_fd_pr__pfet_01v8 W=1.4 L=0.15
Xn_311_n1 n_311 n_312 vss vss sky130_fd_pr__nfet_01v8 W=0.42 L=0.15
Xn_311_n2 n_311 n_310 vss vss sky130_fd_pr__nfet_01v8 W=0.42 L=0.15
Xn_310_p1 n_310 n_309 n_310_x vdd sky130_fd_pr__pfet_01v8 W=1.4 L=0.15
Xn_310_p2 n_310_x n_311 vdd vdd sky130_fd_pr__pfet_01v8 W=1.4 L=0.15
Xn_310_n1 n_310 n_309 vss vss sky130_fd_pr__nfet_01v8 W=0.42 L=0.15
Xn_310_n2 n_310 n_311 vss vss sky130_fd_pr__nfet_01v8 W=0.42 L=0.15
Xn_313_p1 n_313 n_310 n_313_x vdd sky130_fd_pr__pfet_01v8 W=1.4 L=0.15
Xn_313_p2 n_313_x n_205 vdd vdd sky130_fd_pr__pfet_01v8 W=1.4 L=0.15
Xn_313_n1 n_313 n_310 vss vss sky130_fd_pr__nfet_01v8 W=0.42 L=0.15
Xn_313_n2 n_313 n_205 vss vss sky130_fd_pr__nfet_01v8 W=0.42 L=0.15
Xn_314_p1 n_314 n_313 n_314_x vdd sky130_fd_pr__pfet_01v8 W=1.4 L=0.15
Xn_314_p2 n_314_x n_4 vdd vdd sky130_fd_pr__pfet_01v8 W=1.4 L=0.15
Xn_314_n1 n_314 n_313 vss vss sky130_fd_pr__nfet_01v8 W=0.42 L=0.15
Xn_314_n2 n_314 n_4 vss vss sky130_fd_pr__nfet_01v8 W=0.42 L=0.15
Xn_315_n n_315 n_314 vss vss sky130_fd_pr__nfet_01v8 W=0.42 L=0.15
Xn_315_p n_315 n_314 vdd vdd sky130_fd_pr__pfet_01v8 W=0.7 L=0.15
Xn_317_p1 n_317 n_311 n_317_x vdd sky130_fd_pr__pfet_01v8 W=1.4 L=0.15
Xn_317_p2 n_317_x n_205 vdd vdd sky130_fd_pr__pfet_01v8 W=1.4 L=0.15
Xn_317_n1 n_317 n_311 vss vss sky130_fd_pr__nfet_01v8 W=0.42 L=0.15
Xn_317_n2 n_317 n_205 vss vss sky130_fd_pr__nfet_01v8 W=0.42 L=0.15
Xn_316_p1 n_316 n_317 n_316_x vdd sky130_fd_pr__pfet_01v8 W=1.4 L=0.15
Xn_316_p2 n_316_x cnt3 vdd vdd sky130_fd_pr__pfet_01v8 W=1.4 L=0.15
Xn_316_n1 n_316 n_317 vss vss sky130_fd_pr__nfet_01v8 W=0.42 L=0.15
Xn_316_n2 n_316 cnt3 vss vss sky130_fd_pr__nfet_01v8 W=0.42 L=0.15
Xcnt3_p1 cnt3 n_315 cnt3_x vdd sky130_fd_pr__pfet_01v8 W=1.4 L=0.15
Xcnt3_p2 cnt3_x n_316 vdd vdd sky130_fd_pr__pfet_01v8 W=1.4 L=0.15
Xcnt3_n1 cnt3 n_315 vss vss sky130_fd_pr__nfet_01v8 W=0.42 L=0.15
Xcnt3_n2 cnt3 n_316 vss vss sky130_fd_pr__nfet_01v8 W=0.42 L=0.15
Xn_318_p1 n_318 cnt3 vdd vdd sky130_fd_pr__pfet_01v8 W=0.7 L=0.15
Xn_318_p2 n_318 n_299 vdd vdd sky130_fd_pr__pfet_01v8 W=0.7 L=0.15
Xn_318_n1 n_318 cnt3 n_318_x vss sky130_fd_pr__nfet_01v8 W=0.84 L=0.15
Xn_318_n2 n_318_x n_299 vss vss sky130_fd_pr__nfet_01v8 W=0.84 L=0.15
Xn_319_n n_319 n_318 vss vss sky130_fd_pr__nfet_01v8 W=0.42 L=0.15
Xn_319_p n_319 n_318 vdd vdd sky130_fd_pr__pfet_01v8 W=0.7 L=0.15
Xn_320_p1 n_320 cnt4 vdd vdd sky130_fd_pr__pfet_01v8 W=0.7 L=0.15
Xn_320_p2 n_320 n_319 vdd vdd sky130_fd_pr__pfet_01v8 W=0.7 L=0.15
Xn_320_n1 n_320 cnt4 n_320_x vss sky130_fd_pr__nfet_01v8 W=0.84 L=0.15
Xn_320_n2 n_320_x n_319 vss vss sky130_fd_pr__nfet_01v8 W=0.84 L=0.15
Xn_321_p1 n_321 cnt4 vdd vdd sky130_fd_pr__pfet_01v8 W=0.7 L=0.15
Xn_321_p2 n_321 n_320 vdd vdd sky130_fd_pr__pfet_01v8 W=0.7 L=0.15
Xn_321_n1 n_321 cnt4 n_321_x vss sky130_fd_pr__nfet_01v8 W=0.84 L=0.15
Xn_321_n2 n_321_x n_320 vss vss sky130_fd_pr__nfet_01v8 W=0.84 L=0.15
Xn_322_p1 n_322 n_319 vdd vdd sky130_fd_pr__pfet_01v8 W=0.7 L=0.15
Xn_322_p2 n_322 n_320 vdd vdd sky130_fd_pr__pfet_01v8 W=0.7 L=0.15
Xn_322_n1 n_322 n_319 n_322_x vss sky130_fd_pr__nfet_01v8 W=0.84 L=0.15
Xn_322_n2 n_322_x n_320 vss vss sky130_fd_pr__nfet_01v8 W=0.84 L=0.15
Xn_323_p1 n_323 n_321 vdd vdd sky130_fd_pr__pfet_01v8 W=0.7 L=0.15
Xn_323_p2 n_323 n_322 vdd vdd sky130_fd_pr__pfet_01v8 W=0.7 L=0.15
Xn_323_n1 n_323 n_321 n_323_x vss sky130_fd_pr__nfet_01v8 W=0.84 L=0.15
Xn_323_n2 n_323_x n_322 vss vss sky130_fd_pr__nfet_01v8 W=0.84 L=0.15
Xn_324_p1 n_324 n_236 vdd vdd sky130_fd_pr__pfet_01v8 W=0.7 L=0.15
Xn_324_p2 n_324 n_323 vdd vdd sky130_fd_pr__pfet_01v8 W=0.7 L=0.15
Xn_324_n1 n_324 n_236 n_324_x vss sky130_fd_pr__nfet_01v8 W=0.84 L=0.15
Xn_324_n2 n_324_x n_323 vss vss sky130_fd_pr__nfet_01v8 W=0.84 L=0.15
Xn_325_n n_325 n_324 vss vss sky130_fd_pr__nfet_01v8 W=0.42 L=0.15
Xn_325_p n_325 n_324 vdd vdd sky130_fd_pr__pfet_01v8 W=0.7 L=0.15
Xn_326_n n_326 n_325 vss vss sky130_fd_pr__nfet_01v8 W=0.42 L=0.15
Xn_326_p n_326 n_325 vdd vdd sky130_fd_pr__pfet_01v8 W=0.7 L=0.15
Xn_327_p1 n_327 n_325 n_327_x vdd sky130_fd_pr__pfet_01v8 W=1.4 L=0.15
Xn_327_p2 n_327_x n_202 vdd vdd sky130_fd_pr__pfet_01v8 W=1.4 L=0.15
Xn_327_n1 n_327 n_325 vss vss sky130_fd_pr__nfet_01v8 W=0.42 L=0.15
Xn_327_n2 n_327 n_202 vss vss sky130_fd_pr__nfet_01v8 W=0.42 L=0.15
Xn_328_p1 n_328 n_327 n_328_x vdd sky130_fd_pr__pfet_01v8 W=1.4 L=0.15
Xn_328_p2 n_328_x n_4 vdd vdd sky130_fd_pr__pfet_01v8 W=1.4 L=0.15
Xn_328_n1 n_328 n_327 vss vss sky130_fd_pr__nfet_01v8 W=0.42 L=0.15
Xn_328_n2 n_328 n_4 vss vss sky130_fd_pr__nfet_01v8 W=0.42 L=0.15
Xn_329_n n_329 n_328 vss vss sky130_fd_pr__nfet_01v8 W=0.42 L=0.15
Xn_329_p n_329 n_328 vdd vdd sky130_fd_pr__pfet_01v8 W=0.7 L=0.15
Xn_332_p1 n_332 n_326 n_332_x vdd sky130_fd_pr__pfet_01v8 W=1.4 L=0.15
Xn_332_p2 n_332_x n_202 vdd vdd sky130_fd_pr__pfet_01v8 W=1.4 L=0.15
Xn_332_n1 n_332 n_326 vss vss sky130_fd_pr__nfet_01v8 W=0.42 L=0.15
Xn_332_n2 n_332 n_202 vss vss sky130_fd_pr__nfet_01v8 W=0.42 L=0.15
Xn_331_p1 n_331 n_332 n_331_x vdd sky130_fd_pr__pfet_01v8 W=1.4 L=0.15
Xn_331_p2 n_331_x n_330 vdd vdd sky130_fd_pr__pfet_01v8 W=1.4 L=0.15
Xn_331_n1 n_331 n_332 vss vss sky130_fd_pr__nfet_01v8 W=0.42 L=0.15
Xn_331_n2 n_331 n_330 vss vss sky130_fd_pr__nfet_01v8 W=0.42 L=0.15
Xn_330_p1 n_330 n_329 n_330_x vdd sky130_fd_pr__pfet_01v8 W=1.4 L=0.15
Xn_330_p2 n_330_x n_331 vdd vdd sky130_fd_pr__pfet_01v8 W=1.4 L=0.15
Xn_330_n1 n_330 n_329 vss vss sky130_fd_pr__nfet_01v8 W=0.42 L=0.15
Xn_330_n2 n_330 n_331 vss vss sky130_fd_pr__nfet_01v8 W=0.42 L=0.15
Xn_333_p1 n_333 n_330 n_333_x vdd sky130_fd_pr__pfet_01v8 W=1.4 L=0.15
Xn_333_p2 n_333_x n_205 vdd vdd sky130_fd_pr__pfet_01v8 W=1.4 L=0.15
Xn_333_n1 n_333 n_330 vss vss sky130_fd_pr__nfet_01v8 W=0.42 L=0.15
Xn_333_n2 n_333 n_205 vss vss sky130_fd_pr__nfet_01v8 W=0.42 L=0.15
Xn_334_p1 n_334 n_333 n_334_x vdd sky130_fd_pr__pfet_01v8 W=1.4 L=0.15
Xn_334_p2 n_334_x n_4 vdd vdd sky130_fd_pr__pfet_01v8 W=1.4 L=0.15
Xn_334_n1 n_334 n_333 vss vss sky130_fd_pr__nfet_01v8 W=0.42 L=0.15
Xn_334_n2 n_334 n_4 vss vss sky130_fd_pr__nfet_01v8 W=0.42 L=0.15
Xn_335_n n_335 n_334 vss vss sky130_fd_pr__nfet_01v8 W=0.42 L=0.15
Xn_335_p n_335 n_334 vdd vdd sky130_fd_pr__pfet_01v8 W=0.7 L=0.15
Xn_337_p1 n_337 n_331 n_337_x vdd sky130_fd_pr__pfet_01v8 W=1.4 L=0.15
Xn_337_p2 n_337_x n_205 vdd vdd sky130_fd_pr__pfet_01v8 W=1.4 L=0.15
Xn_337_n1 n_337 n_331 vss vss sky130_fd_pr__nfet_01v8 W=0.42 L=0.15
Xn_337_n2 n_337 n_205 vss vss sky130_fd_pr__nfet_01v8 W=0.42 L=0.15
Xn_336_p1 n_336 n_337 n_336_x vdd sky130_fd_pr__pfet_01v8 W=1.4 L=0.15
Xn_336_p2 n_336_x cnt4 vdd vdd sky130_fd_pr__pfet_01v8 W=1.4 L=0.15
Xn_336_n1 n_336 n_337 vss vss sky130_fd_pr__nfet_01v8 W=0.42 L=0.15
Xn_336_n2 n_336 cnt4 vss vss sky130_fd_pr__nfet_01v8 W=0.42 L=0.15
Xcnt4_p1 cnt4 n_335 cnt4_x vdd sky130_fd_pr__pfet_01v8 W=1.4 L=0.15
Xcnt4_p2 cnt4_x n_336 vdd vdd sky130_fd_pr__pfet_01v8 W=1.4 L=0.15
Xcnt4_n1 cnt4 n_335 vss vss sky130_fd_pr__nfet_01v8 W=0.42 L=0.15
Xcnt4_n2 cnt4 n_336 vss vss sky130_fd_pr__nfet_01v8 W=0.42 L=0.15
Xn_338_p1 n_338 cnt4 vdd vdd sky130_fd_pr__pfet_01v8 W=0.7 L=0.15
Xn_338_p2 n_338 n_319 vdd vdd sky130_fd_pr__pfet_01v8 W=0.7 L=0.15
Xn_338_n1 n_338 cnt4 n_338_x vss sky130_fd_pr__nfet_01v8 W=0.84 L=0.15
Xn_338_n2 n_338_x n_319 vss vss sky130_fd_pr__nfet_01v8 W=0.84 L=0.15
Xn_339_n n_339 n_338 vss vss sky130_fd_pr__nfet_01v8 W=0.42 L=0.15
Xn_339_p n_339 n_338 vdd vdd sky130_fd_pr__pfet_01v8 W=0.7 L=0.15
Xn_340_p1 n_340 cnt5 vdd vdd sky130_fd_pr__pfet_01v8 W=0.7 L=0.15
Xn_340_p2 n_340 n_339 vdd vdd sky130_fd_pr__pfet_01v8 W=0.7 L=0.15
Xn_340_n1 n_340 cnt5 n_340_x vss sky130_fd_pr__nfet_01v8 W=0.84 L=0.15
Xn_340_n2 n_340_x n_339 vss vss sky130_fd_pr__nfet_01v8 W=0.84 L=0.15
Xn_341_p1 n_341 cnt5 vdd vdd sky130_fd_pr__pfet_01v8 W=0.7 L=0.15
Xn_341_p2 n_341 n_340 vdd vdd sky130_fd_pr__pfet_01v8 W=0.7 L=0.15
Xn_341_n1 n_341 cnt5 n_341_x vss sky130_fd_pr__nfet_01v8 W=0.84 L=0.15
Xn_341_n2 n_341_x n_340 vss vss sky130_fd_pr__nfet_01v8 W=0.84 L=0.15
Xn_342_p1 n_342 n_339 vdd vdd sky130_fd_pr__pfet_01v8 W=0.7 L=0.15
Xn_342_p2 n_342 n_340 vdd vdd sky130_fd_pr__pfet_01v8 W=0.7 L=0.15
Xn_342_n1 n_342 n_339 n_342_x vss sky130_fd_pr__nfet_01v8 W=0.84 L=0.15
Xn_342_n2 n_342_x n_340 vss vss sky130_fd_pr__nfet_01v8 W=0.84 L=0.15
Xn_343_p1 n_343 n_341 vdd vdd sky130_fd_pr__pfet_01v8 W=0.7 L=0.15
Xn_343_p2 n_343 n_342 vdd vdd sky130_fd_pr__pfet_01v8 W=0.7 L=0.15
Xn_343_n1 n_343 n_341 n_343_x vss sky130_fd_pr__nfet_01v8 W=0.84 L=0.15
Xn_343_n2 n_343_x n_342 vss vss sky130_fd_pr__nfet_01v8 W=0.84 L=0.15
Xn_344_p1 n_344 n_236 vdd vdd sky130_fd_pr__pfet_01v8 W=0.7 L=0.15
Xn_344_p2 n_344 n_343 vdd vdd sky130_fd_pr__pfet_01v8 W=0.7 L=0.15
Xn_344_n1 n_344 n_236 n_344_x vss sky130_fd_pr__nfet_01v8 W=0.84 L=0.15
Xn_344_n2 n_344_x n_343 vss vss sky130_fd_pr__nfet_01v8 W=0.84 L=0.15
Xn_345_n n_345 n_344 vss vss sky130_fd_pr__nfet_01v8 W=0.42 L=0.15
Xn_345_p n_345 n_344 vdd vdd sky130_fd_pr__pfet_01v8 W=0.7 L=0.15
Xn_346_n n_346 n_345 vss vss sky130_fd_pr__nfet_01v8 W=0.42 L=0.15
Xn_346_p n_346 n_345 vdd vdd sky130_fd_pr__pfet_01v8 W=0.7 L=0.15
Xn_347_p1 n_347 n_345 n_347_x vdd sky130_fd_pr__pfet_01v8 W=1.4 L=0.15
Xn_347_p2 n_347_x n_202 vdd vdd sky130_fd_pr__pfet_01v8 W=1.4 L=0.15
Xn_347_n1 n_347 n_345 vss vss sky130_fd_pr__nfet_01v8 W=0.42 L=0.15
Xn_347_n2 n_347 n_202 vss vss sky130_fd_pr__nfet_01v8 W=0.42 L=0.15
Xn_348_p1 n_348 n_347 n_348_x vdd sky130_fd_pr__pfet_01v8 W=1.4 L=0.15
Xn_348_p2 n_348_x n_4 vdd vdd sky130_fd_pr__pfet_01v8 W=1.4 L=0.15
Xn_348_n1 n_348 n_347 vss vss sky130_fd_pr__nfet_01v8 W=0.42 L=0.15
Xn_348_n2 n_348 n_4 vss vss sky130_fd_pr__nfet_01v8 W=0.42 L=0.15
Xn_349_n n_349 n_348 vss vss sky130_fd_pr__nfet_01v8 W=0.42 L=0.15
Xn_349_p n_349 n_348 vdd vdd sky130_fd_pr__pfet_01v8 W=0.7 L=0.15
Xn_352_p1 n_352 n_346 n_352_x vdd sky130_fd_pr__pfet_01v8 W=1.4 L=0.15
Xn_352_p2 n_352_x n_202 vdd vdd sky130_fd_pr__pfet_01v8 W=1.4 L=0.15
Xn_352_n1 n_352 n_346 vss vss sky130_fd_pr__nfet_01v8 W=0.42 L=0.15
Xn_352_n2 n_352 n_202 vss vss sky130_fd_pr__nfet_01v8 W=0.42 L=0.15
Xn_351_p1 n_351 n_352 n_351_x vdd sky130_fd_pr__pfet_01v8 W=1.4 L=0.15
Xn_351_p2 n_351_x n_350 vdd vdd sky130_fd_pr__pfet_01v8 W=1.4 L=0.15
Xn_351_n1 n_351 n_352 vss vss sky130_fd_pr__nfet_01v8 W=0.42 L=0.15
Xn_351_n2 n_351 n_350 vss vss sky130_fd_pr__nfet_01v8 W=0.42 L=0.15
Xn_350_p1 n_350 n_349 n_350_x vdd sky130_fd_pr__pfet_01v8 W=1.4 L=0.15
Xn_350_p2 n_350_x n_351 vdd vdd sky130_fd_pr__pfet_01v8 W=1.4 L=0.15
Xn_350_n1 n_350 n_349 vss vss sky130_fd_pr__nfet_01v8 W=0.42 L=0.15
Xn_350_n2 n_350 n_351 vss vss sky130_fd_pr__nfet_01v8 W=0.42 L=0.15
Xn_353_p1 n_353 n_350 n_353_x vdd sky130_fd_pr__pfet_01v8 W=1.4 L=0.15
Xn_353_p2 n_353_x n_205 vdd vdd sky130_fd_pr__pfet_01v8 W=1.4 L=0.15
Xn_353_n1 n_353 n_350 vss vss sky130_fd_pr__nfet_01v8 W=0.42 L=0.15
Xn_353_n2 n_353 n_205 vss vss sky130_fd_pr__nfet_01v8 W=0.42 L=0.15
Xn_354_p1 n_354 n_353 n_354_x vdd sky130_fd_pr__pfet_01v8 W=1.4 L=0.15
Xn_354_p2 n_354_x n_4 vdd vdd sky130_fd_pr__pfet_01v8 W=1.4 L=0.15
Xn_354_n1 n_354 n_353 vss vss sky130_fd_pr__nfet_01v8 W=0.42 L=0.15
Xn_354_n2 n_354 n_4 vss vss sky130_fd_pr__nfet_01v8 W=0.42 L=0.15
Xn_355_n n_355 n_354 vss vss sky130_fd_pr__nfet_01v8 W=0.42 L=0.15
Xn_355_p n_355 n_354 vdd vdd sky130_fd_pr__pfet_01v8 W=0.7 L=0.15
Xn_357_p1 n_357 n_351 n_357_x vdd sky130_fd_pr__pfet_01v8 W=1.4 L=0.15
Xn_357_p2 n_357_x n_205 vdd vdd sky130_fd_pr__pfet_01v8 W=1.4 L=0.15
Xn_357_n1 n_357 n_351 vss vss sky130_fd_pr__nfet_01v8 W=0.42 L=0.15
Xn_357_n2 n_357 n_205 vss vss sky130_fd_pr__nfet_01v8 W=0.42 L=0.15
Xn_356_p1 n_356 n_357 n_356_x vdd sky130_fd_pr__pfet_01v8 W=1.4 L=0.15
Xn_356_p2 n_356_x cnt5 vdd vdd sky130_fd_pr__pfet_01v8 W=1.4 L=0.15
Xn_356_n1 n_356 n_357 vss vss sky130_fd_pr__nfet_01v8 W=0.42 L=0.15
Xn_356_n2 n_356 cnt5 vss vss sky130_fd_pr__nfet_01v8 W=0.42 L=0.15
Xcnt5_p1 cnt5 n_355 cnt5_x vdd sky130_fd_pr__pfet_01v8 W=1.4 L=0.15
Xcnt5_p2 cnt5_x n_356 vdd vdd sky130_fd_pr__pfet_01v8 W=1.4 L=0.15
Xcnt5_n1 cnt5 n_355 vss vss sky130_fd_pr__nfet_01v8 W=0.42 L=0.15
Xcnt5_n2 cnt5 n_356 vss vss sky130_fd_pr__nfet_01v8 W=0.42 L=0.15
Xn_358_p1 n_358 cnt5 vdd vdd sky130_fd_pr__pfet_01v8 W=0.7 L=0.15
Xn_358_p2 n_358 n_339 vdd vdd sky130_fd_pr__pfet_01v8 W=0.7 L=0.15
Xn_358_n1 n_358 cnt5 n_358_x vss sky130_fd_pr__nfet_01v8 W=0.84 L=0.15
Xn_358_n2 n_358_x n_339 vss vss sky130_fd_pr__nfet_01v8 W=0.84 L=0.15
Xn_359_n n_359 n_358 vss vss sky130_fd_pr__nfet_01v8 W=0.42 L=0.15
Xn_359_p n_359 n_358 vdd vdd sky130_fd_pr__pfet_01v8 W=0.7 L=0.15
Xn_360_p1 n_360 cnt6 vdd vdd sky130_fd_pr__pfet_01v8 W=0.7 L=0.15
Xn_360_p2 n_360 n_359 vdd vdd sky130_fd_pr__pfet_01v8 W=0.7 L=0.15
Xn_360_n1 n_360 cnt6 n_360_x vss sky130_fd_pr__nfet_01v8 W=0.84 L=0.15
Xn_360_n2 n_360_x n_359 vss vss sky130_fd_pr__nfet_01v8 W=0.84 L=0.15
Xn_361_p1 n_361 cnt6 vdd vdd sky130_fd_pr__pfet_01v8 W=0.7 L=0.15
Xn_361_p2 n_361 n_360 vdd vdd sky130_fd_pr__pfet_01v8 W=0.7 L=0.15
Xn_361_n1 n_361 cnt6 n_361_x vss sky130_fd_pr__nfet_01v8 W=0.84 L=0.15
Xn_361_n2 n_361_x n_360 vss vss sky130_fd_pr__nfet_01v8 W=0.84 L=0.15
Xn_362_p1 n_362 n_359 vdd vdd sky130_fd_pr__pfet_01v8 W=0.7 L=0.15
Xn_362_p2 n_362 n_360 vdd vdd sky130_fd_pr__pfet_01v8 W=0.7 L=0.15
Xn_362_n1 n_362 n_359 n_362_x vss sky130_fd_pr__nfet_01v8 W=0.84 L=0.15
Xn_362_n2 n_362_x n_360 vss vss sky130_fd_pr__nfet_01v8 W=0.84 L=0.15
Xn_363_p1 n_363 n_361 vdd vdd sky130_fd_pr__pfet_01v8 W=0.7 L=0.15
Xn_363_p2 n_363 n_362 vdd vdd sky130_fd_pr__pfet_01v8 W=0.7 L=0.15
Xn_363_n1 n_363 n_361 n_363_x vss sky130_fd_pr__nfet_01v8 W=0.84 L=0.15
Xn_363_n2 n_363_x n_362 vss vss sky130_fd_pr__nfet_01v8 W=0.84 L=0.15
Xn_364_p1 n_364 n_236 vdd vdd sky130_fd_pr__pfet_01v8 W=0.7 L=0.15
Xn_364_p2 n_364 n_363 vdd vdd sky130_fd_pr__pfet_01v8 W=0.7 L=0.15
Xn_364_n1 n_364 n_236 n_364_x vss sky130_fd_pr__nfet_01v8 W=0.84 L=0.15
Xn_364_n2 n_364_x n_363 vss vss sky130_fd_pr__nfet_01v8 W=0.84 L=0.15
Xn_365_n n_365 n_364 vss vss sky130_fd_pr__nfet_01v8 W=0.42 L=0.15
Xn_365_p n_365 n_364 vdd vdd sky130_fd_pr__pfet_01v8 W=0.7 L=0.15
Xn_366_n n_366 n_365 vss vss sky130_fd_pr__nfet_01v8 W=0.42 L=0.15
Xn_366_p n_366 n_365 vdd vdd sky130_fd_pr__pfet_01v8 W=0.7 L=0.15
Xn_367_p1 n_367 n_365 n_367_x vdd sky130_fd_pr__pfet_01v8 W=1.4 L=0.15
Xn_367_p2 n_367_x n_202 vdd vdd sky130_fd_pr__pfet_01v8 W=1.4 L=0.15
Xn_367_n1 n_367 n_365 vss vss sky130_fd_pr__nfet_01v8 W=0.42 L=0.15
Xn_367_n2 n_367 n_202 vss vss sky130_fd_pr__nfet_01v8 W=0.42 L=0.15
Xn_368_p1 n_368 n_367 n_368_x vdd sky130_fd_pr__pfet_01v8 W=1.4 L=0.15
Xn_368_p2 n_368_x n_4 vdd vdd sky130_fd_pr__pfet_01v8 W=1.4 L=0.15
Xn_368_n1 n_368 n_367 vss vss sky130_fd_pr__nfet_01v8 W=0.42 L=0.15
Xn_368_n2 n_368 n_4 vss vss sky130_fd_pr__nfet_01v8 W=0.42 L=0.15
Xn_369_n n_369 n_368 vss vss sky130_fd_pr__nfet_01v8 W=0.42 L=0.15
Xn_369_p n_369 n_368 vdd vdd sky130_fd_pr__pfet_01v8 W=0.7 L=0.15
Xn_372_p1 n_372 n_366 n_372_x vdd sky130_fd_pr__pfet_01v8 W=1.4 L=0.15
Xn_372_p2 n_372_x n_202 vdd vdd sky130_fd_pr__pfet_01v8 W=1.4 L=0.15
Xn_372_n1 n_372 n_366 vss vss sky130_fd_pr__nfet_01v8 W=0.42 L=0.15
Xn_372_n2 n_372 n_202 vss vss sky130_fd_pr__nfet_01v8 W=0.42 L=0.15
Xn_371_p1 n_371 n_372 n_371_x vdd sky130_fd_pr__pfet_01v8 W=1.4 L=0.15
Xn_371_p2 n_371_x n_370 vdd vdd sky130_fd_pr__pfet_01v8 W=1.4 L=0.15
Xn_371_n1 n_371 n_372 vss vss sky130_fd_pr__nfet_01v8 W=0.42 L=0.15
Xn_371_n2 n_371 n_370 vss vss sky130_fd_pr__nfet_01v8 W=0.42 L=0.15
Xn_370_p1 n_370 n_369 n_370_x vdd sky130_fd_pr__pfet_01v8 W=1.4 L=0.15
Xn_370_p2 n_370_x n_371 vdd vdd sky130_fd_pr__pfet_01v8 W=1.4 L=0.15
Xn_370_n1 n_370 n_369 vss vss sky130_fd_pr__nfet_01v8 W=0.42 L=0.15
Xn_370_n2 n_370 n_371 vss vss sky130_fd_pr__nfet_01v8 W=0.42 L=0.15
Xn_373_p1 n_373 n_370 n_373_x vdd sky130_fd_pr__pfet_01v8 W=1.4 L=0.15
Xn_373_p2 n_373_x n_205 vdd vdd sky130_fd_pr__pfet_01v8 W=1.4 L=0.15
Xn_373_n1 n_373 n_370 vss vss sky130_fd_pr__nfet_01v8 W=0.42 L=0.15
Xn_373_n2 n_373 n_205 vss vss sky130_fd_pr__nfet_01v8 W=0.42 L=0.15
Xn_374_p1 n_374 n_373 n_374_x vdd sky130_fd_pr__pfet_01v8 W=1.4 L=0.15
Xn_374_p2 n_374_x n_4 vdd vdd sky130_fd_pr__pfet_01v8 W=1.4 L=0.15
Xn_374_n1 n_374 n_373 vss vss sky130_fd_pr__nfet_01v8 W=0.42 L=0.15
Xn_374_n2 n_374 n_4 vss vss sky130_fd_pr__nfet_01v8 W=0.42 L=0.15
Xn_375_n n_375 n_374 vss vss sky130_fd_pr__nfet_01v8 W=0.42 L=0.15
Xn_375_p n_375 n_374 vdd vdd sky130_fd_pr__pfet_01v8 W=0.7 L=0.15
Xn_377_p1 n_377 n_371 n_377_x vdd sky130_fd_pr__pfet_01v8 W=1.4 L=0.15
Xn_377_p2 n_377_x n_205 vdd vdd sky130_fd_pr__pfet_01v8 W=1.4 L=0.15
Xn_377_n1 n_377 n_371 vss vss sky130_fd_pr__nfet_01v8 W=0.42 L=0.15
Xn_377_n2 n_377 n_205 vss vss sky130_fd_pr__nfet_01v8 W=0.42 L=0.15
Xn_376_p1 n_376 n_377 n_376_x vdd sky130_fd_pr__pfet_01v8 W=1.4 L=0.15
Xn_376_p2 n_376_x cnt6 vdd vdd sky130_fd_pr__pfet_01v8 W=1.4 L=0.15
Xn_376_n1 n_376 n_377 vss vss sky130_fd_pr__nfet_01v8 W=0.42 L=0.15
Xn_376_n2 n_376 cnt6 vss vss sky130_fd_pr__nfet_01v8 W=0.42 L=0.15
Xcnt6_p1 cnt6 n_375 cnt6_x vdd sky130_fd_pr__pfet_01v8 W=1.4 L=0.15
Xcnt6_p2 cnt6_x n_376 vdd vdd sky130_fd_pr__pfet_01v8 W=1.4 L=0.15
Xcnt6_n1 cnt6 n_375 vss vss sky130_fd_pr__nfet_01v8 W=0.42 L=0.15
Xcnt6_n2 cnt6 n_376 vss vss sky130_fd_pr__nfet_01v8 W=0.42 L=0.15
Xn_378_p1 n_378 cnt6 vdd vdd sky130_fd_pr__pfet_01v8 W=0.7 L=0.15
Xn_378_p2 n_378 n_359 vdd vdd sky130_fd_pr__pfet_01v8 W=0.7 L=0.15
Xn_378_n1 n_378 cnt6 n_378_x vss sky130_fd_pr__nfet_01v8 W=0.84 L=0.15
Xn_378_n2 n_378_x n_359 vss vss sky130_fd_pr__nfet_01v8 W=0.84 L=0.15
Xn_379_n n_379 n_378 vss vss sky130_fd_pr__nfet_01v8 W=0.42 L=0.15
Xn_379_p n_379 n_378 vdd vdd sky130_fd_pr__pfet_01v8 W=0.7 L=0.15
Xn_380_p1 n_380 cnt7 vdd vdd sky130_fd_pr__pfet_01v8 W=0.7 L=0.15
Xn_380_p2 n_380 n_379 vdd vdd sky130_fd_pr__pfet_01v8 W=0.7 L=0.15
Xn_380_n1 n_380 cnt7 n_380_x vss sky130_fd_pr__nfet_01v8 W=0.84 L=0.15
Xn_380_n2 n_380_x n_379 vss vss sky130_fd_pr__nfet_01v8 W=0.84 L=0.15
Xn_381_p1 n_381 cnt7 vdd vdd sky130_fd_pr__pfet_01v8 W=0.7 L=0.15
Xn_381_p2 n_381 n_380 vdd vdd sky130_fd_pr__pfet_01v8 W=0.7 L=0.15
Xn_381_n1 n_381 cnt7 n_381_x vss sky130_fd_pr__nfet_01v8 W=0.84 L=0.15
Xn_381_n2 n_381_x n_380 vss vss sky130_fd_pr__nfet_01v8 W=0.84 L=0.15
Xn_382_p1 n_382 n_379 vdd vdd sky130_fd_pr__pfet_01v8 W=0.7 L=0.15
Xn_382_p2 n_382 n_380 vdd vdd sky130_fd_pr__pfet_01v8 W=0.7 L=0.15
Xn_382_n1 n_382 n_379 n_382_x vss sky130_fd_pr__nfet_01v8 W=0.84 L=0.15
Xn_382_n2 n_382_x n_380 vss vss sky130_fd_pr__nfet_01v8 W=0.84 L=0.15
Xn_383_p1 n_383 n_381 vdd vdd sky130_fd_pr__pfet_01v8 W=0.7 L=0.15
Xn_383_p2 n_383 n_382 vdd vdd sky130_fd_pr__pfet_01v8 W=0.7 L=0.15
Xn_383_n1 n_383 n_381 n_383_x vss sky130_fd_pr__nfet_01v8 W=0.84 L=0.15
Xn_383_n2 n_383_x n_382 vss vss sky130_fd_pr__nfet_01v8 W=0.84 L=0.15
Xn_384_p1 n_384 n_236 vdd vdd sky130_fd_pr__pfet_01v8 W=0.7 L=0.15
Xn_384_p2 n_384 n_383 vdd vdd sky130_fd_pr__pfet_01v8 W=0.7 L=0.15
Xn_384_n1 n_384 n_236 n_384_x vss sky130_fd_pr__nfet_01v8 W=0.84 L=0.15
Xn_384_n2 n_384_x n_383 vss vss sky130_fd_pr__nfet_01v8 W=0.84 L=0.15
Xn_385_n n_385 n_384 vss vss sky130_fd_pr__nfet_01v8 W=0.42 L=0.15
Xn_385_p n_385 n_384 vdd vdd sky130_fd_pr__pfet_01v8 W=0.7 L=0.15
Xn_386_n n_386 n_385 vss vss sky130_fd_pr__nfet_01v8 W=0.42 L=0.15
Xn_386_p n_386 n_385 vdd vdd sky130_fd_pr__pfet_01v8 W=0.7 L=0.15
Xn_387_p1 n_387 n_385 n_387_x vdd sky130_fd_pr__pfet_01v8 W=1.4 L=0.15
Xn_387_p2 n_387_x n_202 vdd vdd sky130_fd_pr__pfet_01v8 W=1.4 L=0.15
Xn_387_n1 n_387 n_385 vss vss sky130_fd_pr__nfet_01v8 W=0.42 L=0.15
Xn_387_n2 n_387 n_202 vss vss sky130_fd_pr__nfet_01v8 W=0.42 L=0.15
Xn_388_p1 n_388 n_387 n_388_x vdd sky130_fd_pr__pfet_01v8 W=1.4 L=0.15
Xn_388_p2 n_388_x n_4 vdd vdd sky130_fd_pr__pfet_01v8 W=1.4 L=0.15
Xn_388_n1 n_388 n_387 vss vss sky130_fd_pr__nfet_01v8 W=0.42 L=0.15
Xn_388_n2 n_388 n_4 vss vss sky130_fd_pr__nfet_01v8 W=0.42 L=0.15
Xn_389_n n_389 n_388 vss vss sky130_fd_pr__nfet_01v8 W=0.42 L=0.15
Xn_389_p n_389 n_388 vdd vdd sky130_fd_pr__pfet_01v8 W=0.7 L=0.15
Xn_392_p1 n_392 n_386 n_392_x vdd sky130_fd_pr__pfet_01v8 W=1.4 L=0.15
Xn_392_p2 n_392_x n_202 vdd vdd sky130_fd_pr__pfet_01v8 W=1.4 L=0.15
Xn_392_n1 n_392 n_386 vss vss sky130_fd_pr__nfet_01v8 W=0.42 L=0.15
Xn_392_n2 n_392 n_202 vss vss sky130_fd_pr__nfet_01v8 W=0.42 L=0.15
Xn_391_p1 n_391 n_392 n_391_x vdd sky130_fd_pr__pfet_01v8 W=1.4 L=0.15
Xn_391_p2 n_391_x n_390 vdd vdd sky130_fd_pr__pfet_01v8 W=1.4 L=0.15
Xn_391_n1 n_391 n_392 vss vss sky130_fd_pr__nfet_01v8 W=0.42 L=0.15
Xn_391_n2 n_391 n_390 vss vss sky130_fd_pr__nfet_01v8 W=0.42 L=0.15
Xn_390_p1 n_390 n_389 n_390_x vdd sky130_fd_pr__pfet_01v8 W=1.4 L=0.15
Xn_390_p2 n_390_x n_391 vdd vdd sky130_fd_pr__pfet_01v8 W=1.4 L=0.15
Xn_390_n1 n_390 n_389 vss vss sky130_fd_pr__nfet_01v8 W=0.42 L=0.15
Xn_390_n2 n_390 n_391 vss vss sky130_fd_pr__nfet_01v8 W=0.42 L=0.15
Xn_393_p1 n_393 n_390 n_393_x vdd sky130_fd_pr__pfet_01v8 W=1.4 L=0.15
Xn_393_p2 n_393_x n_205 vdd vdd sky130_fd_pr__pfet_01v8 W=1.4 L=0.15
Xn_393_n1 n_393 n_390 vss vss sky130_fd_pr__nfet_01v8 W=0.42 L=0.15
Xn_393_n2 n_393 n_205 vss vss sky130_fd_pr__nfet_01v8 W=0.42 L=0.15
Xn_394_p1 n_394 n_393 n_394_x vdd sky130_fd_pr__pfet_01v8 W=1.4 L=0.15
Xn_394_p2 n_394_x n_4 vdd vdd sky130_fd_pr__pfet_01v8 W=1.4 L=0.15
Xn_394_n1 n_394 n_393 vss vss sky130_fd_pr__nfet_01v8 W=0.42 L=0.15
Xn_394_n2 n_394 n_4 vss vss sky130_fd_pr__nfet_01v8 W=0.42 L=0.15
Xn_395_n n_395 n_394 vss vss sky130_fd_pr__nfet_01v8 W=0.42 L=0.15
Xn_395_p n_395 n_394 vdd vdd sky130_fd_pr__pfet_01v8 W=0.7 L=0.15
Xn_397_p1 n_397 n_391 n_397_x vdd sky130_fd_pr__pfet_01v8 W=1.4 L=0.15
Xn_397_p2 n_397_x n_205 vdd vdd sky130_fd_pr__pfet_01v8 W=1.4 L=0.15
Xn_397_n1 n_397 n_391 vss vss sky130_fd_pr__nfet_01v8 W=0.42 L=0.15
Xn_397_n2 n_397 n_205 vss vss sky130_fd_pr__nfet_01v8 W=0.42 L=0.15
Xn_396_p1 n_396 n_397 n_396_x vdd sky130_fd_pr__pfet_01v8 W=1.4 L=0.15
Xn_396_p2 n_396_x cnt7 vdd vdd sky130_fd_pr__pfet_01v8 W=1.4 L=0.15
Xn_396_n1 n_396 n_397 vss vss sky130_fd_pr__nfet_01v8 W=0.42 L=0.15
Xn_396_n2 n_396 cnt7 vss vss sky130_fd_pr__nfet_01v8 W=0.42 L=0.15
Xcnt7_p1 cnt7 n_395 cnt7_x vdd sky130_fd_pr__pfet_01v8 W=1.4 L=0.15
Xcnt7_p2 cnt7_x n_396 vdd vdd sky130_fd_pr__pfet_01v8 W=1.4 L=0.15
Xcnt7_n1 cnt7 n_395 vss vss sky130_fd_pr__nfet_01v8 W=0.42 L=0.15
Xcnt7_n2 cnt7 n_396 vss vss sky130_fd_pr__nfet_01v8 W=0.42 L=0.15
Xn_398_n n_398 n_234 vss vss sky130_fd_pr__nfet_01v8 W=0.42 L=0.15
Xn_398_p n_398 n_234 vdd vdd sky130_fd_pr__pfet_01v8 W=0.7 L=0.15
Xn_399_p1 n_399 s1 vdd vdd sky130_fd_pr__pfet_01v8 W=0.7 L=0.15
Xn_399_p2 n_399 n_398 vdd vdd sky130_fd_pr__pfet_01v8 W=0.7 L=0.15
Xn_399_n1 n_399 s1 n_399_x vss sky130_fd_pr__nfet_01v8 W=0.84 L=0.15
Xn_399_n2 n_399_x n_398 vss vss sky130_fd_pr__nfet_01v8 W=0.84 L=0.15
Xn_400_n n_400 n_399 vss vss sky130_fd_pr__nfet_01v8 W=0.42 L=0.15
Xn_400_p n_400 n_399 vdd vdd sky130_fd_pr__pfet_01v8 W=0.7 L=0.15
Xn_401_n n_401 pw vss vss sky130_fd_pr__nfet_01v8 W=0.42 L=0.15
Xn_401_p n_401 pw vdd vdd sky130_fd_pr__pfet_01v8 W=0.7 L=0.15
Xn_402_p1 n_402 n_400 vdd vdd sky130_fd_pr__pfet_01v8 W=0.7 L=0.15
Xn_402_p2 n_402 n_401 vdd vdd sky130_fd_pr__pfet_01v8 W=0.7 L=0.15
Xn_402_n1 n_402 n_400 n_402_x vss sky130_fd_pr__nfet_01v8 W=0.84 L=0.15
Xn_402_n2 n_402_x n_401 vss vss sky130_fd_pr__nfet_01v8 W=0.84 L=0.15
Xn_403_n n_403 n_402 vss vss sky130_fd_pr__nfet_01v8 W=0.42 L=0.15
Xn_403_p n_403 n_402 vdd vdd sky130_fd_pr__pfet_01v8 W=0.7 L=0.15
Xn_404_n n_404 n_403 vss vss sky130_fd_pr__nfet_01v8 W=0.42 L=0.15
Xn_404_p n_404 n_403 vdd vdd sky130_fd_pr__pfet_01v8 W=0.7 L=0.15
Xn_405_p1 n_405 n_403 n_405_x vdd sky130_fd_pr__pfet_01v8 W=1.4 L=0.15
Xn_405_p2 n_405_x n_202 vdd vdd sky130_fd_pr__pfet_01v8 W=1.4 L=0.15
Xn_405_n1 n_405 n_403 vss vss sky130_fd_pr__nfet_01v8 W=0.42 L=0.15
Xn_405_n2 n_405 n_202 vss vss sky130_fd_pr__nfet_01v8 W=0.42 L=0.15
Xn_406_p1 n_406 n_405 n_406_x vdd sky130_fd_pr__pfet_01v8 W=1.4 L=0.15
Xn_406_p2 n_406_x n_4 vdd vdd sky130_fd_pr__pfet_01v8 W=1.4 L=0.15
Xn_406_n1 n_406 n_405 vss vss sky130_fd_pr__nfet_01v8 W=0.42 L=0.15
Xn_406_n2 n_406 n_4 vss vss sky130_fd_pr__nfet_01v8 W=0.42 L=0.15
Xn_407_n n_407 n_406 vss vss sky130_fd_pr__nfet_01v8 W=0.42 L=0.15
Xn_407_p n_407 n_406 vdd vdd sky130_fd_pr__pfet_01v8 W=0.7 L=0.15
Xn_410_p1 n_410 n_404 n_410_x vdd sky130_fd_pr__pfet_01v8 W=1.4 L=0.15
Xn_410_p2 n_410_x n_202 vdd vdd sky130_fd_pr__pfet_01v8 W=1.4 L=0.15
Xn_410_n1 n_410 n_404 vss vss sky130_fd_pr__nfet_01v8 W=0.42 L=0.15
Xn_410_n2 n_410 n_202 vss vss sky130_fd_pr__nfet_01v8 W=0.42 L=0.15
Xn_409_p1 n_409 n_410 n_409_x vdd sky130_fd_pr__pfet_01v8 W=1.4 L=0.15
Xn_409_p2 n_409_x n_408 vdd vdd sky130_fd_pr__pfet_01v8 W=1.4 L=0.15
Xn_409_n1 n_409 n_410 vss vss sky130_fd_pr__nfet_01v8 W=0.42 L=0.15
Xn_409_n2 n_409 n_408 vss vss sky130_fd_pr__nfet_01v8 W=0.42 L=0.15
Xn_408_p1 n_408 n_407 n_408_x vdd sky130_fd_pr__pfet_01v8 W=1.4 L=0.15
Xn_408_p2 n_408_x n_409 vdd vdd sky130_fd_pr__pfet_01v8 W=1.4 L=0.15
Xn_408_n1 n_408 n_407 vss vss sky130_fd_pr__nfet_01v8 W=0.42 L=0.15
Xn_408_n2 n_408 n_409 vss vss sky130_fd_pr__nfet_01v8 W=0.42 L=0.15
Xn_411_p1 n_411 n_408 n_411_x vdd sky130_fd_pr__pfet_01v8 W=1.4 L=0.15
Xn_411_p2 n_411_x n_205 vdd vdd sky130_fd_pr__pfet_01v8 W=1.4 L=0.15
Xn_411_n1 n_411 n_408 vss vss sky130_fd_pr__nfet_01v8 W=0.42 L=0.15
Xn_411_n2 n_411 n_205 vss vss sky130_fd_pr__nfet_01v8 W=0.42 L=0.15
Xn_412_p1 n_412 n_411 n_412_x vdd sky130_fd_pr__pfet_01v8 W=1.4 L=0.15
Xn_412_p2 n_412_x n_4 vdd vdd sky130_fd_pr__pfet_01v8 W=1.4 L=0.15
Xn_412_n1 n_412 n_411 vss vss sky130_fd_pr__nfet_01v8 W=0.42 L=0.15
Xn_412_n2 n_412 n_4 vss vss sky130_fd_pr__nfet_01v8 W=0.42 L=0.15
Xn_413_n n_413 n_412 vss vss sky130_fd_pr__nfet_01v8 W=0.42 L=0.15
Xn_413_p n_413 n_412 vdd vdd sky130_fd_pr__pfet_01v8 W=0.7 L=0.15
Xn_415_p1 n_415 n_409 n_415_x vdd sky130_fd_pr__pfet_01v8 W=1.4 L=0.15
Xn_415_p2 n_415_x n_205 vdd vdd sky130_fd_pr__pfet_01v8 W=1.4 L=0.15
Xn_415_n1 n_415 n_409 vss vss sky130_fd_pr__nfet_01v8 W=0.42 L=0.15
Xn_415_n2 n_415 n_205 vss vss sky130_fd_pr__nfet_01v8 W=0.42 L=0.15
Xn_414_p1 n_414 n_415 n_414_x vdd sky130_fd_pr__pfet_01v8 W=1.4 L=0.15
Xn_414_p2 n_414_x w vdd vdd sky130_fd_pr__pfet_01v8 W=1.4 L=0.15
Xn_414_n1 n_414 n_415 vss vss sky130_fd_pr__nfet_01v8 W=0.42 L=0.15
Xn_414_n2 n_414 w vss vss sky130_fd_pr__nfet_01v8 W=0.42 L=0.15
Xw_p1 w n_413 w_x vdd sky130_fd_pr__pfet_01v8 W=1.4 L=0.15
Xw_p2 w_x n_414 vdd vdd sky130_fd_pr__pfet_01v8 W=1.4 L=0.15
Xw_n1 w n_413 vss vss sky130_fd_pr__nfet_01v8 W=0.42 L=0.15
Xw_n2 w n_414 vss vss sky130_fd_pr__nfet_01v8 W=0.42 L=0.15
Xn_416_p1 n_416 s1 vdd vdd sky130_fd_pr__pfet_01v8 W=0.7 L=0.15
Xn_416_p2 n_416 n_234 vdd vdd sky130_fd_pr__pfet_01v8 W=0.7 L=0.15
Xn_416_n1 n_416 s1 n_416_x vss sky130_fd_pr__nfet_01v8 W=0.84 L=0.15
Xn_416_n2 n_416_x n_234 vss vss sky130_fd_pr__nfet_01v8 W=0.84 L=0.15
Xn_417_n n_417 n_416 vss vss sky130_fd_pr__nfet_01v8 W=0.42 L=0.15
Xn_417_p n_417 n_416 vdd vdd sky130_fd_pr__pfet_01v8 W=0.7 L=0.15
Xn_418_p1 n_418 pw n_418_x vdd sky130_fd_pr__pfet_01v8 W=1.4 L=0.15
Xn_418_p2 n_418_x n_417 vdd vdd sky130_fd_pr__pfet_01v8 W=1.4 L=0.15
Xn_418_n1 n_418 pw vss vss sky130_fd_pr__nfet_01v8 W=0.42 L=0.15
Xn_418_n2 n_418 n_417 vss vss sky130_fd_pr__nfet_01v8 W=0.42 L=0.15
Xn_419_n n_419 n_418 vss vss sky130_fd_pr__nfet_01v8 W=0.42 L=0.15
Xn_419_p n_419 n_418 vdd vdd sky130_fd_pr__pfet_01v8 W=0.7 L=0.15
Xn_420_n n_420 n_419 vss vss sky130_fd_pr__nfet_01v8 W=0.42 L=0.15
Xn_420_p n_420 n_419 vdd vdd sky130_fd_pr__pfet_01v8 W=0.7 L=0.15
Xn_421_p1 n_421 n_419 n_421_x vdd sky130_fd_pr__pfet_01v8 W=1.4 L=0.15
Xn_421_p2 n_421_x n_202 vdd vdd sky130_fd_pr__pfet_01v8 W=1.4 L=0.15
Xn_421_n1 n_421 n_419 vss vss sky130_fd_pr__nfet_01v8 W=0.42 L=0.15
Xn_421_n2 n_421 n_202 vss vss sky130_fd_pr__nfet_01v8 W=0.42 L=0.15
Xn_422_p1 n_422 n_421 n_422_x vdd sky130_fd_pr__pfet_01v8 W=1.4 L=0.15
Xn_422_p2 n_422_x n_4 vdd vdd sky130_fd_pr__pfet_01v8 W=1.4 L=0.15
Xn_422_n1 n_422 n_421 vss vss sky130_fd_pr__nfet_01v8 W=0.42 L=0.15
Xn_422_n2 n_422 n_4 vss vss sky130_fd_pr__nfet_01v8 W=0.42 L=0.15
Xn_423_n n_423 n_422 vss vss sky130_fd_pr__nfet_01v8 W=0.42 L=0.15
Xn_423_p n_423 n_422 vdd vdd sky130_fd_pr__pfet_01v8 W=0.7 L=0.15
Xn_426_p1 n_426 n_420 n_426_x vdd sky130_fd_pr__pfet_01v8 W=1.4 L=0.15
Xn_426_p2 n_426_x n_202 vdd vdd sky130_fd_pr__pfet_01v8 W=1.4 L=0.15
Xn_426_n1 n_426 n_420 vss vss sky130_fd_pr__nfet_01v8 W=0.42 L=0.15
Xn_426_n2 n_426 n_202 vss vss sky130_fd_pr__nfet_01v8 W=0.42 L=0.15
Xn_425_p1 n_425 n_426 n_425_x vdd sky130_fd_pr__pfet_01v8 W=1.4 L=0.15
Xn_425_p2 n_425_x n_424 vdd vdd sky130_fd_pr__pfet_01v8 W=1.4 L=0.15
Xn_425_n1 n_425 n_426 vss vss sky130_fd_pr__nfet_01v8 W=0.42 L=0.15
Xn_425_n2 n_425 n_424 vss vss sky130_fd_pr__nfet_01v8 W=0.42 L=0.15
Xn_424_p1 n_424 n_423 n_424_x vdd sky130_fd_pr__pfet_01v8 W=1.4 L=0.15
Xn_424_p2 n_424_x n_425 vdd vdd sky130_fd_pr__pfet_01v8 W=1.4 L=0.15
Xn_424_n1 n_424 n_423 vss vss sky130_fd_pr__nfet_01v8 W=0.42 L=0.15
Xn_424_n2 n_424 n_425 vss vss sky130_fd_pr__nfet_01v8 W=0.42 L=0.15
Xn_427_p1 n_427 n_424 n_427_x vdd sky130_fd_pr__pfet_01v8 W=1.4 L=0.15
Xn_427_p2 n_427_x n_205 vdd vdd sky130_fd_pr__pfet_01v8 W=1.4 L=0.15
Xn_427_n1 n_427 n_424 vss vss sky130_fd_pr__nfet_01v8 W=0.42 L=0.15
Xn_427_n2 n_427 n_205 vss vss sky130_fd_pr__nfet_01v8 W=0.42 L=0.15
Xn_428_p1 n_428 n_427 n_428_x vdd sky130_fd_pr__pfet_01v8 W=1.4 L=0.15
Xn_428_p2 n_428_x n_4 vdd vdd sky130_fd_pr__pfet_01v8 W=1.4 L=0.15
Xn_428_n1 n_428 n_427 vss vss sky130_fd_pr__nfet_01v8 W=0.42 L=0.15
Xn_428_n2 n_428 n_4 vss vss sky130_fd_pr__nfet_01v8 W=0.42 L=0.15
Xn_429_n n_429 n_428 vss vss sky130_fd_pr__nfet_01v8 W=0.42 L=0.15
Xn_429_p n_429 n_428 vdd vdd sky130_fd_pr__pfet_01v8 W=0.7 L=0.15
Xn_431_p1 n_431 n_425 n_431_x vdd sky130_fd_pr__pfet_01v8 W=1.4 L=0.15
Xn_431_p2 n_431_x n_205 vdd vdd sky130_fd_pr__pfet_01v8 W=1.4 L=0.15
Xn_431_n1 n_431 n_425 vss vss sky130_fd_pr__nfet_01v8 W=0.42 L=0.15
Xn_431_n2 n_431 n_205 vss vss sky130_fd_pr__nfet_01v8 W=0.42 L=0.15
Xn_430_p1 n_430 n_431 n_430_x vdd sky130_fd_pr__pfet_01v8 W=1.4 L=0.15
Xn_430_p2 n_430_x pw vdd vdd sky130_fd_pr__pfet_01v8 W=1.4 L=0.15
Xn_430_n1 n_430 n_431 vss vss sky130_fd_pr__nfet_01v8 W=0.42 L=0.15
Xn_430_n2 n_430 pw vss vss sky130_fd_pr__nfet_01v8 W=0.42 L=0.15
Xpw_p1 pw n_429 pw_x vdd sky130_fd_pr__pfet_01v8 W=1.4 L=0.15
Xpw_p2 pw_x n_430 vdd vdd sky130_fd_pr__pfet_01v8 W=1.4 L=0.15
Xpw_n1 pw n_429 vss vss sky130_fd_pr__nfet_01v8 W=0.42 L=0.15
Xpw_n2 pw n_430 vss vss sky130_fd_pr__nfet_01v8 W=0.42 L=0.15
Xn_432_p1 n_432 cnt0 n_432_x vdd sky130_fd_pr__pfet_01v8 W=1.4 L=0.15
Xn_432_p2 n_432_x cnt1 vdd vdd sky130_fd_pr__pfet_01v8 W=1.4 L=0.15
Xn_432_n1 n_432 cnt0 vss vss sky130_fd_pr__nfet_01v8 W=0.42 L=0.15
Xn_432_n2 n_432 cnt1 vss vss sky130_fd_pr__nfet_01v8 W=0.42 L=0.15
Xn_433_n n_433 n_432 vss vss sky130_fd_pr__nfet_01v8 W=0.42 L=0.15
Xn_433_p n_433 n_432 vdd vdd sky130_fd_pr__pfet_01v8 W=0.7 L=0.15
Xn_434_p1 n_434 cnt2 n_434_x vdd sky130_fd_pr__pfet_01v8 W=1.4 L=0.15
Xn_434_p2 n_434_x cnt3 vdd vdd sky130_fd_pr__pfet_01v8 W=1.4 L=0.15
Xn_434_n1 n_434 cnt2 vss vss sky130_fd_pr__nfet_01v8 W=0.42 L=0.15
Xn_434_n2 n_434 cnt3 vss vss sky130_fd_pr__nfet_01v8 W=0.42 L=0.15
Xn_435_n n_435 n_434 vss vss sky130_fd_pr__nfet_01v8 W=0.42 L=0.15
Xn_435_p n_435 n_434 vdd vdd sky130_fd_pr__pfet_01v8 W=0.7 L=0.15
Xn_436_p1 n_436 n_433 n_436_x vdd sky130_fd_pr__pfet_01v8 W=1.4 L=0.15
Xn_436_p2 n_436_x n_435 vdd vdd sky130_fd_pr__pfet_01v8 W=1.4 L=0.15
Xn_436_n1 n_436 n_433 vss vss sky130_fd_pr__nfet_01v8 W=0.42 L=0.15
Xn_436_n2 n_436 n_435 vss vss sky130_fd_pr__nfet_01v8 W=0.42 L=0.15
Xn_437_p1 n_437 n_231 n_437_x vdd sky130_fd_pr__pfet_01v8 W=1.4 L=0.15
Xn_437_p2 n_437_x n_436 vdd vdd sky130_fd_pr__pfet_01v8 W=1.4 L=0.15
Xn_437_n1 n_437 n_231 vss vss sky130_fd_pr__nfet_01v8 W=0.42 L=0.15
Xn_437_n2 n_437 n_436 vss vss sky130_fd_pr__nfet_01v8 W=0.42 L=0.15
Xn_438_n n_438 n_437 vss vss sky130_fd_pr__nfet_01v8 W=0.42 L=0.15
Xn_438_p n_438 n_437 vdd vdd sky130_fd_pr__pfet_01v8 W=0.7 L=0.15
Xn_439_p1 n_439 s1 vdd vdd sky130_fd_pr__pfet_01v8 W=0.7 L=0.15
Xn_439_p2 n_439 n_438 vdd vdd sky130_fd_pr__pfet_01v8 W=0.7 L=0.15
Xn_439_n1 n_439 s1 n_439_x vss sky130_fd_pr__nfet_01v8 W=0.84 L=0.15
Xn_439_n2 n_439_x n_438 vss vss sky130_fd_pr__nfet_01v8 W=0.84 L=0.15
Xn_440_n n_440 n_439 vss vss sky130_fd_pr__nfet_01v8 W=0.42 L=0.15
Xn_440_p n_440 n_439 vdd vdd sky130_fd_pr__pfet_01v8 W=0.7 L=0.15
Xn_441_p1 n_441 p_tile vdd vdd sky130_fd_pr__pfet_01v8 W=0.7 L=0.15
Xn_441_p2 n_441 n_440 vdd vdd sky130_fd_pr__pfet_01v8 W=0.7 L=0.15
Xn_441_n1 n_441 p_tile n_441_x vss sky130_fd_pr__nfet_01v8 W=0.84 L=0.15
Xn_441_n2 n_441_x n_440 vss vss sky130_fd_pr__nfet_01v8 W=0.84 L=0.15
Xn_442_p1 n_442 p_tile vdd vdd sky130_fd_pr__pfet_01v8 W=0.7 L=0.15
Xn_442_p2 n_442 n_441 vdd vdd sky130_fd_pr__pfet_01v8 W=0.7 L=0.15
Xn_442_n1 n_442 p_tile n_442_x vss sky130_fd_pr__nfet_01v8 W=0.84 L=0.15
Xn_442_n2 n_442_x n_441 vss vss sky130_fd_pr__nfet_01v8 W=0.84 L=0.15
Xn_443_p1 n_443 n_440 vdd vdd sky130_fd_pr__pfet_01v8 W=0.7 L=0.15
Xn_443_p2 n_443 n_441 vdd vdd sky130_fd_pr__pfet_01v8 W=0.7 L=0.15
Xn_443_n1 n_443 n_440 n_443_x vss sky130_fd_pr__nfet_01v8 W=0.84 L=0.15
Xn_443_n2 n_443_x n_441 vss vss sky130_fd_pr__nfet_01v8 W=0.84 L=0.15
Xn_444_p1 n_444 n_442 vdd vdd sky130_fd_pr__pfet_01v8 W=0.7 L=0.15
Xn_444_p2 n_444 n_443 vdd vdd sky130_fd_pr__pfet_01v8 W=0.7 L=0.15
Xn_444_n1 n_444 n_442 n_444_x vss sky130_fd_pr__nfet_01v8 W=0.84 L=0.15
Xn_444_n2 n_444_x n_443 vss vss sky130_fd_pr__nfet_01v8 W=0.84 L=0.15
Xn_445_n n_445 n_444 vss vss sky130_fd_pr__nfet_01v8 W=0.42 L=0.15
Xn_445_p n_445 n_444 vdd vdd sky130_fd_pr__pfet_01v8 W=0.7 L=0.15
Xn_446_p1 n_446 n_444 n_446_x vdd sky130_fd_pr__pfet_01v8 W=1.4 L=0.15
Xn_446_p2 n_446_x n_202 vdd vdd sky130_fd_pr__pfet_01v8 W=1.4 L=0.15
Xn_446_n1 n_446 n_444 vss vss sky130_fd_pr__nfet_01v8 W=0.42 L=0.15
Xn_446_n2 n_446 n_202 vss vss sky130_fd_pr__nfet_01v8 W=0.42 L=0.15
Xn_447_p1 n_447 n_446 n_447_x vdd sky130_fd_pr__pfet_01v8 W=1.4 L=0.15
Xn_447_p2 n_447_x n_4 vdd vdd sky130_fd_pr__pfet_01v8 W=1.4 L=0.15
Xn_447_n1 n_447 n_446 vss vss sky130_fd_pr__nfet_01v8 W=0.42 L=0.15
Xn_447_n2 n_447 n_4 vss vss sky130_fd_pr__nfet_01v8 W=0.42 L=0.15
Xn_448_n n_448 n_447 vss vss sky130_fd_pr__nfet_01v8 W=0.42 L=0.15
Xn_448_p n_448 n_447 vdd vdd sky130_fd_pr__pfet_01v8 W=0.7 L=0.15
Xn_451_p1 n_451 n_445 n_451_x vdd sky130_fd_pr__pfet_01v8 W=1.4 L=0.15
Xn_451_p2 n_451_x n_202 vdd vdd sky130_fd_pr__pfet_01v8 W=1.4 L=0.15
Xn_451_n1 n_451 n_445 vss vss sky130_fd_pr__nfet_01v8 W=0.42 L=0.15
Xn_451_n2 n_451 n_202 vss vss sky130_fd_pr__nfet_01v8 W=0.42 L=0.15
Xn_450_p1 n_450 n_451 n_450_x vdd sky130_fd_pr__pfet_01v8 W=1.4 L=0.15
Xn_450_p2 n_450_x n_449 vdd vdd sky130_fd_pr__pfet_01v8 W=1.4 L=0.15
Xn_450_n1 n_450 n_451 vss vss sky130_fd_pr__nfet_01v8 W=0.42 L=0.15
Xn_450_n2 n_450 n_449 vss vss sky130_fd_pr__nfet_01v8 W=0.42 L=0.15
Xn_449_p1 n_449 n_448 n_449_x vdd sky130_fd_pr__pfet_01v8 W=1.4 L=0.15
Xn_449_p2 n_449_x n_450 vdd vdd sky130_fd_pr__pfet_01v8 W=1.4 L=0.15
Xn_449_n1 n_449 n_448 vss vss sky130_fd_pr__nfet_01v8 W=0.42 L=0.15
Xn_449_n2 n_449 n_450 vss vss sky130_fd_pr__nfet_01v8 W=0.42 L=0.15
Xn_452_p1 n_452 n_449 n_452_x vdd sky130_fd_pr__pfet_01v8 W=1.4 L=0.15
Xn_452_p2 n_452_x n_205 vdd vdd sky130_fd_pr__pfet_01v8 W=1.4 L=0.15
Xn_452_n1 n_452 n_449 vss vss sky130_fd_pr__nfet_01v8 W=0.42 L=0.15
Xn_452_n2 n_452 n_205 vss vss sky130_fd_pr__nfet_01v8 W=0.42 L=0.15
Xn_453_p1 n_453 n_452 n_453_x vdd sky130_fd_pr__pfet_01v8 W=1.4 L=0.15
Xn_453_p2 n_453_x n_4 vdd vdd sky130_fd_pr__pfet_01v8 W=1.4 L=0.15
Xn_453_n1 n_453 n_452 vss vss sky130_fd_pr__nfet_01v8 W=0.42 L=0.15
Xn_453_n2 n_453 n_4 vss vss sky130_fd_pr__nfet_01v8 W=0.42 L=0.15
Xn_454_n n_454 n_453 vss vss sky130_fd_pr__nfet_01v8 W=0.42 L=0.15
Xn_454_p n_454 n_453 vdd vdd sky130_fd_pr__pfet_01v8 W=0.7 L=0.15
Xn_456_p1 n_456 n_450 n_456_x vdd sky130_fd_pr__pfet_01v8 W=1.4 L=0.15
Xn_456_p2 n_456_x n_205 vdd vdd sky130_fd_pr__pfet_01v8 W=1.4 L=0.15
Xn_456_n1 n_456 n_450 vss vss sky130_fd_pr__nfet_01v8 W=0.42 L=0.15
Xn_456_n2 n_456 n_205 vss vss sky130_fd_pr__nfet_01v8 W=0.42 L=0.15
Xn_455_p1 n_455 n_456 n_455_x vdd sky130_fd_pr__pfet_01v8 W=1.4 L=0.15
Xn_455_p2 n_455_x p_tile vdd vdd sky130_fd_pr__pfet_01v8 W=1.4 L=0.15
Xn_455_n1 n_455 n_456 vss vss sky130_fd_pr__nfet_01v8 W=0.42 L=0.15
Xn_455_n2 n_455 p_tile vss vss sky130_fd_pr__nfet_01v8 W=0.42 L=0.15
Xp_tile_p1 p_tile n_454 p_tile_x vdd sky130_fd_pr__pfet_01v8 W=1.4 L=0.15
Xp_tile_p2 p_tile_x n_455 vdd vdd sky130_fd_pr__pfet_01v8 W=1.4 L=0.15
Xp_tile_n1 p_tile n_454 vss vss sky130_fd_pr__nfet_01v8 W=0.42 L=0.15
Xp_tile_n2 p_tile n_455 vss vss sky130_fd_pr__nfet_01v8 W=0.42 L=0.15
Xn_457_p1 n_457 pw vdd vdd sky130_fd_pr__pfet_01v8 W=0.7 L=0.15
Xn_457_p2 n_457 lora_en vdd vdd sky130_fd_pr__pfet_01v8 W=0.7 L=0.15
Xn_457_n1 n_457 pw n_457_x vss sky130_fd_pr__nfet_01v8 W=0.84 L=0.15
Xn_457_n2 n_457_x lora_en vss vss sky130_fd_pr__nfet_01v8 W=0.84 L=0.15
Xn_458_n n_458 n_457 vss vss sky130_fd_pr__nfet_01v8 W=0.42 L=0.15
Xn_458_p n_458 n_457 vdd vdd sky130_fd_pr__pfet_01v8 W=0.7 L=0.15
Xn_459_n n_459 cnt2 vss vss sky130_fd_pr__nfet_01v8 W=0.42 L=0.15
Xn_459_p n_459 cnt2 vdd vdd sky130_fd_pr__pfet_01v8 W=0.7 L=0.15
Xn_460_n n_460 cnt3 vss vss sky130_fd_pr__nfet_01v8 W=0.42 L=0.15
Xn_460_p n_460 cnt3 vdd vdd sky130_fd_pr__pfet_01v8 W=0.7 L=0.15
Xn_461_n n_461 cnt4 vss vss sky130_fd_pr__nfet_01v8 W=0.42 L=0.15
Xn_461_p n_461 cnt4 vdd vdd sky130_fd_pr__pfet_01v8 W=0.7 L=0.15
Xn_462_n n_462 cnt5 vss vss sky130_fd_pr__nfet_01v8 W=0.42 L=0.15
Xn_462_p n_462 cnt5 vdd vdd sky130_fd_pr__pfet_01v8 W=0.7 L=0.15
Xn_463_n n_463 cnt6 vss vss sky130_fd_pr__nfet_01v8 W=0.42 L=0.15
Xn_463_p n_463 cnt6 vdd vdd sky130_fd_pr__pfet_01v8 W=0.7 L=0.15
Xn_464_p1 n_464 cnt0 vdd vdd sky130_fd_pr__pfet_01v8 W=0.7 L=0.15
Xn_464_p2 n_464 cnt1 vdd vdd sky130_fd_pr__pfet_01v8 W=0.7 L=0.15
Xn_464_n1 n_464 cnt0 n_464_x vss sky130_fd_pr__nfet_01v8 W=0.84 L=0.15
Xn_464_n2 n_464_x cnt1 vss vss sky130_fd_pr__nfet_01v8 W=0.84 L=0.15
Xn_465_n n_465 n_464 vss vss sky130_fd_pr__nfet_01v8 W=0.42 L=0.15
Xn_465_p n_465 n_464 vdd vdd sky130_fd_pr__pfet_01v8 W=0.7 L=0.15
Xn_466_p1 n_466 n_459 vdd vdd sky130_fd_pr__pfet_01v8 W=0.7 L=0.15
Xn_466_p2 n_466 n_460 vdd vdd sky130_fd_pr__pfet_01v8 W=0.7 L=0.15
Xn_466_n1 n_466 n_459 n_466_x vss sky130_fd_pr__nfet_01v8 W=0.84 L=0.15
Xn_466_n2 n_466_x n_460 vss vss sky130_fd_pr__nfet_01v8 W=0.84 L=0.15
Xn_467_n n_467 n_466 vss vss sky130_fd_pr__nfet_01v8 W=0.42 L=0.15
Xn_467_p n_467 n_466 vdd vdd sky130_fd_pr__pfet_01v8 W=0.7 L=0.15
Xn_468_p1 n_468 n_461 vdd vdd sky130_fd_pr__pfet_01v8 W=0.7 L=0.15
Xn_468_p2 n_468 n_462 vdd vdd sky130_fd_pr__pfet_01v8 W=0.7 L=0.15
Xn_468_n1 n_468 n_461 n_468_x vss sky130_fd_pr__nfet_01v8 W=0.84 L=0.15
Xn_468_n2 n_468_x n_462 vss vss sky130_fd_pr__nfet_01v8 W=0.84 L=0.15
Xn_469_n n_469 n_468 vss vss sky130_fd_pr__nfet_01v8 W=0.42 L=0.15
Xn_469_p n_469 n_468 vdd vdd sky130_fd_pr__pfet_01v8 W=0.7 L=0.15
Xn_470_p1 n_470 n_465 vdd vdd sky130_fd_pr__pfet_01v8 W=0.7 L=0.15
Xn_470_p2 n_470 n_467 vdd vdd sky130_fd_pr__pfet_01v8 W=0.7 L=0.15
Xn_470_n1 n_470 n_465 n_470_x vss sky130_fd_pr__nfet_01v8 W=0.84 L=0.15
Xn_470_n2 n_470_x n_467 vss vss sky130_fd_pr__nfet_01v8 W=0.84 L=0.15
Xn_471_n n_471 n_470 vss vss sky130_fd_pr__nfet_01v8 W=0.42 L=0.15
Xn_471_p n_471 n_470 vdd vdd sky130_fd_pr__pfet_01v8 W=0.7 L=0.15
Xn_472_p1 n_472 n_469 vdd vdd sky130_fd_pr__pfet_01v8 W=0.7 L=0.15
Xn_472_p2 n_472 n_463 vdd vdd sky130_fd_pr__pfet_01v8 W=0.7 L=0.15
Xn_472_n1 n_472 n_469 n_472_x vss sky130_fd_pr__nfet_01v8 W=0.84 L=0.15
Xn_472_n2 n_472_x n_463 vss vss sky130_fd_pr__nfet_01v8 W=0.84 L=0.15
Xn_473_n n_473 n_472 vss vss sky130_fd_pr__nfet_01v8 W=0.42 L=0.15
Xn_473_p n_473 n_472 vdd vdd sky130_fd_pr__pfet_01v8 W=0.7 L=0.15
Xn_474_p1 n_474 n_471 vdd vdd sky130_fd_pr__pfet_01v8 W=0.7 L=0.15
Xn_474_p2 n_474 n_473 vdd vdd sky130_fd_pr__pfet_01v8 W=0.7 L=0.15
Xn_474_n1 n_474 n_471 n_474_x vss sky130_fd_pr__nfet_01v8 W=0.84 L=0.15
Xn_474_n2 n_474_x n_473 vss vss sky130_fd_pr__nfet_01v8 W=0.84 L=0.15
Xn_475_n n_475 n_474 vss vss sky130_fd_pr__nfet_01v8 W=0.42 L=0.15
Xn_475_p n_475 n_474 vdd vdd sky130_fd_pr__pfet_01v8 W=0.7 L=0.15
Xn_476_p1 n_476 n_458 vdd vdd sky130_fd_pr__pfet_01v8 W=0.7 L=0.15
Xn_476_p2 n_476 n_475 vdd vdd sky130_fd_pr__pfet_01v8 W=0.7 L=0.15
Xn_476_n1 n_476 n_458 n_476_x vss sky130_fd_pr__nfet_01v8 W=0.84 L=0.15
Xn_476_n2 n_476_x n_475 vss vss sky130_fd_pr__nfet_01v8 W=0.84 L=0.15
Xn_477_n n_477 n_476 vss vss sky130_fd_pr__nfet_01v8 W=0.42 L=0.15
Xn_477_p n_477 n_476 vdd vdd sky130_fd_pr__pfet_01v8 W=0.7 L=0.15
Xn_478_p1 n_478 r_on n_478_x vdd sky130_fd_pr__pfet_01v8 W=1.4 L=0.15
Xn_478_p2 n_478_x n_477 vdd vdd sky130_fd_pr__pfet_01v8 W=1.4 L=0.15
Xn_478_n1 n_478 r_on vss vss sky130_fd_pr__nfet_01v8 W=0.42 L=0.15
Xn_478_n2 n_478 n_477 vss vss sky130_fd_pr__nfet_01v8 W=0.42 L=0.15
Xn_479_n n_479 n_478 vss vss sky130_fd_pr__nfet_01v8 W=0.42 L=0.15
Xn_479_p n_479 n_478 vdd vdd sky130_fd_pr__pfet_01v8 W=0.7 L=0.15
Xn_480_n n_480 n_479 vss vss sky130_fd_pr__nfet_01v8 W=0.42 L=0.15
Xn_480_p n_480 n_479 vdd vdd sky130_fd_pr__pfet_01v8 W=0.7 L=0.15
Xn_481_p1 n_481 n_479 n_481_x vdd sky130_fd_pr__pfet_01v8 W=1.4 L=0.15
Xn_481_p2 n_481_x n_202 vdd vdd sky130_fd_pr__pfet_01v8 W=1.4 L=0.15
Xn_481_n1 n_481 n_479 vss vss sky130_fd_pr__nfet_01v8 W=0.42 L=0.15
Xn_481_n2 n_481 n_202 vss vss sky130_fd_pr__nfet_01v8 W=0.42 L=0.15
Xn_482_p1 n_482 n_481 n_482_x vdd sky130_fd_pr__pfet_01v8 W=1.4 L=0.15
Xn_482_p2 n_482_x n_4 vdd vdd sky130_fd_pr__pfet_01v8 W=1.4 L=0.15
Xn_482_n1 n_482 n_481 vss vss sky130_fd_pr__nfet_01v8 W=0.42 L=0.15
Xn_482_n2 n_482 n_4 vss vss sky130_fd_pr__nfet_01v8 W=0.42 L=0.15
Xn_483_n n_483 n_482 vss vss sky130_fd_pr__nfet_01v8 W=0.42 L=0.15
Xn_483_p n_483 n_482 vdd vdd sky130_fd_pr__pfet_01v8 W=0.7 L=0.15
Xn_486_p1 n_486 n_480 n_486_x vdd sky130_fd_pr__pfet_01v8 W=1.4 L=0.15
Xn_486_p2 n_486_x n_202 vdd vdd sky130_fd_pr__pfet_01v8 W=1.4 L=0.15
Xn_486_n1 n_486 n_480 vss vss sky130_fd_pr__nfet_01v8 W=0.42 L=0.15
Xn_486_n2 n_486 n_202 vss vss sky130_fd_pr__nfet_01v8 W=0.42 L=0.15
Xn_485_p1 n_485 n_486 n_485_x vdd sky130_fd_pr__pfet_01v8 W=1.4 L=0.15
Xn_485_p2 n_485_x n_484 vdd vdd sky130_fd_pr__pfet_01v8 W=1.4 L=0.15
Xn_485_n1 n_485 n_486 vss vss sky130_fd_pr__nfet_01v8 W=0.42 L=0.15
Xn_485_n2 n_485 n_484 vss vss sky130_fd_pr__nfet_01v8 W=0.42 L=0.15
Xn_484_p1 n_484 n_483 n_484_x vdd sky130_fd_pr__pfet_01v8 W=1.4 L=0.15
Xn_484_p2 n_484_x n_485 vdd vdd sky130_fd_pr__pfet_01v8 W=1.4 L=0.15
Xn_484_n1 n_484 n_483 vss vss sky130_fd_pr__nfet_01v8 W=0.42 L=0.15
Xn_484_n2 n_484 n_485 vss vss sky130_fd_pr__nfet_01v8 W=0.42 L=0.15
Xn_487_p1 n_487 n_484 n_487_x vdd sky130_fd_pr__pfet_01v8 W=1.4 L=0.15
Xn_487_p2 n_487_x n_205 vdd vdd sky130_fd_pr__pfet_01v8 W=1.4 L=0.15
Xn_487_n1 n_487 n_484 vss vss sky130_fd_pr__nfet_01v8 W=0.42 L=0.15
Xn_487_n2 n_487 n_205 vss vss sky130_fd_pr__nfet_01v8 W=0.42 L=0.15
Xn_488_p1 n_488 n_487 n_488_x vdd sky130_fd_pr__pfet_01v8 W=1.4 L=0.15
Xn_488_p2 n_488_x n_4 vdd vdd sky130_fd_pr__pfet_01v8 W=1.4 L=0.15
Xn_488_n1 n_488 n_487 vss vss sky130_fd_pr__nfet_01v8 W=0.42 L=0.15
Xn_488_n2 n_488 n_4 vss vss sky130_fd_pr__nfet_01v8 W=0.42 L=0.15
Xn_489_n n_489 n_488 vss vss sky130_fd_pr__nfet_01v8 W=0.42 L=0.15
Xn_489_p n_489 n_488 vdd vdd sky130_fd_pr__pfet_01v8 W=0.7 L=0.15
Xn_491_p1 n_491 n_485 n_491_x vdd sky130_fd_pr__pfet_01v8 W=1.4 L=0.15
Xn_491_p2 n_491_x n_205 vdd vdd sky130_fd_pr__pfet_01v8 W=1.4 L=0.15
Xn_491_n1 n_491 n_485 vss vss sky130_fd_pr__nfet_01v8 W=0.42 L=0.15
Xn_491_n2 n_491 n_205 vss vss sky130_fd_pr__nfet_01v8 W=0.42 L=0.15
Xn_490_p1 n_490 n_491 n_490_x vdd sky130_fd_pr__pfet_01v8 W=1.4 L=0.15
Xn_490_p2 n_490_x r_on vdd vdd sky130_fd_pr__pfet_01v8 W=1.4 L=0.15
Xn_490_n1 n_490 n_491 vss vss sky130_fd_pr__nfet_01v8 W=0.42 L=0.15
Xn_490_n2 n_490 r_on vss vss sky130_fd_pr__nfet_01v8 W=0.42 L=0.15
Xr_on_p1 r_on n_489 r_on_x vdd sky130_fd_pr__pfet_01v8 W=1.4 L=0.15
Xr_on_p2 r_on_x n_490 vdd vdd sky130_fd_pr__pfet_01v8 W=1.4 L=0.15
Xr_on_n1 r_on n_489 vss vss sky130_fd_pr__nfet_01v8 W=0.42 L=0.15
Xr_on_n2 r_on n_490 vss vss sky130_fd_pr__nfet_01v8 W=0.42 L=0.15
Xn_492_n n_492 cnt1 vss vss sky130_fd_pr__nfet_01v8 W=0.42 L=0.15
Xn_492_p n_492 cnt1 vdd vdd sky130_fd_pr__pfet_01v8 W=0.7 L=0.15
Xn_493_n n_493 cnt3 vss vss sky130_fd_pr__nfet_01v8 W=0.42 L=0.15
Xn_493_p n_493 cnt3 vdd vdd sky130_fd_pr__pfet_01v8 W=0.7 L=0.15
Xn_494_n n_494 cnt6 vss vss sky130_fd_pr__nfet_01v8 W=0.42 L=0.15
Xn_494_p n_494 cnt6 vdd vdd sky130_fd_pr__pfet_01v8 W=0.7 L=0.15
Xn_495_p1 n_495 cnt0 vdd vdd sky130_fd_pr__pfet_01v8 W=0.7 L=0.15
Xn_495_p2 n_495 n_492 vdd vdd sky130_fd_pr__pfet_01v8 W=0.7 L=0.15
Xn_495_n1 n_495 cnt0 n_495_x vss sky130_fd_pr__nfet_01v8 W=0.84 L=0.15
Xn_495_n2 n_495_x n_492 vss vss sky130_fd_pr__nfet_01v8 W=0.84 L=0.15
Xn_496_n n_496 n_495 vss vss sky130_fd_pr__nfet_01v8 W=0.42 L=0.15
Xn_496_p n_496 n_495 vdd vdd sky130_fd_pr__pfet_01v8 W=0.7 L=0.15
Xn_497_p1 n_497 cnt2 vdd vdd sky130_fd_pr__pfet_01v8 W=0.7 L=0.15
Xn_497_p2 n_497 n_493 vdd vdd sky130_fd_pr__pfet_01v8 W=0.7 L=0.15
Xn_497_n1 n_497 cnt2 n_497_x vss sky130_fd_pr__nfet_01v8 W=0.84 L=0.15
Xn_497_n2 n_497_x n_493 vss vss sky130_fd_pr__nfet_01v8 W=0.84 L=0.15
Xn_498_n n_498 n_497 vss vss sky130_fd_pr__nfet_01v8 W=0.42 L=0.15
Xn_498_p n_498 n_497 vdd vdd sky130_fd_pr__pfet_01v8 W=0.7 L=0.15
Xn_499_p1 n_499 cnt4 vdd vdd sky130_fd_pr__pfet_01v8 W=0.7 L=0.15
Xn_499_p2 n_499 cnt5 vdd vdd sky130_fd_pr__pfet_01v8 W=0.7 L=0.15
Xn_499_n1 n_499 cnt4 n_499_x vss sky130_fd_pr__nfet_01v8 W=0.84 L=0.15
Xn_499_n2 n_499_x cnt5 vss vss sky130_fd_pr__nfet_01v8 W=0.84 L=0.15
Xn_500_n n_500 n_499 vss vss sky130_fd_pr__nfet_01v8 W=0.42 L=0.15
Xn_500_p n_500 n_499 vdd vdd sky130_fd_pr__pfet_01v8 W=0.7 L=0.15
Xn_501_p1 n_501 n_496 vdd vdd sky130_fd_pr__pfet_01v8 W=0.7 L=0.15
Xn_501_p2 n_501 n_498 vdd vdd sky130_fd_pr__pfet_01v8 W=0.7 L=0.15
Xn_501_n1 n_501 n_496 n_501_x vss sky130_fd_pr__nfet_01v8 W=0.84 L=0.15
Xn_501_n2 n_501_x n_498 vss vss sky130_fd_pr__nfet_01v8 W=0.84 L=0.15
Xn_502_n n_502 n_501 vss vss sky130_fd_pr__nfet_01v8 W=0.42 L=0.15
Xn_502_p n_502 n_501 vdd vdd sky130_fd_pr__pfet_01v8 W=0.7 L=0.15
Xn_503_p1 n_503 n_500 vdd vdd sky130_fd_pr__pfet_01v8 W=0.7 L=0.15
Xn_503_p2 n_503 n_494 vdd vdd sky130_fd_pr__pfet_01v8 W=0.7 L=0.15
Xn_503_n1 n_503 n_500 n_503_x vss sky130_fd_pr__nfet_01v8 W=0.84 L=0.15
Xn_503_n2 n_503_x n_494 vss vss sky130_fd_pr__nfet_01v8 W=0.84 L=0.15
Xn_504_n n_504 n_503 vss vss sky130_fd_pr__nfet_01v8 W=0.42 L=0.15
Xn_504_p n_504 n_503 vdd vdd sky130_fd_pr__pfet_01v8 W=0.7 L=0.15
Xn_505_p1 n_505 n_502 vdd vdd sky130_fd_pr__pfet_01v8 W=0.7 L=0.15
Xn_505_p2 n_505 n_504 vdd vdd sky130_fd_pr__pfet_01v8 W=0.7 L=0.15
Xn_505_n1 n_505 n_502 n_505_x vss sky130_fd_pr__nfet_01v8 W=0.84 L=0.15
Xn_505_n2 n_505_x n_504 vss vss sky130_fd_pr__nfet_01v8 W=0.84 L=0.15
Xn_506_n n_506 n_505 vss vss sky130_fd_pr__nfet_01v8 W=0.42 L=0.15
Xn_506_p n_506 n_505 vdd vdd sky130_fd_pr__pfet_01v8 W=0.7 L=0.15
Xn_507_p1 n_507 pw vdd vdd sky130_fd_pr__pfet_01v8 W=0.7 L=0.15
Xn_507_p2 n_507 n_506 vdd vdd sky130_fd_pr__pfet_01v8 W=0.7 L=0.15
Xn_507_n1 n_507 pw n_507_x vss sky130_fd_pr__nfet_01v8 W=0.84 L=0.15
Xn_507_n2 n_507_x n_506 vss vss sky130_fd_pr__nfet_01v8 W=0.84 L=0.15
Xn_508_n n_508 n_507 vss vss sky130_fd_pr__nfet_01v8 W=0.42 L=0.15
Xn_508_p n_508 n_507 vdd vdd sky130_fd_pr__pfet_01v8 W=0.7 L=0.15
Xn_509_p1 n_509 r_off n_509_x vdd sky130_fd_pr__pfet_01v8 W=1.4 L=0.15
Xn_509_p2 n_509_x n_508 vdd vdd sky130_fd_pr__pfet_01v8 W=1.4 L=0.15
Xn_509_n1 n_509 r_off vss vss sky130_fd_pr__nfet_01v8 W=0.42 L=0.15
Xn_509_n2 n_509 n_508 vss vss sky130_fd_pr__nfet_01v8 W=0.42 L=0.15
Xn_510_n n_510 n_509 vss vss sky130_fd_pr__nfet_01v8 W=0.42 L=0.15
Xn_510_p n_510 n_509 vdd vdd sky130_fd_pr__pfet_01v8 W=0.7 L=0.15
Xn_511_n n_511 n_510 vss vss sky130_fd_pr__nfet_01v8 W=0.42 L=0.15
Xn_511_p n_511 n_510 vdd vdd sky130_fd_pr__pfet_01v8 W=0.7 L=0.15
Xn_512_p1 n_512 n_510 n_512_x vdd sky130_fd_pr__pfet_01v8 W=1.4 L=0.15
Xn_512_p2 n_512_x n_202 vdd vdd sky130_fd_pr__pfet_01v8 W=1.4 L=0.15
Xn_512_n1 n_512 n_510 vss vss sky130_fd_pr__nfet_01v8 W=0.42 L=0.15
Xn_512_n2 n_512 n_202 vss vss sky130_fd_pr__nfet_01v8 W=0.42 L=0.15
Xn_513_p1 n_513 n_512 n_513_x vdd sky130_fd_pr__pfet_01v8 W=1.4 L=0.15
Xn_513_p2 n_513_x n_4 vdd vdd sky130_fd_pr__pfet_01v8 W=1.4 L=0.15
Xn_513_n1 n_513 n_512 vss vss sky130_fd_pr__nfet_01v8 W=0.42 L=0.15
Xn_513_n2 n_513 n_4 vss vss sky130_fd_pr__nfet_01v8 W=0.42 L=0.15
Xn_514_n n_514 n_513 vss vss sky130_fd_pr__nfet_01v8 W=0.42 L=0.15
Xn_514_p n_514 n_513 vdd vdd sky130_fd_pr__pfet_01v8 W=0.7 L=0.15
Xn_517_p1 n_517 n_511 n_517_x vdd sky130_fd_pr__pfet_01v8 W=1.4 L=0.15
Xn_517_p2 n_517_x n_202 vdd vdd sky130_fd_pr__pfet_01v8 W=1.4 L=0.15
Xn_517_n1 n_517 n_511 vss vss sky130_fd_pr__nfet_01v8 W=0.42 L=0.15
Xn_517_n2 n_517 n_202 vss vss sky130_fd_pr__nfet_01v8 W=0.42 L=0.15
Xn_516_p1 n_516 n_517 n_516_x vdd sky130_fd_pr__pfet_01v8 W=1.4 L=0.15
Xn_516_p2 n_516_x n_515 vdd vdd sky130_fd_pr__pfet_01v8 W=1.4 L=0.15
Xn_516_n1 n_516 n_517 vss vss sky130_fd_pr__nfet_01v8 W=0.42 L=0.15
Xn_516_n2 n_516 n_515 vss vss sky130_fd_pr__nfet_01v8 W=0.42 L=0.15
Xn_515_p1 n_515 n_514 n_515_x vdd sky130_fd_pr__pfet_01v8 W=1.4 L=0.15
Xn_515_p2 n_515_x n_516 vdd vdd sky130_fd_pr__pfet_01v8 W=1.4 L=0.15
Xn_515_n1 n_515 n_514 vss vss sky130_fd_pr__nfet_01v8 W=0.42 L=0.15
Xn_515_n2 n_515 n_516 vss vss sky130_fd_pr__nfet_01v8 W=0.42 L=0.15
Xn_518_p1 n_518 n_515 n_518_x vdd sky130_fd_pr__pfet_01v8 W=1.4 L=0.15
Xn_518_p2 n_518_x n_205 vdd vdd sky130_fd_pr__pfet_01v8 W=1.4 L=0.15
Xn_518_n1 n_518 n_515 vss vss sky130_fd_pr__nfet_01v8 W=0.42 L=0.15
Xn_518_n2 n_518 n_205 vss vss sky130_fd_pr__nfet_01v8 W=0.42 L=0.15
Xn_519_p1 n_519 n_518 n_519_x vdd sky130_fd_pr__pfet_01v8 W=1.4 L=0.15
Xn_519_p2 n_519_x n_4 vdd vdd sky130_fd_pr__pfet_01v8 W=1.4 L=0.15
Xn_519_n1 n_519 n_518 vss vss sky130_fd_pr__nfet_01v8 W=0.42 L=0.15
Xn_519_n2 n_519 n_4 vss vss sky130_fd_pr__nfet_01v8 W=0.42 L=0.15
Xn_520_n n_520 n_519 vss vss sky130_fd_pr__nfet_01v8 W=0.42 L=0.15
Xn_520_p n_520 n_519 vdd vdd sky130_fd_pr__pfet_01v8 W=0.7 L=0.15
Xn_522_p1 n_522 n_516 n_522_x vdd sky130_fd_pr__pfet_01v8 W=1.4 L=0.15
Xn_522_p2 n_522_x n_205 vdd vdd sky130_fd_pr__pfet_01v8 W=1.4 L=0.15
Xn_522_n1 n_522 n_516 vss vss sky130_fd_pr__nfet_01v8 W=0.42 L=0.15
Xn_522_n2 n_522 n_205 vss vss sky130_fd_pr__nfet_01v8 W=0.42 L=0.15
Xn_521_p1 n_521 n_522 n_521_x vdd sky130_fd_pr__pfet_01v8 W=1.4 L=0.15
Xn_521_p2 n_521_x r_off vdd vdd sky130_fd_pr__pfet_01v8 W=1.4 L=0.15
Xn_521_n1 n_521 n_522 vss vss sky130_fd_pr__nfet_01v8 W=0.42 L=0.15
Xn_521_n2 n_521 r_off vss vss sky130_fd_pr__nfet_01v8 W=0.42 L=0.15
Xr_off_p1 r_off n_520 r_off_x vdd sky130_fd_pr__pfet_01v8 W=1.4 L=0.15
Xr_off_p2 r_off_x n_521 vdd vdd sky130_fd_pr__pfet_01v8 W=1.4 L=0.15
Xr_off_n1 r_off n_520 vss vss sky130_fd_pr__nfet_01v8 W=0.42 L=0.15
Xr_off_n2 r_off n_521 vss vss sky130_fd_pr__nfet_01v8 W=0.42 L=0.15
Xn_523_n n_523 r_off vss vss sky130_fd_pr__nfet_01v8 W=0.42 L=0.15
Xn_523_p n_523 r_off vdd vdd sky130_fd_pr__pfet_01v8 W=0.7 L=0.15
Xn_524_p1 n_524 r_on vdd vdd sky130_fd_pr__pfet_01v8 W=0.7 L=0.15
Xn_524_p2 n_524 n_523 vdd vdd sky130_fd_pr__pfet_01v8 W=0.7 L=0.15
Xn_524_n1 n_524 r_on n_524_x vss sky130_fd_pr__nfet_01v8 W=0.84 L=0.15
Xn_524_n2 n_524_x n_523 vss vss sky130_fd_pr__nfet_01v8 W=0.84 L=0.15
Xn_525_n n_525 n_524 vss vss sky130_fd_pr__nfet_01v8 W=0.42 L=0.15
Xn_525_p n_525 n_524 vdd vdd sky130_fd_pr__pfet_01v8 W=0.7 L=0.15
Xn_526_n n_526 n_525 vss vss sky130_fd_pr__nfet_01v8 W=0.84 L=0.15
Xn_526_p n_526 n_525 vdd vdd sky130_fd_pr__pfet_01v8 W=1.4 L=0.15
Xramp_en_n ramp_en n_526 vss vss sky130_fd_pr__nfet_01v8 W=1.68 L=0.15
Xramp_en_p ramp_en n_526 vdd vdd sky130_fd_pr__pfet_01v8 W=2.8 L=0.15
Xn_527_n n_527 cnt6 vss vss sky130_fd_pr__nfet_01v8 W=0.42 L=0.15
Xn_527_p n_527 cnt6 vdd vdd sky130_fd_pr__pfet_01v8 W=0.7 L=0.15
Xn_528_p1 n_528 cnt0 vdd vdd sky130_fd_pr__pfet_01v8 W=0.7 L=0.15
Xn_528_p2 n_528 cnt1 vdd vdd sky130_fd_pr__pfet_01v8 W=0.7 L=0.15
Xn_528_n1 n_528 cnt0 n_528_x vss sky130_fd_pr__nfet_01v8 W=0.84 L=0.15
Xn_528_n2 n_528_x cnt1 vss vss sky130_fd_pr__nfet_01v8 W=0.84 L=0.15
Xn_529_n n_529 n_528 vss vss sky130_fd_pr__nfet_01v8 W=0.42 L=0.15
Xn_529_p n_529 n_528 vdd vdd sky130_fd_pr__pfet_01v8 W=0.7 L=0.15
Xn_530_p1 n_530 cnt2 vdd vdd sky130_fd_pr__pfet_01v8 W=0.7 L=0.15
Xn_530_p2 n_530 cnt3 vdd vdd sky130_fd_pr__pfet_01v8 W=0.7 L=0.15
Xn_530_n1 n_530 cnt2 n_530_x vss sky130_fd_pr__nfet_01v8 W=0.84 L=0.15
Xn_530_n2 n_530_x cnt3 vss vss sky130_fd_pr__nfet_01v8 W=0.84 L=0.15
Xn_531_n n_531 n_530 vss vss sky130_fd_pr__nfet_01v8 W=0.42 L=0.15
Xn_531_p n_531 n_530 vdd vdd sky130_fd_pr__pfet_01v8 W=0.7 L=0.15
Xn_532_p1 n_532 cnt4 vdd vdd sky130_fd_pr__pfet_01v8 W=0.7 L=0.15
Xn_532_p2 n_532 cnt5 vdd vdd sky130_fd_pr__pfet_01v8 W=0.7 L=0.15
Xn_532_n1 n_532 cnt4 n_532_x vss sky130_fd_pr__nfet_01v8 W=0.84 L=0.15
Xn_532_n2 n_532_x cnt5 vss vss sky130_fd_pr__nfet_01v8 W=0.84 L=0.15
Xn_533_n n_533 n_532 vss vss sky130_fd_pr__nfet_01v8 W=0.42 L=0.15
Xn_533_p n_533 n_532 vdd vdd sky130_fd_pr__pfet_01v8 W=0.7 L=0.15
Xn_534_p1 n_534 n_529 vdd vdd sky130_fd_pr__pfet_01v8 W=0.7 L=0.15
Xn_534_p2 n_534 n_531 vdd vdd sky130_fd_pr__pfet_01v8 W=0.7 L=0.15
Xn_534_n1 n_534 n_529 n_534_x vss sky130_fd_pr__nfet_01v8 W=0.84 L=0.15
Xn_534_n2 n_534_x n_531 vss vss sky130_fd_pr__nfet_01v8 W=0.84 L=0.15
Xn_535_n n_535 n_534 vss vss sky130_fd_pr__nfet_01v8 W=0.42 L=0.15
Xn_535_p n_535 n_534 vdd vdd sky130_fd_pr__pfet_01v8 W=0.7 L=0.15
Xn_536_p1 n_536 n_533 vdd vdd sky130_fd_pr__pfet_01v8 W=0.7 L=0.15
Xn_536_p2 n_536 n_527 vdd vdd sky130_fd_pr__pfet_01v8 W=0.7 L=0.15
Xn_536_n1 n_536 n_533 n_536_x vss sky130_fd_pr__nfet_01v8 W=0.84 L=0.15
Xn_536_n2 n_536_x n_527 vss vss sky130_fd_pr__nfet_01v8 W=0.84 L=0.15
Xn_537_n n_537 n_536 vss vss sky130_fd_pr__nfet_01v8 W=0.42 L=0.15
Xn_537_p n_537 n_536 vdd vdd sky130_fd_pr__pfet_01v8 W=0.7 L=0.15
Xn_538_p1 n_538 n_535 vdd vdd sky130_fd_pr__pfet_01v8 W=0.7 L=0.15
Xn_538_p2 n_538 n_537 vdd vdd sky130_fd_pr__pfet_01v8 W=0.7 L=0.15
Xn_538_n1 n_538 n_535 n_538_x vss sky130_fd_pr__nfet_01v8 W=0.84 L=0.15
Xn_538_n2 n_538_x n_537 vss vss sky130_fd_pr__nfet_01v8 W=0.84 L=0.15
Xn_539_n n_539 n_538 vss vss sky130_fd_pr__nfet_01v8 W=0.42 L=0.15
Xn_539_p n_539 n_538 vdd vdd sky130_fd_pr__pfet_01v8 W=0.7 L=0.15
Xn_540_n n_540 cnt3 vss vss sky130_fd_pr__nfet_01v8 W=0.42 L=0.15
Xn_540_p n_540 cnt3 vdd vdd sky130_fd_pr__pfet_01v8 W=0.7 L=0.15
Xn_541_n n_541 cnt4 vss vss sky130_fd_pr__nfet_01v8 W=0.42 L=0.15
Xn_541_p n_541 cnt4 vdd vdd sky130_fd_pr__pfet_01v8 W=0.7 L=0.15
Xn_542_n n_542 cnt5 vss vss sky130_fd_pr__nfet_01v8 W=0.42 L=0.15
Xn_542_p n_542 cnt5 vdd vdd sky130_fd_pr__pfet_01v8 W=0.7 L=0.15
Xn_543_n n_543 cnt6 vss vss sky130_fd_pr__nfet_01v8 W=0.42 L=0.15
Xn_543_p n_543 cnt6 vdd vdd sky130_fd_pr__pfet_01v8 W=0.7 L=0.15
Xn_544_p1 n_544 cnt0 vdd vdd sky130_fd_pr__pfet_01v8 W=0.7 L=0.15
Xn_544_p2 n_544 cnt1 vdd vdd sky130_fd_pr__pfet_01v8 W=0.7 L=0.15
Xn_544_n1 n_544 cnt0 n_544_x vss sky130_fd_pr__nfet_01v8 W=0.84 L=0.15
Xn_544_n2 n_544_x cnt1 vss vss sky130_fd_pr__nfet_01v8 W=0.84 L=0.15
Xn_545_n n_545 n_544 vss vss sky130_fd_pr__nfet_01v8 W=0.42 L=0.15
Xn_545_p n_545 n_544 vdd vdd sky130_fd_pr__pfet_01v8 W=0.7 L=0.15
Xn_546_p1 n_546 cnt2 vdd vdd sky130_fd_pr__pfet_01v8 W=0.7 L=0.15
Xn_546_p2 n_546 n_540 vdd vdd sky130_fd_pr__pfet_01v8 W=0.7 L=0.15
Xn_546_n1 n_546 cnt2 n_546_x vss sky130_fd_pr__nfet_01v8 W=0.84 L=0.15
Xn_546_n2 n_546_x n_540 vss vss sky130_fd_pr__nfet_01v8 W=0.84 L=0.15
Xn_547_n n_547 n_546 vss vss sky130_fd_pr__nfet_01v8 W=0.42 L=0.15
Xn_547_p n_547 n_546 vdd vdd sky130_fd_pr__pfet_01v8 W=0.7 L=0.15
Xn_548_p1 n_548 n_541 vdd vdd sky130_fd_pr__pfet_01v8 W=0.7 L=0.15
Xn_548_p2 n_548 n_542 vdd vdd sky130_fd_pr__pfet_01v8 W=0.7 L=0.15
Xn_548_n1 n_548 n_541 n_548_x vss sky130_fd_pr__nfet_01v8 W=0.84 L=0.15
Xn_548_n2 n_548_x n_542 vss vss sky130_fd_pr__nfet_01v8 W=0.84 L=0.15
Xn_549_n n_549 n_548 vss vss sky130_fd_pr__nfet_01v8 W=0.42 L=0.15
Xn_549_p n_549 n_548 vdd vdd sky130_fd_pr__pfet_01v8 W=0.7 L=0.15
Xn_550_p1 n_550 n_545 vdd vdd sky130_fd_pr__pfet_01v8 W=0.7 L=0.15
Xn_550_p2 n_550 n_547 vdd vdd sky130_fd_pr__pfet_01v8 W=0.7 L=0.15
Xn_550_n1 n_550 n_545 n_550_x vss sky130_fd_pr__nfet_01v8 W=0.84 L=0.15
Xn_550_n2 n_550_x n_547 vss vss sky130_fd_pr__nfet_01v8 W=0.84 L=0.15
Xn_551_n n_551 n_550 vss vss sky130_fd_pr__nfet_01v8 W=0.42 L=0.15
Xn_551_p n_551 n_550 vdd vdd sky130_fd_pr__pfet_01v8 W=0.7 L=0.15
Xn_552_p1 n_552 n_549 vdd vdd sky130_fd_pr__pfet_01v8 W=0.7 L=0.15
Xn_552_p2 n_552 n_543 vdd vdd sky130_fd_pr__pfet_01v8 W=0.7 L=0.15
Xn_552_n1 n_552 n_549 n_552_x vss sky130_fd_pr__nfet_01v8 W=0.84 L=0.15
Xn_552_n2 n_552_x n_543 vss vss sky130_fd_pr__nfet_01v8 W=0.84 L=0.15
Xn_553_n n_553 n_552 vss vss sky130_fd_pr__nfet_01v8 W=0.42 L=0.15
Xn_553_p n_553 n_552 vdd vdd sky130_fd_pr__pfet_01v8 W=0.7 L=0.15
Xn_554_p1 n_554 n_551 vdd vdd sky130_fd_pr__pfet_01v8 W=0.7 L=0.15
Xn_554_p2 n_554 n_553 vdd vdd sky130_fd_pr__pfet_01v8 W=0.7 L=0.15
Xn_554_n1 n_554 n_551 n_554_x vss sky130_fd_pr__nfet_01v8 W=0.84 L=0.15
Xn_554_n2 n_554_x n_553 vss vss sky130_fd_pr__nfet_01v8 W=0.84 L=0.15
Xn_555_n n_555 n_554 vss vss sky130_fd_pr__nfet_01v8 W=0.42 L=0.15
Xn_555_p n_555 n_554 vdd vdd sky130_fd_pr__pfet_01v8 W=0.7 L=0.15
Xn_556_n n_556 lora_en vss vss sky130_fd_pr__nfet_01v8 W=0.42 L=0.15
Xn_556_p n_556 lora_en vdd vdd sky130_fd_pr__pfet_01v8 W=0.7 L=0.15
Xn_557_p1 n_557 lora_en vdd vdd sky130_fd_pr__pfet_01v8 W=0.7 L=0.15
Xn_557_p2 n_557 n_539 vdd vdd sky130_fd_pr__pfet_01v8 W=0.7 L=0.15
Xn_557_n1 n_557 lora_en n_557_x vss sky130_fd_pr__nfet_01v8 W=0.84 L=0.15
Xn_557_n2 n_557_x n_539 vss vss sky130_fd_pr__nfet_01v8 W=0.84 L=0.15
Xn_558_p1 n_558 n_556 vdd vdd sky130_fd_pr__pfet_01v8 W=0.7 L=0.15
Xn_558_p2 n_558 n_555 vdd vdd sky130_fd_pr__pfet_01v8 W=0.7 L=0.15
Xn_558_n1 n_558 n_556 n_558_x vss sky130_fd_pr__nfet_01v8 W=0.84 L=0.15
Xn_558_n2 n_558_x n_555 vss vss sky130_fd_pr__nfet_01v8 W=0.84 L=0.15
Xn_559_p1 n_559 n_557 vdd vdd sky130_fd_pr__pfet_01v8 W=0.7 L=0.15
Xn_559_p2 n_559 n_558 vdd vdd sky130_fd_pr__pfet_01v8 W=0.7 L=0.15
Xn_559_n1 n_559 n_557 n_559_x vss sky130_fd_pr__nfet_01v8 W=0.84 L=0.15
Xn_559_n2 n_559_x n_558 vss vss sky130_fd_pr__nfet_01v8 W=0.84 L=0.15
Xn_560_p1 n_560 pw vdd vdd sky130_fd_pr__pfet_01v8 W=0.7 L=0.15
Xn_560_p2 n_560 n_559 vdd vdd sky130_fd_pr__pfet_01v8 W=0.7 L=0.15
Xn_560_n1 n_560 pw n_560_x vss sky130_fd_pr__nfet_01v8 W=0.84 L=0.15
Xn_560_n2 n_560_x n_559 vss vss sky130_fd_pr__nfet_01v8 W=0.84 L=0.15
Xn_561_n n_561 n_560 vss vss sky130_fd_pr__nfet_01v8 W=0.42 L=0.15
Xn_561_p n_561 n_560 vdd vdd sky130_fd_pr__pfet_01v8 W=0.7 L=0.15
Xn_562_p1 n_562 sg n_562_x vdd sky130_fd_pr__pfet_01v8 W=1.4 L=0.15
Xn_562_p2 n_562_x n_561 vdd vdd sky130_fd_pr__pfet_01v8 W=1.4 L=0.15
Xn_562_n1 n_562 sg vss vss sky130_fd_pr__nfet_01v8 W=0.42 L=0.15
Xn_562_n2 n_562 n_561 vss vss sky130_fd_pr__nfet_01v8 W=0.42 L=0.15
Xn_563_n n_563 n_562 vss vss sky130_fd_pr__nfet_01v8 W=0.42 L=0.15
Xn_563_p n_563 n_562 vdd vdd sky130_fd_pr__pfet_01v8 W=0.7 L=0.15
Xn_564_n n_564 n_563 vss vss sky130_fd_pr__nfet_01v8 W=0.42 L=0.15
Xn_564_p n_564 n_563 vdd vdd sky130_fd_pr__pfet_01v8 W=0.7 L=0.15
Xn_565_p1 n_565 n_563 n_565_x vdd sky130_fd_pr__pfet_01v8 W=1.4 L=0.15
Xn_565_p2 n_565_x n_202 vdd vdd sky130_fd_pr__pfet_01v8 W=1.4 L=0.15
Xn_565_n1 n_565 n_563 vss vss sky130_fd_pr__nfet_01v8 W=0.42 L=0.15
Xn_565_n2 n_565 n_202 vss vss sky130_fd_pr__nfet_01v8 W=0.42 L=0.15
Xn_566_p1 n_566 n_565 n_566_x vdd sky130_fd_pr__pfet_01v8 W=1.4 L=0.15
Xn_566_p2 n_566_x n_4 vdd vdd sky130_fd_pr__pfet_01v8 W=1.4 L=0.15
Xn_566_n1 n_566 n_565 vss vss sky130_fd_pr__nfet_01v8 W=0.42 L=0.15
Xn_566_n2 n_566 n_4 vss vss sky130_fd_pr__nfet_01v8 W=0.42 L=0.15
Xn_567_n n_567 n_566 vss vss sky130_fd_pr__nfet_01v8 W=0.42 L=0.15
Xn_567_p n_567 n_566 vdd vdd sky130_fd_pr__pfet_01v8 W=0.7 L=0.15
Xn_570_p1 n_570 n_564 n_570_x vdd sky130_fd_pr__pfet_01v8 W=1.4 L=0.15
Xn_570_p2 n_570_x n_202 vdd vdd sky130_fd_pr__pfet_01v8 W=1.4 L=0.15
Xn_570_n1 n_570 n_564 vss vss sky130_fd_pr__nfet_01v8 W=0.42 L=0.15
Xn_570_n2 n_570 n_202 vss vss sky130_fd_pr__nfet_01v8 W=0.42 L=0.15
Xn_569_p1 n_569 n_570 n_569_x vdd sky130_fd_pr__pfet_01v8 W=1.4 L=0.15
Xn_569_p2 n_569_x n_568 vdd vdd sky130_fd_pr__pfet_01v8 W=1.4 L=0.15
Xn_569_n1 n_569 n_570 vss vss sky130_fd_pr__nfet_01v8 W=0.42 L=0.15
Xn_569_n2 n_569 n_568 vss vss sky130_fd_pr__nfet_01v8 W=0.42 L=0.15
Xn_568_p1 n_568 n_567 n_568_x vdd sky130_fd_pr__pfet_01v8 W=1.4 L=0.15
Xn_568_p2 n_568_x n_569 vdd vdd sky130_fd_pr__pfet_01v8 W=1.4 L=0.15
Xn_568_n1 n_568 n_567 vss vss sky130_fd_pr__nfet_01v8 W=0.42 L=0.15
Xn_568_n2 n_568 n_569 vss vss sky130_fd_pr__nfet_01v8 W=0.42 L=0.15
Xn_571_p1 n_571 n_568 n_571_x vdd sky130_fd_pr__pfet_01v8 W=1.4 L=0.15
Xn_571_p2 n_571_x n_205 vdd vdd sky130_fd_pr__pfet_01v8 W=1.4 L=0.15
Xn_571_n1 n_571 n_568 vss vss sky130_fd_pr__nfet_01v8 W=0.42 L=0.15
Xn_571_n2 n_571 n_205 vss vss sky130_fd_pr__nfet_01v8 W=0.42 L=0.15
Xn_572_p1 n_572 n_571 n_572_x vdd sky130_fd_pr__pfet_01v8 W=1.4 L=0.15
Xn_572_p2 n_572_x n_4 vdd vdd sky130_fd_pr__pfet_01v8 W=1.4 L=0.15
Xn_572_n1 n_572 n_571 vss vss sky130_fd_pr__nfet_01v8 W=0.42 L=0.15
Xn_572_n2 n_572 n_4 vss vss sky130_fd_pr__nfet_01v8 W=0.42 L=0.15
Xn_573_n n_573 n_572 vss vss sky130_fd_pr__nfet_01v8 W=0.42 L=0.15
Xn_573_p n_573 n_572 vdd vdd sky130_fd_pr__pfet_01v8 W=0.7 L=0.15
Xn_575_p1 n_575 n_569 n_575_x vdd sky130_fd_pr__pfet_01v8 W=1.4 L=0.15
Xn_575_p2 n_575_x n_205 vdd vdd sky130_fd_pr__pfet_01v8 W=1.4 L=0.15
Xn_575_n1 n_575 n_569 vss vss sky130_fd_pr__nfet_01v8 W=0.42 L=0.15
Xn_575_n2 n_575 n_205 vss vss sky130_fd_pr__nfet_01v8 W=0.42 L=0.15
Xn_574_p1 n_574 n_575 n_574_x vdd sky130_fd_pr__pfet_01v8 W=1.4 L=0.15
Xn_574_p2 n_574_x sg vdd vdd sky130_fd_pr__pfet_01v8 W=1.4 L=0.15
Xn_574_n1 n_574 n_575 vss vss sky130_fd_pr__nfet_01v8 W=0.42 L=0.15
Xn_574_n2 n_574 sg vss vss sky130_fd_pr__nfet_01v8 W=0.42 L=0.15
Xsg_p1 sg n_573 sg_x vdd sky130_fd_pr__pfet_01v8 W=1.4 L=0.15
Xsg_p2 sg_x n_574 vdd vdd sky130_fd_pr__pfet_01v8 W=1.4 L=0.15
Xsg_n1 sg n_573 vss vss sky130_fd_pr__nfet_01v8 W=0.42 L=0.15
Xsg_n2 sg n_574 vss vss sky130_fd_pr__nfet_01v8 W=0.42 L=0.15
Xn_576_p1 n_576 win_hi vdd vdd sky130_fd_pr__pfet_01v8 W=0.7 L=0.15
Xn_576_p2 n_576 cnt4 vdd vdd sky130_fd_pr__pfet_01v8 W=0.7 L=0.15
Xn_576_n1 n_576 win_hi n_576_x vss sky130_fd_pr__nfet_01v8 W=0.84 L=0.15
Xn_576_n2 n_576_x cnt4 vss vss sky130_fd_pr__nfet_01v8 W=0.84 L=0.15
Xn_577_p1 n_577 n_231 vdd vdd sky130_fd_pr__pfet_01v8 W=0.7 L=0.15
Xn_577_p2 n_577 cnt0 vdd vdd sky130_fd_pr__pfet_01v8 W=0.7 L=0.15
Xn_577_n1 n_577 n_231 n_577_x vss sky130_fd_pr__nfet_01v8 W=0.84 L=0.15
Xn_577_n2 n_577_x cnt0 vss vss sky130_fd_pr__nfet_01v8 W=0.84 L=0.15
Xn_578_p1 n_578 n_576 vdd vdd sky130_fd_pr__pfet_01v8 W=0.7 L=0.15
Xn_578_p2 n_578 n_577 vdd vdd sky130_fd_pr__pfet_01v8 W=0.7 L=0.15
Xn_578_n1 n_578 n_576 n_578_x vss sky130_fd_pr__nfet_01v8 W=0.84 L=0.15
Xn_578_n2 n_578_x n_577 vss vss sky130_fd_pr__nfet_01v8 W=0.84 L=0.15
Xn_579_p1 n_579 win_hi vdd vdd sky130_fd_pr__pfet_01v8 W=0.7 L=0.15
Xn_579_p2 n_579 cnt5 vdd vdd sky130_fd_pr__pfet_01v8 W=0.7 L=0.15
Xn_579_n1 n_579 win_hi n_579_x vss sky130_fd_pr__nfet_01v8 W=0.84 L=0.15
Xn_579_n2 n_579_x cnt5 vss vss sky130_fd_pr__nfet_01v8 W=0.84 L=0.15
Xn_580_p1 n_580 n_231 vdd vdd sky130_fd_pr__pfet_01v8 W=0.7 L=0.15
Xn_580_p2 n_580 cnt1 vdd vdd sky130_fd_pr__pfet_01v8 W=0.7 L=0.15
Xn_580_n1 n_580 n_231 n_580_x vss sky130_fd_pr__nfet_01v8 W=0.84 L=0.15
Xn_580_n2 n_580_x cnt1 vss vss sky130_fd_pr__nfet_01v8 W=0.84 L=0.15
Xn_581_p1 n_581 n_579 vdd vdd sky130_fd_pr__pfet_01v8 W=0.7 L=0.15
Xn_581_p2 n_581 n_580 vdd vdd sky130_fd_pr__pfet_01v8 W=0.7 L=0.15
Xn_581_n1 n_581 n_579 n_581_x vss sky130_fd_pr__nfet_01v8 W=0.84 L=0.15
Xn_581_n2 n_581_x n_580 vss vss sky130_fd_pr__nfet_01v8 W=0.84 L=0.15
Xn_582_p1 n_582 win_hi vdd vdd sky130_fd_pr__pfet_01v8 W=0.7 L=0.15
Xn_582_p2 n_582 cnt6 vdd vdd sky130_fd_pr__pfet_01v8 W=0.7 L=0.15
Xn_582_n1 n_582 win_hi n_582_x vss sky130_fd_pr__nfet_01v8 W=0.84 L=0.15
Xn_582_n2 n_582_x cnt6 vss vss sky130_fd_pr__nfet_01v8 W=0.84 L=0.15
Xn_583_p1 n_583 n_231 vdd vdd sky130_fd_pr__pfet_01v8 W=0.7 L=0.15
Xn_583_p2 n_583 cnt2 vdd vdd sky130_fd_pr__pfet_01v8 W=0.7 L=0.15
Xn_583_n1 n_583 n_231 n_583_x vss sky130_fd_pr__nfet_01v8 W=0.84 L=0.15
Xn_583_n2 n_583_x cnt2 vss vss sky130_fd_pr__nfet_01v8 W=0.84 L=0.15
Xn_584_p1 n_584 n_582 vdd vdd sky130_fd_pr__pfet_01v8 W=0.7 L=0.15
Xn_584_p2 n_584 n_583 vdd vdd sky130_fd_pr__pfet_01v8 W=0.7 L=0.15
Xn_584_n1 n_584 n_582 n_584_x vss sky130_fd_pr__nfet_01v8 W=0.84 L=0.15
Xn_584_n2 n_584_x n_583 vss vss sky130_fd_pr__nfet_01v8 W=0.84 L=0.15
Xn_585_p1 n_585 n_231 vdd vdd sky130_fd_pr__pfet_01v8 W=0.7 L=0.15
Xn_585_p2 n_585 cnt3 vdd vdd sky130_fd_pr__pfet_01v8 W=0.7 L=0.15
Xn_585_n1 n_585 n_231 n_585_x vss sky130_fd_pr__nfet_01v8 W=0.84 L=0.15
Xn_585_n2 n_585_x cnt3 vss vss sky130_fd_pr__nfet_01v8 W=0.84 L=0.15
Xn_586_n n_586 n_585 vss vss sky130_fd_pr__nfet_01v8 W=0.42 L=0.15
Xn_586_p n_586 n_585 vdd vdd sky130_fd_pr__pfet_01v8 W=0.7 L=0.15
Xn_587_n n_587 n_578 vss vss sky130_fd_pr__nfet_01v8 W=0.42 L=0.15
Xn_587_p n_587 n_578 vdd vdd sky130_fd_pr__pfet_01v8 W=0.7 L=0.15
Xn_588_n n_588 n_581 vss vss sky130_fd_pr__nfet_01v8 W=0.42 L=0.15
Xn_588_p n_588 n_581 vdd vdd sky130_fd_pr__pfet_01v8 W=0.7 L=0.15
Xn_589_n n_589 n_584 vss vss sky130_fd_pr__nfet_01v8 W=0.42 L=0.15
Xn_589_p n_589 n_584 vdd vdd sky130_fd_pr__pfet_01v8 W=0.7 L=0.15
Xn_590_n n_590 n_586 vss vss sky130_fd_pr__nfet_01v8 W=0.42 L=0.15
Xn_590_p n_590 n_586 vdd vdd sky130_fd_pr__pfet_01v8 W=0.7 L=0.15
Xn_591_n n_591 n_440 vss vss sky130_fd_pr__nfet_01v8 W=0.42 L=0.15
Xn_591_p n_591 n_440 vdd vdd sky130_fd_pr__pfet_01v8 W=0.7 L=0.15
Xn_592_n n_592 t_phi2 vss vss sky130_fd_pr__nfet_01v8 W=0.42 L=0.15
Xn_592_p n_592 t_phi2 vdd vdd sky130_fd_pr__pfet_01v8 W=0.7 L=0.15
Xn_593_p1 n_593 t_ck vdd vdd sky130_fd_pr__pfet_01v8 W=0.7 L=0.15
Xn_593_p2 n_593 n_592 vdd vdd sky130_fd_pr__pfet_01v8 W=0.7 L=0.15
Xn_593_n1 n_593 t_ck n_593_x vss sky130_fd_pr__nfet_01v8 W=0.84 L=0.15
Xn_593_n2 n_593_x n_592 vss vss sky130_fd_pr__nfet_01v8 W=0.84 L=0.15
Xn_594_n n_594 n_593 vss vss sky130_fd_pr__nfet_01v8 W=0.42 L=0.15
Xn_594_p n_594 n_593 vdd vdd sky130_fd_pr__pfet_01v8 W=0.7 L=0.15
Xn_595_p1 n_595 n_587 vdd vdd sky130_fd_pr__pfet_01v8 W=0.7 L=0.15
Xn_595_p2 n_595 x_mag0 vdd vdd sky130_fd_pr__pfet_01v8 W=0.7 L=0.15
Xn_595_n1 n_595 n_587 n_595_x vss sky130_fd_pr__nfet_01v8 W=0.84 L=0.15
Xn_595_n2 n_595_x x_mag0 vss vss sky130_fd_pr__nfet_01v8 W=0.84 L=0.15
Xn_596_n n_596 n_595 vss vss sky130_fd_pr__nfet_01v8 W=0.42 L=0.15
Xn_596_p n_596 n_595 vdd vdd sky130_fd_pr__pfet_01v8 W=0.7 L=0.15
Xn_597_p1 n_597 n_588 vdd vdd sky130_fd_pr__pfet_01v8 W=0.7 L=0.15
Xn_597_p2 n_597 x_mag1 vdd vdd sky130_fd_pr__pfet_01v8 W=0.7 L=0.15
Xn_597_n1 n_597 n_588 n_597_x vss sky130_fd_pr__nfet_01v8 W=0.84 L=0.15
Xn_597_n2 n_597_x x_mag1 vss vss sky130_fd_pr__nfet_01v8 W=0.84 L=0.15
Xn_598_p1 n_598 n_588 n_598_x vdd sky130_fd_pr__pfet_01v8 W=1.4 L=0.15
Xn_598_p2 n_598_x x_mag1 vdd vdd sky130_fd_pr__pfet_01v8 W=1.4 L=0.15
Xn_598_n1 n_598 n_588 vss vss sky130_fd_pr__nfet_01v8 W=0.42 L=0.15
Xn_598_n2 n_598 x_mag1 vss vss sky130_fd_pr__nfet_01v8 W=0.42 L=0.15
Xn_599_n n_599 n_598 vss vss sky130_fd_pr__nfet_01v8 W=0.42 L=0.15
Xn_599_p n_599 n_598 vdd vdd sky130_fd_pr__pfet_01v8 W=0.7 L=0.15
Xn_600_p1 n_600 n_596 vdd vdd sky130_fd_pr__pfet_01v8 W=0.7 L=0.15
Xn_600_p2 n_600 n_599 vdd vdd sky130_fd_pr__pfet_01v8 W=0.7 L=0.15
Xn_600_n1 n_600 n_596 n_600_x vss sky130_fd_pr__nfet_01v8 W=0.84 L=0.15
Xn_600_n2 n_600_x n_599 vss vss sky130_fd_pr__nfet_01v8 W=0.84 L=0.15
Xn_601_p1 n_601 n_597 vdd vdd sky130_fd_pr__pfet_01v8 W=0.7 L=0.15
Xn_601_p2 n_601 n_600 vdd vdd sky130_fd_pr__pfet_01v8 W=0.7 L=0.15
Xn_601_n1 n_601 n_597 n_601_x vss sky130_fd_pr__nfet_01v8 W=0.84 L=0.15
Xn_601_n2 n_601_x n_600 vss vss sky130_fd_pr__nfet_01v8 W=0.84 L=0.15
Xn_602_p1 n_602 n_589 vdd vdd sky130_fd_pr__pfet_01v8 W=0.7 L=0.15
Xn_602_p2 n_602 x_mag2 vdd vdd sky130_fd_pr__pfet_01v8 W=0.7 L=0.15
Xn_602_n1 n_602 n_589 n_602_x vss sky130_fd_pr__nfet_01v8 W=0.84 L=0.15
Xn_602_n2 n_602_x x_mag2 vss vss sky130_fd_pr__nfet_01v8 W=0.84 L=0.15
Xn_603_p1 n_603 n_589 n_603_x vdd sky130_fd_pr__pfet_01v8 W=1.4 L=0.15
Xn_603_p2 n_603_x x_mag2 vdd vdd sky130_fd_pr__pfet_01v8 W=1.4 L=0.15
Xn_603_n1 n_603 n_589 vss vss sky130_fd_pr__nfet_01v8 W=0.42 L=0.15
Xn_603_n2 n_603 x_mag2 vss vss sky130_fd_pr__nfet_01v8 W=0.42 L=0.15
Xn_604_n n_604 n_603 vss vss sky130_fd_pr__nfet_01v8 W=0.42 L=0.15
Xn_604_p n_604 n_603 vdd vdd sky130_fd_pr__pfet_01v8 W=0.7 L=0.15
Xn_605_p1 n_605 n_601 vdd vdd sky130_fd_pr__pfet_01v8 W=0.7 L=0.15
Xn_605_p2 n_605 n_604 vdd vdd sky130_fd_pr__pfet_01v8 W=0.7 L=0.15
Xn_605_n1 n_605 n_601 n_605_x vss sky130_fd_pr__nfet_01v8 W=0.84 L=0.15
Xn_605_n2 n_605_x n_604 vss vss sky130_fd_pr__nfet_01v8 W=0.84 L=0.15
Xn_606_p1 n_606 n_602 vdd vdd sky130_fd_pr__pfet_01v8 W=0.7 L=0.15
Xn_606_p2 n_606 n_605 vdd vdd sky130_fd_pr__pfet_01v8 W=0.7 L=0.15
Xn_606_n1 n_606 n_602 n_606_x vss sky130_fd_pr__nfet_01v8 W=0.84 L=0.15
Xn_606_n2 n_606_x n_605 vss vss sky130_fd_pr__nfet_01v8 W=0.84 L=0.15
Xn_607_p1 n_607 n_590 vdd vdd sky130_fd_pr__pfet_01v8 W=0.7 L=0.15
Xn_607_p2 n_607 x_mag3 vdd vdd sky130_fd_pr__pfet_01v8 W=0.7 L=0.15
Xn_607_n1 n_607 n_590 n_607_x vss sky130_fd_pr__nfet_01v8 W=0.84 L=0.15
Xn_607_n2 n_607_x x_mag3 vss vss sky130_fd_pr__nfet_01v8 W=0.84 L=0.15
Xn_608_p1 n_608 n_590 n_608_x vdd sky130_fd_pr__pfet_01v8 W=1.4 L=0.15
Xn_608_p2 n_608_x x_mag3 vdd vdd sky130_fd_pr__pfet_01v8 W=1.4 L=0.15
Xn_608_n1 n_608 n_590 vss vss sky130_fd_pr__nfet_01v8 W=0.42 L=0.15
Xn_608_n2 n_608 x_mag3 vss vss sky130_fd_pr__nfet_01v8 W=0.42 L=0.15
Xn_609_n n_609 n_608 vss vss sky130_fd_pr__nfet_01v8 W=0.42 L=0.15
Xn_609_p n_609 n_608 vdd vdd sky130_fd_pr__pfet_01v8 W=0.7 L=0.15
Xn_610_p1 n_610 n_606 vdd vdd sky130_fd_pr__pfet_01v8 W=0.7 L=0.15
Xn_610_p2 n_610 n_609 vdd vdd sky130_fd_pr__pfet_01v8 W=0.7 L=0.15
Xn_610_n1 n_610 n_606 n_610_x vss sky130_fd_pr__nfet_01v8 W=0.84 L=0.15
Xn_610_n2 n_610_x n_609 vss vss sky130_fd_pr__nfet_01v8 W=0.84 L=0.15
Xn_611_p1 n_611 n_607 vdd vdd sky130_fd_pr__pfet_01v8 W=0.7 L=0.15
Xn_611_p2 n_611 n_610 vdd vdd sky130_fd_pr__pfet_01v8 W=0.7 L=0.15
Xn_611_n1 n_611 n_607 n_611_x vss sky130_fd_pr__nfet_01v8 W=0.84 L=0.15
Xn_611_n2 n_611_x n_610 vss vss sky130_fd_pr__nfet_01v8 W=0.84 L=0.15
Xn_612_p1 n_612 n_403 vdd vdd sky130_fd_pr__pfet_01v8 W=0.7 L=0.15
Xn_612_p2 n_612 n_611 vdd vdd sky130_fd_pr__pfet_01v8 W=0.7 L=0.15
Xn_612_n1 n_612 n_403 n_612_x vss sky130_fd_pr__nfet_01v8 W=0.84 L=0.15
Xn_612_n2 n_612_x n_611 vss vss sky130_fd_pr__nfet_01v8 W=0.84 L=0.15
Xn_613_n n_613 n_612 vss vss sky130_fd_pr__nfet_01v8 W=0.42 L=0.15
Xn_613_p n_613 n_612 vdd vdd sky130_fd_pr__pfet_01v8 W=0.7 L=0.15
Xn_614_p1 n_614 n_440 vdd vdd sky130_fd_pr__pfet_01v8 W=0.7 L=0.15
Xn_614_p2 n_614 n_613 vdd vdd sky130_fd_pr__pfet_01v8 W=0.7 L=0.15
Xn_614_n1 n_614 n_440 n_614_x vss sky130_fd_pr__nfet_01v8 W=0.84 L=0.15
Xn_614_n2 n_614_x n_613 vss vss sky130_fd_pr__nfet_01v8 W=0.84 L=0.15
Xn_615_p1 n_615 n_591 vdd vdd sky130_fd_pr__pfet_01v8 W=0.7 L=0.15
Xn_615_p2 n_615 env0 vdd vdd sky130_fd_pr__pfet_01v8 W=0.7 L=0.15
Xn_615_n1 n_615 n_591 n_615_x vss sky130_fd_pr__nfet_01v8 W=0.84 L=0.15
Xn_615_n2 n_615_x env0 vss vss sky130_fd_pr__nfet_01v8 W=0.84 L=0.15
Xn_616_p1 n_616 n_614 vdd vdd sky130_fd_pr__pfet_01v8 W=0.7 L=0.15
Xn_616_p2 n_616 n_615 vdd vdd sky130_fd_pr__pfet_01v8 W=0.7 L=0.15
Xn_616_n1 n_616 n_614 n_616_x vss sky130_fd_pr__nfet_01v8 W=0.84 L=0.15
Xn_616_n2 n_616_x n_615 vss vss sky130_fd_pr__nfet_01v8 W=0.84 L=0.15
Xn_617_n n_617 n_616 vss vss sky130_fd_pr__nfet_01v8 W=0.42 L=0.15
Xn_617_p n_617 n_616 vdd vdd sky130_fd_pr__pfet_01v8 W=0.7 L=0.15
Xn_618_p1 n_618 n_616 n_618_x vdd sky130_fd_pr__pfet_01v8 W=1.4 L=0.15
Xn_618_p2 n_618_x n_202 vdd vdd sky130_fd_pr__pfet_01v8 W=1.4 L=0.15
Xn_618_n1 n_618 n_616 vss vss sky130_fd_pr__nfet_01v8 W=0.42 L=0.15
Xn_618_n2 n_618 n_202 vss vss sky130_fd_pr__nfet_01v8 W=0.42 L=0.15
Xn_619_p1 n_619 n_618 n_619_x vdd sky130_fd_pr__pfet_01v8 W=1.4 L=0.15
Xn_619_p2 n_619_x n_4 vdd vdd sky130_fd_pr__pfet_01v8 W=1.4 L=0.15
Xn_619_n1 n_619 n_618 vss vss sky130_fd_pr__nfet_01v8 W=0.42 L=0.15
Xn_619_n2 n_619 n_4 vss vss sky130_fd_pr__nfet_01v8 W=0.42 L=0.15
Xn_620_n n_620 n_619 vss vss sky130_fd_pr__nfet_01v8 W=0.42 L=0.15
Xn_620_p n_620 n_619 vdd vdd sky130_fd_pr__pfet_01v8 W=0.7 L=0.15
Xn_623_p1 n_623 n_617 n_623_x vdd sky130_fd_pr__pfet_01v8 W=1.4 L=0.15
Xn_623_p2 n_623_x n_202 vdd vdd sky130_fd_pr__pfet_01v8 W=1.4 L=0.15
Xn_623_n1 n_623 n_617 vss vss sky130_fd_pr__nfet_01v8 W=0.42 L=0.15
Xn_623_n2 n_623 n_202 vss vss sky130_fd_pr__nfet_01v8 W=0.42 L=0.15
Xn_622_p1 n_622 n_623 n_622_x vdd sky130_fd_pr__pfet_01v8 W=1.4 L=0.15
Xn_622_p2 n_622_x n_621 vdd vdd sky130_fd_pr__pfet_01v8 W=1.4 L=0.15
Xn_622_n1 n_622 n_623 vss vss sky130_fd_pr__nfet_01v8 W=0.42 L=0.15
Xn_622_n2 n_622 n_621 vss vss sky130_fd_pr__nfet_01v8 W=0.42 L=0.15
Xn_621_p1 n_621 n_620 n_621_x vdd sky130_fd_pr__pfet_01v8 W=1.4 L=0.15
Xn_621_p2 n_621_x n_622 vdd vdd sky130_fd_pr__pfet_01v8 W=1.4 L=0.15
Xn_621_n1 n_621 n_620 vss vss sky130_fd_pr__nfet_01v8 W=0.42 L=0.15
Xn_621_n2 n_621 n_622 vss vss sky130_fd_pr__nfet_01v8 W=0.42 L=0.15
Xn_624_p1 n_624 n_621 n_624_x vdd sky130_fd_pr__pfet_01v8 W=1.4 L=0.15
Xn_624_p2 n_624_x n_205 vdd vdd sky130_fd_pr__pfet_01v8 W=1.4 L=0.15
Xn_624_n1 n_624 n_621 vss vss sky130_fd_pr__nfet_01v8 W=0.42 L=0.15
Xn_624_n2 n_624 n_205 vss vss sky130_fd_pr__nfet_01v8 W=0.42 L=0.15
Xn_625_p1 n_625 n_624 n_625_x vdd sky130_fd_pr__pfet_01v8 W=1.4 L=0.15
Xn_625_p2 n_625_x n_4 vdd vdd sky130_fd_pr__pfet_01v8 W=1.4 L=0.15
Xn_625_n1 n_625 n_624 vss vss sky130_fd_pr__nfet_01v8 W=0.42 L=0.15
Xn_625_n2 n_625 n_4 vss vss sky130_fd_pr__nfet_01v8 W=0.42 L=0.15
Xn_626_n n_626 n_625 vss vss sky130_fd_pr__nfet_01v8 W=0.42 L=0.15
Xn_626_p n_626 n_625 vdd vdd sky130_fd_pr__pfet_01v8 W=0.7 L=0.15
Xn_628_p1 n_628 n_622 n_628_x vdd sky130_fd_pr__pfet_01v8 W=1.4 L=0.15
Xn_628_p2 n_628_x n_205 vdd vdd sky130_fd_pr__pfet_01v8 W=1.4 L=0.15
Xn_628_n1 n_628 n_622 vss vss sky130_fd_pr__nfet_01v8 W=0.42 L=0.15
Xn_628_n2 n_628 n_205 vss vss sky130_fd_pr__nfet_01v8 W=0.42 L=0.15
Xn_627_p1 n_627 n_628 n_627_x vdd sky130_fd_pr__pfet_01v8 W=1.4 L=0.15
Xn_627_p2 n_627_x env0 vdd vdd sky130_fd_pr__pfet_01v8 W=1.4 L=0.15
Xn_627_n1 n_627 n_628 vss vss sky130_fd_pr__nfet_01v8 W=0.42 L=0.15
Xn_627_n2 n_627 env0 vss vss sky130_fd_pr__nfet_01v8 W=0.42 L=0.15
Xenv0_p1 env0 n_626 env0_x vdd sky130_fd_pr__pfet_01v8 W=1.4 L=0.15
Xenv0_p2 env0_x n_627 vdd vdd sky130_fd_pr__pfet_01v8 W=1.4 L=0.15
Xenv0_n1 env0 n_626 vss vss sky130_fd_pr__nfet_01v8 W=0.42 L=0.15
Xenv0_n2 env0 n_627 vss vss sky130_fd_pr__nfet_01v8 W=0.42 L=0.15
Xn_629_n n_629 env0 vss vss sky130_fd_pr__nfet_01v8 W=0.42 L=0.15
Xn_629_p n_629 env0 vdd vdd sky130_fd_pr__pfet_01v8 W=0.7 L=0.15
Xn_630_p1 n_630 env0 vdd vdd sky130_fd_pr__pfet_01v8 W=0.7 L=0.15
Xn_630_p2 n_630 n_594 vdd vdd sky130_fd_pr__pfet_01v8 W=0.7 L=0.15
Xn_630_n1 n_630 env0 n_630_x vss sky130_fd_pr__nfet_01v8 W=0.84 L=0.15
Xn_630_n2 n_630_x n_594 vss vss sky130_fd_pr__nfet_01v8 W=0.84 L=0.15
Xn_631_n n_631 n_630 vss vss sky130_fd_pr__nfet_01v8 W=0.42 L=0.15
Xn_631_p n_631 n_630 vdd vdd sky130_fd_pr__pfet_01v8 W=0.7 L=0.15
Xn_632_p1 n_632 n_629 vdd vdd sky130_fd_pr__pfet_01v8 W=0.7 L=0.15
Xn_632_p2 n_632 n_594 vdd vdd sky130_fd_pr__pfet_01v8 W=0.7 L=0.15
Xn_632_n1 n_632 n_629 n_632_x vss sky130_fd_pr__nfet_01v8 W=0.84 L=0.15
Xn_632_n2 n_632_x n_594 vss vss sky130_fd_pr__nfet_01v8 W=0.84 L=0.15
Xn_633_n n_633 n_632 vss vss sky130_fd_pr__nfet_01v8 W=0.42 L=0.15
Xn_633_p n_633 n_632 vdd vdd sky130_fd_pr__pfet_01v8 W=0.7 L=0.15
Xn_634_p1 n_634 n_633 n_634_x vdd sky130_fd_pr__pfet_01v8 W=1.4 L=0.15
Xn_634_p2 n_634_x n_4 vdd vdd sky130_fd_pr__pfet_01v8 W=1.4 L=0.15
Xn_634_n1 n_634 n_633 vss vss sky130_fd_pr__nfet_01v8 W=0.42 L=0.15
Xn_634_n2 n_634 n_4 vss vss sky130_fd_pr__nfet_01v8 W=0.42 L=0.15
Xn_635_n n_635 n_634 vss vss sky130_fd_pr__nfet_01v8 W=0.42 L=0.15
Xn_635_p n_635 n_634 vdd vdd sky130_fd_pr__pfet_01v8 W=0.7 L=0.15
Xn_637_p1 n_637 n_631 n_637_x vdd sky130_fd_pr__pfet_01v8 W=1.4 L=0.15
Xn_637_p2 n_637_x n_636 vdd vdd sky130_fd_pr__pfet_01v8 W=1.4 L=0.15
Xn_637_n1 n_637 n_631 vss vss sky130_fd_pr__nfet_01v8 W=0.42 L=0.15
Xn_637_n2 n_637 n_636 vss vss sky130_fd_pr__nfet_01v8 W=0.42 L=0.15
Xn_636_p1 n_636 n_635 n_636_x vdd sky130_fd_pr__pfet_01v8 W=1.4 L=0.15
Xn_636_p2 n_636_x n_637 vdd vdd sky130_fd_pr__pfet_01v8 W=1.4 L=0.15
Xn_636_n1 n_636 n_635 vss vss sky130_fd_pr__nfet_01v8 W=0.42 L=0.15
Xn_636_n2 n_636 n_637 vss vss sky130_fd_pr__nfet_01v8 W=0.42 L=0.15
Xn_638_n n_638 n_636 vss vss sky130_fd_pr__nfet_01v8 W=0.42 L=0.15
Xn_638_p n_638 n_636 vdd vdd sky130_fd_pr__pfet_01v8 W=0.7 L=0.15
Xn_639_n n_639 n_638 vss vss sky130_fd_pr__nfet_01v8 W=0.42 L=0.15
Xn_639_p n_639 n_638 vdd vdd sky130_fd_pr__pfet_01v8 W=0.7 L=0.15
Xn_640_n n_640 x_neg0 vss vss sky130_fd_pr__nfet_01v8 W=0.42 L=0.15
Xn_640_p n_640 x_neg0 vdd vdd sky130_fd_pr__pfet_01v8 W=0.7 L=0.15
Xn_641_p1 n_641 n_639 vdd vdd sky130_fd_pr__pfet_01v8 W=0.7 L=0.15
Xn_641_p2 n_641 n_640 vdd vdd sky130_fd_pr__pfet_01v8 W=0.7 L=0.15
Xn_641_n1 n_641 n_639 n_641_x vss sky130_fd_pr__nfet_01v8 W=0.84 L=0.15
Xn_641_n2 n_641_x n_640 vss vss sky130_fd_pr__nfet_01v8 W=0.84 L=0.15
Xxin_p_r0_n xin_p_r0 n_641 vss vss sky130_fd_pr__nfet_01v8 W=0.42 L=0.15
Xxin_p_r0_p xin_p_r0 n_641 vdd vdd sky130_fd_pr__pfet_01v8 W=0.7 L=0.15
Xn_642_p1 n_642 n_639 vdd vdd sky130_fd_pr__pfet_01v8 W=0.7 L=0.15
Xn_642_p2 n_642 x_neg0 vdd vdd sky130_fd_pr__pfet_01v8 W=0.7 L=0.15
Xn_642_n1 n_642 n_639 n_642_x vss sky130_fd_pr__nfet_01v8 W=0.84 L=0.15
Xn_642_n2 n_642_x x_neg0 vss vss sky130_fd_pr__nfet_01v8 W=0.84 L=0.15
Xxin_n_r0_n xin_n_r0 n_642 vss vss sky130_fd_pr__nfet_01v8 W=0.42 L=0.15
Xxin_n_r0_p xin_n_r0 n_642 vdd vdd sky130_fd_pr__pfet_01v8 W=0.7 L=0.15
Xn_643_p1 n_643 n_639 vdd vdd sky130_fd_pr__pfet_01v8 W=0.7 L=0.15
Xn_643_p2 n_643 lora_en vdd vdd sky130_fd_pr__pfet_01v8 W=0.7 L=0.15
Xn_643_n1 n_643 n_639 n_643_x vss sky130_fd_pr__nfet_01v8 W=0.84 L=0.15
Xn_643_n2 n_643_x lora_en vss vss sky130_fd_pr__nfet_01v8 W=0.84 L=0.15
Xxrd_en0_n xrd_en0 n_643 vss vss sky130_fd_pr__nfet_01v8 W=0.42 L=0.15
Xxrd_en0_p xrd_en0 n_643 vdd vdd sky130_fd_pr__pfet_01v8 W=0.7 L=0.15
Xn_644_p1 n_644 n_587 vdd vdd sky130_fd_pr__pfet_01v8 W=0.7 L=0.15
Xn_644_p2 n_644 x_mag4 vdd vdd sky130_fd_pr__pfet_01v8 W=0.7 L=0.15
Xn_644_n1 n_644 n_587 n_644_x vss sky130_fd_pr__nfet_01v8 W=0.84 L=0.15
Xn_644_n2 n_644_x x_mag4 vss vss sky130_fd_pr__nfet_01v8 W=0.84 L=0.15
Xn_645_n n_645 n_644 vss vss sky130_fd_pr__nfet_01v8 W=0.42 L=0.15
Xn_645_p n_645 n_644 vdd vdd sky130_fd_pr__pfet_01v8 W=0.7 L=0.15
Xn_646_p1 n_646 n_588 vdd vdd sky130_fd_pr__pfet_01v8 W=0.7 L=0.15
Xn_646_p2 n_646 x_mag5 vdd vdd sky130_fd_pr__pfet_01v8 W=0.7 L=0.15
Xn_646_n1 n_646 n_588 n_646_x vss sky130_fd_pr__nfet_01v8 W=0.84 L=0.15
Xn_646_n2 n_646_x x_mag5 vss vss sky130_fd_pr__nfet_01v8 W=0.84 L=0.15
Xn_647_p1 n_647 n_588 n_647_x vdd sky130_fd_pr__pfet_01v8 W=1.4 L=0.15
Xn_647_p2 n_647_x x_mag5 vdd vdd sky130_fd_pr__pfet_01v8 W=1.4 L=0.15
Xn_647_n1 n_647 n_588 vss vss sky130_fd_pr__nfet_01v8 W=0.42 L=0.15
Xn_647_n2 n_647 x_mag5 vss vss sky130_fd_pr__nfet_01v8 W=0.42 L=0.15
Xn_648_n n_648 n_647 vss vss sky130_fd_pr__nfet_01v8 W=0.42 L=0.15
Xn_648_p n_648 n_647 vdd vdd sky130_fd_pr__pfet_01v8 W=0.7 L=0.15
Xn_649_p1 n_649 n_645 vdd vdd sky130_fd_pr__pfet_01v8 W=0.7 L=0.15
Xn_649_p2 n_649 n_648 vdd vdd sky130_fd_pr__pfet_01v8 W=0.7 L=0.15
Xn_649_n1 n_649 n_645 n_649_x vss sky130_fd_pr__nfet_01v8 W=0.84 L=0.15
Xn_649_n2 n_649_x n_648 vss vss sky130_fd_pr__nfet_01v8 W=0.84 L=0.15
Xn_650_p1 n_650 n_646 vdd vdd sky130_fd_pr__pfet_01v8 W=0.7 L=0.15
Xn_650_p2 n_650 n_649 vdd vdd sky130_fd_pr__pfet_01v8 W=0.7 L=0.15
Xn_650_n1 n_650 n_646 n_650_x vss sky130_fd_pr__nfet_01v8 W=0.84 L=0.15
Xn_650_n2 n_650_x n_649 vss vss sky130_fd_pr__nfet_01v8 W=0.84 L=0.15
Xn_651_p1 n_651 n_589 vdd vdd sky130_fd_pr__pfet_01v8 W=0.7 L=0.15
Xn_651_p2 n_651 x_mag6 vdd vdd sky130_fd_pr__pfet_01v8 W=0.7 L=0.15
Xn_651_n1 n_651 n_589 n_651_x vss sky130_fd_pr__nfet_01v8 W=0.84 L=0.15
Xn_651_n2 n_651_x x_mag6 vss vss sky130_fd_pr__nfet_01v8 W=0.84 L=0.15
Xn_652_p1 n_652 n_589 n_652_x vdd sky130_fd_pr__pfet_01v8 W=1.4 L=0.15
Xn_652_p2 n_652_x x_mag6 vdd vdd sky130_fd_pr__pfet_01v8 W=1.4 L=0.15
Xn_652_n1 n_652 n_589 vss vss sky130_fd_pr__nfet_01v8 W=0.42 L=0.15
Xn_652_n2 n_652 x_mag6 vss vss sky130_fd_pr__nfet_01v8 W=0.42 L=0.15
Xn_653_n n_653 n_652 vss vss sky130_fd_pr__nfet_01v8 W=0.42 L=0.15
Xn_653_p n_653 n_652 vdd vdd sky130_fd_pr__pfet_01v8 W=0.7 L=0.15
Xn_654_p1 n_654 n_650 vdd vdd sky130_fd_pr__pfet_01v8 W=0.7 L=0.15
Xn_654_p2 n_654 n_653 vdd vdd sky130_fd_pr__pfet_01v8 W=0.7 L=0.15
Xn_654_n1 n_654 n_650 n_654_x vss sky130_fd_pr__nfet_01v8 W=0.84 L=0.15
Xn_654_n2 n_654_x n_653 vss vss sky130_fd_pr__nfet_01v8 W=0.84 L=0.15
Xn_655_p1 n_655 n_651 vdd vdd sky130_fd_pr__pfet_01v8 W=0.7 L=0.15
Xn_655_p2 n_655 n_654 vdd vdd sky130_fd_pr__pfet_01v8 W=0.7 L=0.15
Xn_655_n1 n_655 n_651 n_655_x vss sky130_fd_pr__nfet_01v8 W=0.84 L=0.15
Xn_655_n2 n_655_x n_654 vss vss sky130_fd_pr__nfet_01v8 W=0.84 L=0.15
Xn_656_p1 n_656 n_590 vdd vdd sky130_fd_pr__pfet_01v8 W=0.7 L=0.15
Xn_656_p2 n_656 x_mag7 vdd vdd sky130_fd_pr__pfet_01v8 W=0.7 L=0.15
Xn_656_n1 n_656 n_590 n_656_x vss sky130_fd_pr__nfet_01v8 W=0.84 L=0.15
Xn_656_n2 n_656_x x_mag7 vss vss sky130_fd_pr__nfet_01v8 W=0.84 L=0.15
Xn_657_p1 n_657 n_590 n_657_x vdd sky130_fd_pr__pfet_01v8 W=1.4 L=0.15
Xn_657_p2 n_657_x x_mag7 vdd vdd sky130_fd_pr__pfet_01v8 W=1.4 L=0.15
Xn_657_n1 n_657 n_590 vss vss sky130_fd_pr__nfet_01v8 W=0.42 L=0.15
Xn_657_n2 n_657 x_mag7 vss vss sky130_fd_pr__nfet_01v8 W=0.42 L=0.15
Xn_658_n n_658 n_657 vss vss sky130_fd_pr__nfet_01v8 W=0.42 L=0.15
Xn_658_p n_658 n_657 vdd vdd sky130_fd_pr__pfet_01v8 W=0.7 L=0.15
Xn_659_p1 n_659 n_655 vdd vdd sky130_fd_pr__pfet_01v8 W=0.7 L=0.15
Xn_659_p2 n_659 n_658 vdd vdd sky130_fd_pr__pfet_01v8 W=0.7 L=0.15
Xn_659_n1 n_659 n_655 n_659_x vss sky130_fd_pr__nfet_01v8 W=0.84 L=0.15
Xn_659_n2 n_659_x n_658 vss vss sky130_fd_pr__nfet_01v8 W=0.84 L=0.15
Xn_660_p1 n_660 n_656 vdd vdd sky130_fd_pr__pfet_01v8 W=0.7 L=0.15
Xn_660_p2 n_660 n_659 vdd vdd sky130_fd_pr__pfet_01v8 W=0.7 L=0.15
Xn_660_n1 n_660 n_656 n_660_x vss sky130_fd_pr__nfet_01v8 W=0.84 L=0.15
Xn_660_n2 n_660_x n_659 vss vss sky130_fd_pr__nfet_01v8 W=0.84 L=0.15
Xn_661_p1 n_661 n_403 vdd vdd sky130_fd_pr__pfet_01v8 W=0.7 L=0.15
Xn_661_p2 n_661 n_660 vdd vdd sky130_fd_pr__pfet_01v8 W=0.7 L=0.15
Xn_661_n1 n_661 n_403 n_661_x vss sky130_fd_pr__nfet_01v8 W=0.84 L=0.15
Xn_661_n2 n_661_x n_660 vss vss sky130_fd_pr__nfet_01v8 W=0.84 L=0.15
Xn_662_n n_662 n_661 vss vss sky130_fd_pr__nfet_01v8 W=0.42 L=0.15
Xn_662_p n_662 n_661 vdd vdd sky130_fd_pr__pfet_01v8 W=0.7 L=0.15
Xn_663_p1 n_663 n_440 vdd vdd sky130_fd_pr__pfet_01v8 W=0.7 L=0.15
Xn_663_p2 n_663 n_662 vdd vdd sky130_fd_pr__pfet_01v8 W=0.7 L=0.15
Xn_663_n1 n_663 n_440 n_663_x vss sky130_fd_pr__nfet_01v8 W=0.84 L=0.15
Xn_663_n2 n_663_x n_662 vss vss sky130_fd_pr__nfet_01v8 W=0.84 L=0.15
Xn_664_p1 n_664 n_591 vdd vdd sky130_fd_pr__pfet_01v8 W=0.7 L=0.15
Xn_664_p2 n_664 env1 vdd vdd sky130_fd_pr__pfet_01v8 W=0.7 L=0.15
Xn_664_n1 n_664 n_591 n_664_x vss sky130_fd_pr__nfet_01v8 W=0.84 L=0.15
Xn_664_n2 n_664_x env1 vss vss sky130_fd_pr__nfet_01v8 W=0.84 L=0.15
Xn_665_p1 n_665 n_663 vdd vdd sky130_fd_pr__pfet_01v8 W=0.7 L=0.15
Xn_665_p2 n_665 n_664 vdd vdd sky130_fd_pr__pfet_01v8 W=0.7 L=0.15
Xn_665_n1 n_665 n_663 n_665_x vss sky130_fd_pr__nfet_01v8 W=0.84 L=0.15
Xn_665_n2 n_665_x n_664 vss vss sky130_fd_pr__nfet_01v8 W=0.84 L=0.15
Xn_666_n n_666 n_665 vss vss sky130_fd_pr__nfet_01v8 W=0.42 L=0.15
Xn_666_p n_666 n_665 vdd vdd sky130_fd_pr__pfet_01v8 W=0.7 L=0.15
Xn_667_p1 n_667 n_665 n_667_x vdd sky130_fd_pr__pfet_01v8 W=1.4 L=0.15
Xn_667_p2 n_667_x n_202 vdd vdd sky130_fd_pr__pfet_01v8 W=1.4 L=0.15
Xn_667_n1 n_667 n_665 vss vss sky130_fd_pr__nfet_01v8 W=0.42 L=0.15
Xn_667_n2 n_667 n_202 vss vss sky130_fd_pr__nfet_01v8 W=0.42 L=0.15
Xn_668_p1 n_668 n_667 n_668_x vdd sky130_fd_pr__pfet_01v8 W=1.4 L=0.15
Xn_668_p2 n_668_x n_4 vdd vdd sky130_fd_pr__pfet_01v8 W=1.4 L=0.15
Xn_668_n1 n_668 n_667 vss vss sky130_fd_pr__nfet_01v8 W=0.42 L=0.15
Xn_668_n2 n_668 n_4 vss vss sky130_fd_pr__nfet_01v8 W=0.42 L=0.15
Xn_669_n n_669 n_668 vss vss sky130_fd_pr__nfet_01v8 W=0.42 L=0.15
Xn_669_p n_669 n_668 vdd vdd sky130_fd_pr__pfet_01v8 W=0.7 L=0.15
Xn_672_p1 n_672 n_666 n_672_x vdd sky130_fd_pr__pfet_01v8 W=1.4 L=0.15
Xn_672_p2 n_672_x n_202 vdd vdd sky130_fd_pr__pfet_01v8 W=1.4 L=0.15
Xn_672_n1 n_672 n_666 vss vss sky130_fd_pr__nfet_01v8 W=0.42 L=0.15
Xn_672_n2 n_672 n_202 vss vss sky130_fd_pr__nfet_01v8 W=0.42 L=0.15
Xn_671_p1 n_671 n_672 n_671_x vdd sky130_fd_pr__pfet_01v8 W=1.4 L=0.15
Xn_671_p2 n_671_x n_670 vdd vdd sky130_fd_pr__pfet_01v8 W=1.4 L=0.15
Xn_671_n1 n_671 n_672 vss vss sky130_fd_pr__nfet_01v8 W=0.42 L=0.15
Xn_671_n2 n_671 n_670 vss vss sky130_fd_pr__nfet_01v8 W=0.42 L=0.15
Xn_670_p1 n_670 n_669 n_670_x vdd sky130_fd_pr__pfet_01v8 W=1.4 L=0.15
Xn_670_p2 n_670_x n_671 vdd vdd sky130_fd_pr__pfet_01v8 W=1.4 L=0.15
Xn_670_n1 n_670 n_669 vss vss sky130_fd_pr__nfet_01v8 W=0.42 L=0.15
Xn_670_n2 n_670 n_671 vss vss sky130_fd_pr__nfet_01v8 W=0.42 L=0.15
Xn_673_p1 n_673 n_670 n_673_x vdd sky130_fd_pr__pfet_01v8 W=1.4 L=0.15
Xn_673_p2 n_673_x n_205 vdd vdd sky130_fd_pr__pfet_01v8 W=1.4 L=0.15
Xn_673_n1 n_673 n_670 vss vss sky130_fd_pr__nfet_01v8 W=0.42 L=0.15
Xn_673_n2 n_673 n_205 vss vss sky130_fd_pr__nfet_01v8 W=0.42 L=0.15
Xn_674_p1 n_674 n_673 n_674_x vdd sky130_fd_pr__pfet_01v8 W=1.4 L=0.15
Xn_674_p2 n_674_x n_4 vdd vdd sky130_fd_pr__pfet_01v8 W=1.4 L=0.15
Xn_674_n1 n_674 n_673 vss vss sky130_fd_pr__nfet_01v8 W=0.42 L=0.15
Xn_674_n2 n_674 n_4 vss vss sky130_fd_pr__nfet_01v8 W=0.42 L=0.15
Xn_675_n n_675 n_674 vss vss sky130_fd_pr__nfet_01v8 W=0.42 L=0.15
Xn_675_p n_675 n_674 vdd vdd sky130_fd_pr__pfet_01v8 W=0.7 L=0.15
Xn_677_p1 n_677 n_671 n_677_x vdd sky130_fd_pr__pfet_01v8 W=1.4 L=0.15
Xn_677_p2 n_677_x n_205 vdd vdd sky130_fd_pr__pfet_01v8 W=1.4 L=0.15
Xn_677_n1 n_677 n_671 vss vss sky130_fd_pr__nfet_01v8 W=0.42 L=0.15
Xn_677_n2 n_677 n_205 vss vss sky130_fd_pr__nfet_01v8 W=0.42 L=0.15
Xn_676_p1 n_676 n_677 n_676_x vdd sky130_fd_pr__pfet_01v8 W=1.4 L=0.15
Xn_676_p2 n_676_x env1 vdd vdd sky130_fd_pr__pfet_01v8 W=1.4 L=0.15
Xn_676_n1 n_676 n_677 vss vss sky130_fd_pr__nfet_01v8 W=0.42 L=0.15
Xn_676_n2 n_676 env1 vss vss sky130_fd_pr__nfet_01v8 W=0.42 L=0.15
Xenv1_p1 env1 n_675 env1_x vdd sky130_fd_pr__pfet_01v8 W=1.4 L=0.15
Xenv1_p2 env1_x n_676 vdd vdd sky130_fd_pr__pfet_01v8 W=1.4 L=0.15
Xenv1_n1 env1 n_675 vss vss sky130_fd_pr__nfet_01v8 W=0.42 L=0.15
Xenv1_n2 env1 n_676 vss vss sky130_fd_pr__nfet_01v8 W=0.42 L=0.15
Xn_678_n n_678 env1 vss vss sky130_fd_pr__nfet_01v8 W=0.42 L=0.15
Xn_678_p n_678 env1 vdd vdd sky130_fd_pr__pfet_01v8 W=0.7 L=0.15
Xn_679_p1 n_679 env1 vdd vdd sky130_fd_pr__pfet_01v8 W=0.7 L=0.15
Xn_679_p2 n_679 n_594 vdd vdd sky130_fd_pr__pfet_01v8 W=0.7 L=0.15
Xn_679_n1 n_679 env1 n_679_x vss sky130_fd_pr__nfet_01v8 W=0.84 L=0.15
Xn_679_n2 n_679_x n_594 vss vss sky130_fd_pr__nfet_01v8 W=0.84 L=0.15
Xn_680_n n_680 n_679 vss vss sky130_fd_pr__nfet_01v8 W=0.42 L=0.15
Xn_680_p n_680 n_679 vdd vdd sky130_fd_pr__pfet_01v8 W=0.7 L=0.15
Xn_681_p1 n_681 n_678 vdd vdd sky130_fd_pr__pfet_01v8 W=0.7 L=0.15
Xn_681_p2 n_681 n_594 vdd vdd sky130_fd_pr__pfet_01v8 W=0.7 L=0.15
Xn_681_n1 n_681 n_678 n_681_x vss sky130_fd_pr__nfet_01v8 W=0.84 L=0.15
Xn_681_n2 n_681_x n_594 vss vss sky130_fd_pr__nfet_01v8 W=0.84 L=0.15
Xn_682_n n_682 n_681 vss vss sky130_fd_pr__nfet_01v8 W=0.42 L=0.15
Xn_682_p n_682 n_681 vdd vdd sky130_fd_pr__pfet_01v8 W=0.7 L=0.15
Xn_683_p1 n_683 n_682 n_683_x vdd sky130_fd_pr__pfet_01v8 W=1.4 L=0.15
Xn_683_p2 n_683_x n_4 vdd vdd sky130_fd_pr__pfet_01v8 W=1.4 L=0.15
Xn_683_n1 n_683 n_682 vss vss sky130_fd_pr__nfet_01v8 W=0.42 L=0.15
Xn_683_n2 n_683 n_4 vss vss sky130_fd_pr__nfet_01v8 W=0.42 L=0.15
Xn_684_n n_684 n_683 vss vss sky130_fd_pr__nfet_01v8 W=0.42 L=0.15
Xn_684_p n_684 n_683 vdd vdd sky130_fd_pr__pfet_01v8 W=0.7 L=0.15
Xn_686_p1 n_686 n_680 n_686_x vdd sky130_fd_pr__pfet_01v8 W=1.4 L=0.15
Xn_686_p2 n_686_x n_685 vdd vdd sky130_fd_pr__pfet_01v8 W=1.4 L=0.15
Xn_686_n1 n_686 n_680 vss vss sky130_fd_pr__nfet_01v8 W=0.42 L=0.15
Xn_686_n2 n_686 n_685 vss vss sky130_fd_pr__nfet_01v8 W=0.42 L=0.15
Xn_685_p1 n_685 n_684 n_685_x vdd sky130_fd_pr__pfet_01v8 W=1.4 L=0.15
Xn_685_p2 n_685_x n_686 vdd vdd sky130_fd_pr__pfet_01v8 W=1.4 L=0.15
Xn_685_n1 n_685 n_684 vss vss sky130_fd_pr__nfet_01v8 W=0.42 L=0.15
Xn_685_n2 n_685 n_686 vss vss sky130_fd_pr__nfet_01v8 W=0.42 L=0.15
Xn_687_n n_687 n_685 vss vss sky130_fd_pr__nfet_01v8 W=0.42 L=0.15
Xn_687_p n_687 n_685 vdd vdd sky130_fd_pr__pfet_01v8 W=0.7 L=0.15
Xn_688_n n_688 n_687 vss vss sky130_fd_pr__nfet_01v8 W=0.42 L=0.15
Xn_688_p n_688 n_687 vdd vdd sky130_fd_pr__pfet_01v8 W=0.7 L=0.15
Xn_689_n n_689 x_neg1 vss vss sky130_fd_pr__nfet_01v8 W=0.42 L=0.15
Xn_689_p n_689 x_neg1 vdd vdd sky130_fd_pr__pfet_01v8 W=0.7 L=0.15
Xn_690_p1 n_690 n_688 vdd vdd sky130_fd_pr__pfet_01v8 W=0.7 L=0.15
Xn_690_p2 n_690 n_689 vdd vdd sky130_fd_pr__pfet_01v8 W=0.7 L=0.15
Xn_690_n1 n_690 n_688 n_690_x vss sky130_fd_pr__nfet_01v8 W=0.84 L=0.15
Xn_690_n2 n_690_x n_689 vss vss sky130_fd_pr__nfet_01v8 W=0.84 L=0.15
Xxin_p_r1_n xin_p_r1 n_690 vss vss sky130_fd_pr__nfet_01v8 W=0.42 L=0.15
Xxin_p_r1_p xin_p_r1 n_690 vdd vdd sky130_fd_pr__pfet_01v8 W=0.7 L=0.15
Xn_691_p1 n_691 n_688 vdd vdd sky130_fd_pr__pfet_01v8 W=0.7 L=0.15
Xn_691_p2 n_691 x_neg1 vdd vdd sky130_fd_pr__pfet_01v8 W=0.7 L=0.15
Xn_691_n1 n_691 n_688 n_691_x vss sky130_fd_pr__nfet_01v8 W=0.84 L=0.15
Xn_691_n2 n_691_x x_neg1 vss vss sky130_fd_pr__nfet_01v8 W=0.84 L=0.15
Xxin_n_r1_n xin_n_r1 n_691 vss vss sky130_fd_pr__nfet_01v8 W=0.42 L=0.15
Xxin_n_r1_p xin_n_r1 n_691 vdd vdd sky130_fd_pr__pfet_01v8 W=0.7 L=0.15
Xn_692_p1 n_692 n_688 vdd vdd sky130_fd_pr__pfet_01v8 W=0.7 L=0.15
Xn_692_p2 n_692 lora_en vdd vdd sky130_fd_pr__pfet_01v8 W=0.7 L=0.15
Xn_692_n1 n_692 n_688 n_692_x vss sky130_fd_pr__nfet_01v8 W=0.84 L=0.15
Xn_692_n2 n_692_x lora_en vss vss sky130_fd_pr__nfet_01v8 W=0.84 L=0.15
Xxrd_en1_n xrd_en1 n_692 vss vss sky130_fd_pr__nfet_01v8 W=0.42 L=0.15
Xxrd_en1_p xrd_en1 n_692 vdd vdd sky130_fd_pr__pfet_01v8 W=0.7 L=0.15
Xn_693_p1 n_693 n_587 vdd vdd sky130_fd_pr__pfet_01v8 W=0.7 L=0.15
Xn_693_p2 n_693 x_mag8 vdd vdd sky130_fd_pr__pfet_01v8 W=0.7 L=0.15
Xn_693_n1 n_693 n_587 n_693_x vss sky130_fd_pr__nfet_01v8 W=0.84 L=0.15
Xn_693_n2 n_693_x x_mag8 vss vss sky130_fd_pr__nfet_01v8 W=0.84 L=0.15
Xn_694_n n_694 n_693 vss vss sky130_fd_pr__nfet_01v8 W=0.42 L=0.15
Xn_694_p n_694 n_693 vdd vdd sky130_fd_pr__pfet_01v8 W=0.7 L=0.15
Xn_695_p1 n_695 n_588 vdd vdd sky130_fd_pr__pfet_01v8 W=0.7 L=0.15
Xn_695_p2 n_695 x_mag9 vdd vdd sky130_fd_pr__pfet_01v8 W=0.7 L=0.15
Xn_695_n1 n_695 n_588 n_695_x vss sky130_fd_pr__nfet_01v8 W=0.84 L=0.15
Xn_695_n2 n_695_x x_mag9 vss vss sky130_fd_pr__nfet_01v8 W=0.84 L=0.15
Xn_696_p1 n_696 n_588 n_696_x vdd sky130_fd_pr__pfet_01v8 W=1.4 L=0.15
Xn_696_p2 n_696_x x_mag9 vdd vdd sky130_fd_pr__pfet_01v8 W=1.4 L=0.15
Xn_696_n1 n_696 n_588 vss vss sky130_fd_pr__nfet_01v8 W=0.42 L=0.15
Xn_696_n2 n_696 x_mag9 vss vss sky130_fd_pr__nfet_01v8 W=0.42 L=0.15
Xn_697_n n_697 n_696 vss vss sky130_fd_pr__nfet_01v8 W=0.42 L=0.15
Xn_697_p n_697 n_696 vdd vdd sky130_fd_pr__pfet_01v8 W=0.7 L=0.15
Xn_698_p1 n_698 n_694 vdd vdd sky130_fd_pr__pfet_01v8 W=0.7 L=0.15
Xn_698_p2 n_698 n_697 vdd vdd sky130_fd_pr__pfet_01v8 W=0.7 L=0.15
Xn_698_n1 n_698 n_694 n_698_x vss sky130_fd_pr__nfet_01v8 W=0.84 L=0.15
Xn_698_n2 n_698_x n_697 vss vss sky130_fd_pr__nfet_01v8 W=0.84 L=0.15
Xn_699_p1 n_699 n_695 vdd vdd sky130_fd_pr__pfet_01v8 W=0.7 L=0.15
Xn_699_p2 n_699 n_698 vdd vdd sky130_fd_pr__pfet_01v8 W=0.7 L=0.15
Xn_699_n1 n_699 n_695 n_699_x vss sky130_fd_pr__nfet_01v8 W=0.84 L=0.15
Xn_699_n2 n_699_x n_698 vss vss sky130_fd_pr__nfet_01v8 W=0.84 L=0.15
Xn_700_p1 n_700 n_589 vdd vdd sky130_fd_pr__pfet_01v8 W=0.7 L=0.15
Xn_700_p2 n_700 x_mag10 vdd vdd sky130_fd_pr__pfet_01v8 W=0.7 L=0.15
Xn_700_n1 n_700 n_589 n_700_x vss sky130_fd_pr__nfet_01v8 W=0.84 L=0.15
Xn_700_n2 n_700_x x_mag10 vss vss sky130_fd_pr__nfet_01v8 W=0.84 L=0.15
Xn_701_p1 n_701 n_589 n_701_x vdd sky130_fd_pr__pfet_01v8 W=1.4 L=0.15
Xn_701_p2 n_701_x x_mag10 vdd vdd sky130_fd_pr__pfet_01v8 W=1.4 L=0.15
Xn_701_n1 n_701 n_589 vss vss sky130_fd_pr__nfet_01v8 W=0.42 L=0.15
Xn_701_n2 n_701 x_mag10 vss vss sky130_fd_pr__nfet_01v8 W=0.42 L=0.15
Xn_702_n n_702 n_701 vss vss sky130_fd_pr__nfet_01v8 W=0.42 L=0.15
Xn_702_p n_702 n_701 vdd vdd sky130_fd_pr__pfet_01v8 W=0.7 L=0.15
Xn_703_p1 n_703 n_699 vdd vdd sky130_fd_pr__pfet_01v8 W=0.7 L=0.15
Xn_703_p2 n_703 n_702 vdd vdd sky130_fd_pr__pfet_01v8 W=0.7 L=0.15
Xn_703_n1 n_703 n_699 n_703_x vss sky130_fd_pr__nfet_01v8 W=0.84 L=0.15
Xn_703_n2 n_703_x n_702 vss vss sky130_fd_pr__nfet_01v8 W=0.84 L=0.15
Xn_704_p1 n_704 n_700 vdd vdd sky130_fd_pr__pfet_01v8 W=0.7 L=0.15
Xn_704_p2 n_704 n_703 vdd vdd sky130_fd_pr__pfet_01v8 W=0.7 L=0.15
Xn_704_n1 n_704 n_700 n_704_x vss sky130_fd_pr__nfet_01v8 W=0.84 L=0.15
Xn_704_n2 n_704_x n_703 vss vss sky130_fd_pr__nfet_01v8 W=0.84 L=0.15
Xn_705_p1 n_705 n_590 vdd vdd sky130_fd_pr__pfet_01v8 W=0.7 L=0.15
Xn_705_p2 n_705 x_mag11 vdd vdd sky130_fd_pr__pfet_01v8 W=0.7 L=0.15
Xn_705_n1 n_705 n_590 n_705_x vss sky130_fd_pr__nfet_01v8 W=0.84 L=0.15
Xn_705_n2 n_705_x x_mag11 vss vss sky130_fd_pr__nfet_01v8 W=0.84 L=0.15
Xn_706_p1 n_706 n_590 n_706_x vdd sky130_fd_pr__pfet_01v8 W=1.4 L=0.15
Xn_706_p2 n_706_x x_mag11 vdd vdd sky130_fd_pr__pfet_01v8 W=1.4 L=0.15
Xn_706_n1 n_706 n_590 vss vss sky130_fd_pr__nfet_01v8 W=0.42 L=0.15
Xn_706_n2 n_706 x_mag11 vss vss sky130_fd_pr__nfet_01v8 W=0.42 L=0.15
Xn_707_n n_707 n_706 vss vss sky130_fd_pr__nfet_01v8 W=0.42 L=0.15
Xn_707_p n_707 n_706 vdd vdd sky130_fd_pr__pfet_01v8 W=0.7 L=0.15
Xn_708_p1 n_708 n_704 vdd vdd sky130_fd_pr__pfet_01v8 W=0.7 L=0.15
Xn_708_p2 n_708 n_707 vdd vdd sky130_fd_pr__pfet_01v8 W=0.7 L=0.15
Xn_708_n1 n_708 n_704 n_708_x vss sky130_fd_pr__nfet_01v8 W=0.84 L=0.15
Xn_708_n2 n_708_x n_707 vss vss sky130_fd_pr__nfet_01v8 W=0.84 L=0.15
Xn_709_p1 n_709 n_705 vdd vdd sky130_fd_pr__pfet_01v8 W=0.7 L=0.15
Xn_709_p2 n_709 n_708 vdd vdd sky130_fd_pr__pfet_01v8 W=0.7 L=0.15
Xn_709_n1 n_709 n_705 n_709_x vss sky130_fd_pr__nfet_01v8 W=0.84 L=0.15
Xn_709_n2 n_709_x n_708 vss vss sky130_fd_pr__nfet_01v8 W=0.84 L=0.15
Xn_710_p1 n_710 n_403 vdd vdd sky130_fd_pr__pfet_01v8 W=0.7 L=0.15
Xn_710_p2 n_710 n_709 vdd vdd sky130_fd_pr__pfet_01v8 W=0.7 L=0.15
Xn_710_n1 n_710 n_403 n_710_x vss sky130_fd_pr__nfet_01v8 W=0.84 L=0.15
Xn_710_n2 n_710_x n_709 vss vss sky130_fd_pr__nfet_01v8 W=0.84 L=0.15
Xn_711_n n_711 n_710 vss vss sky130_fd_pr__nfet_01v8 W=0.42 L=0.15
Xn_711_p n_711 n_710 vdd vdd sky130_fd_pr__pfet_01v8 W=0.7 L=0.15
Xn_712_p1 n_712 n_440 vdd vdd sky130_fd_pr__pfet_01v8 W=0.7 L=0.15
Xn_712_p2 n_712 n_711 vdd vdd sky130_fd_pr__pfet_01v8 W=0.7 L=0.15
Xn_712_n1 n_712 n_440 n_712_x vss sky130_fd_pr__nfet_01v8 W=0.84 L=0.15
Xn_712_n2 n_712_x n_711 vss vss sky130_fd_pr__nfet_01v8 W=0.84 L=0.15
Xn_713_p1 n_713 n_591 vdd vdd sky130_fd_pr__pfet_01v8 W=0.7 L=0.15
Xn_713_p2 n_713 env2 vdd vdd sky130_fd_pr__pfet_01v8 W=0.7 L=0.15
Xn_713_n1 n_713 n_591 n_713_x vss sky130_fd_pr__nfet_01v8 W=0.84 L=0.15
Xn_713_n2 n_713_x env2 vss vss sky130_fd_pr__nfet_01v8 W=0.84 L=0.15
Xn_714_p1 n_714 n_712 vdd vdd sky130_fd_pr__pfet_01v8 W=0.7 L=0.15
Xn_714_p2 n_714 n_713 vdd vdd sky130_fd_pr__pfet_01v8 W=0.7 L=0.15
Xn_714_n1 n_714 n_712 n_714_x vss sky130_fd_pr__nfet_01v8 W=0.84 L=0.15
Xn_714_n2 n_714_x n_713 vss vss sky130_fd_pr__nfet_01v8 W=0.84 L=0.15
Xn_715_n n_715 n_714 vss vss sky130_fd_pr__nfet_01v8 W=0.42 L=0.15
Xn_715_p n_715 n_714 vdd vdd sky130_fd_pr__pfet_01v8 W=0.7 L=0.15
Xn_716_p1 n_716 n_714 n_716_x vdd sky130_fd_pr__pfet_01v8 W=1.4 L=0.15
Xn_716_p2 n_716_x n_202 vdd vdd sky130_fd_pr__pfet_01v8 W=1.4 L=0.15
Xn_716_n1 n_716 n_714 vss vss sky130_fd_pr__nfet_01v8 W=0.42 L=0.15
Xn_716_n2 n_716 n_202 vss vss sky130_fd_pr__nfet_01v8 W=0.42 L=0.15
Xn_717_p1 n_717 n_716 n_717_x vdd sky130_fd_pr__pfet_01v8 W=1.4 L=0.15
Xn_717_p2 n_717_x n_4 vdd vdd sky130_fd_pr__pfet_01v8 W=1.4 L=0.15
Xn_717_n1 n_717 n_716 vss vss sky130_fd_pr__nfet_01v8 W=0.42 L=0.15
Xn_717_n2 n_717 n_4 vss vss sky130_fd_pr__nfet_01v8 W=0.42 L=0.15
Xn_718_n n_718 n_717 vss vss sky130_fd_pr__nfet_01v8 W=0.42 L=0.15
Xn_718_p n_718 n_717 vdd vdd sky130_fd_pr__pfet_01v8 W=0.7 L=0.15
Xn_721_p1 n_721 n_715 n_721_x vdd sky130_fd_pr__pfet_01v8 W=1.4 L=0.15
Xn_721_p2 n_721_x n_202 vdd vdd sky130_fd_pr__pfet_01v8 W=1.4 L=0.15
Xn_721_n1 n_721 n_715 vss vss sky130_fd_pr__nfet_01v8 W=0.42 L=0.15
Xn_721_n2 n_721 n_202 vss vss sky130_fd_pr__nfet_01v8 W=0.42 L=0.15
Xn_720_p1 n_720 n_721 n_720_x vdd sky130_fd_pr__pfet_01v8 W=1.4 L=0.15
Xn_720_p2 n_720_x n_719 vdd vdd sky130_fd_pr__pfet_01v8 W=1.4 L=0.15
Xn_720_n1 n_720 n_721 vss vss sky130_fd_pr__nfet_01v8 W=0.42 L=0.15
Xn_720_n2 n_720 n_719 vss vss sky130_fd_pr__nfet_01v8 W=0.42 L=0.15
Xn_719_p1 n_719 n_718 n_719_x vdd sky130_fd_pr__pfet_01v8 W=1.4 L=0.15
Xn_719_p2 n_719_x n_720 vdd vdd sky130_fd_pr__pfet_01v8 W=1.4 L=0.15
Xn_719_n1 n_719 n_718 vss vss sky130_fd_pr__nfet_01v8 W=0.42 L=0.15
Xn_719_n2 n_719 n_720 vss vss sky130_fd_pr__nfet_01v8 W=0.42 L=0.15
Xn_722_p1 n_722 n_719 n_722_x vdd sky130_fd_pr__pfet_01v8 W=1.4 L=0.15
Xn_722_p2 n_722_x n_205 vdd vdd sky130_fd_pr__pfet_01v8 W=1.4 L=0.15
Xn_722_n1 n_722 n_719 vss vss sky130_fd_pr__nfet_01v8 W=0.42 L=0.15
Xn_722_n2 n_722 n_205 vss vss sky130_fd_pr__nfet_01v8 W=0.42 L=0.15
Xn_723_p1 n_723 n_722 n_723_x vdd sky130_fd_pr__pfet_01v8 W=1.4 L=0.15
Xn_723_p2 n_723_x n_4 vdd vdd sky130_fd_pr__pfet_01v8 W=1.4 L=0.15
Xn_723_n1 n_723 n_722 vss vss sky130_fd_pr__nfet_01v8 W=0.42 L=0.15
Xn_723_n2 n_723 n_4 vss vss sky130_fd_pr__nfet_01v8 W=0.42 L=0.15
Xn_724_n n_724 n_723 vss vss sky130_fd_pr__nfet_01v8 W=0.42 L=0.15
Xn_724_p n_724 n_723 vdd vdd sky130_fd_pr__pfet_01v8 W=0.7 L=0.15
Xn_726_p1 n_726 n_720 n_726_x vdd sky130_fd_pr__pfet_01v8 W=1.4 L=0.15
Xn_726_p2 n_726_x n_205 vdd vdd sky130_fd_pr__pfet_01v8 W=1.4 L=0.15
Xn_726_n1 n_726 n_720 vss vss sky130_fd_pr__nfet_01v8 W=0.42 L=0.15
Xn_726_n2 n_726 n_205 vss vss sky130_fd_pr__nfet_01v8 W=0.42 L=0.15
Xn_725_p1 n_725 n_726 n_725_x vdd sky130_fd_pr__pfet_01v8 W=1.4 L=0.15
Xn_725_p2 n_725_x env2 vdd vdd sky130_fd_pr__pfet_01v8 W=1.4 L=0.15
Xn_725_n1 n_725 n_726 vss vss sky130_fd_pr__nfet_01v8 W=0.42 L=0.15
Xn_725_n2 n_725 env2 vss vss sky130_fd_pr__nfet_01v8 W=0.42 L=0.15
Xenv2_p1 env2 n_724 env2_x vdd sky130_fd_pr__pfet_01v8 W=1.4 L=0.15
Xenv2_p2 env2_x n_725 vdd vdd sky130_fd_pr__pfet_01v8 W=1.4 L=0.15
Xenv2_n1 env2 n_724 vss vss sky130_fd_pr__nfet_01v8 W=0.42 L=0.15
Xenv2_n2 env2 n_725 vss vss sky130_fd_pr__nfet_01v8 W=0.42 L=0.15
Xn_727_n n_727 env2 vss vss sky130_fd_pr__nfet_01v8 W=0.42 L=0.15
Xn_727_p n_727 env2 vdd vdd sky130_fd_pr__pfet_01v8 W=0.7 L=0.15
Xn_728_p1 n_728 env2 vdd vdd sky130_fd_pr__pfet_01v8 W=0.7 L=0.15
Xn_728_p2 n_728 n_594 vdd vdd sky130_fd_pr__pfet_01v8 W=0.7 L=0.15
Xn_728_n1 n_728 env2 n_728_x vss sky130_fd_pr__nfet_01v8 W=0.84 L=0.15
Xn_728_n2 n_728_x n_594 vss vss sky130_fd_pr__nfet_01v8 W=0.84 L=0.15
Xn_729_n n_729 n_728 vss vss sky130_fd_pr__nfet_01v8 W=0.42 L=0.15
Xn_729_p n_729 n_728 vdd vdd sky130_fd_pr__pfet_01v8 W=0.7 L=0.15
Xn_730_p1 n_730 n_727 vdd vdd sky130_fd_pr__pfet_01v8 W=0.7 L=0.15
Xn_730_p2 n_730 n_594 vdd vdd sky130_fd_pr__pfet_01v8 W=0.7 L=0.15
Xn_730_n1 n_730 n_727 n_730_x vss sky130_fd_pr__nfet_01v8 W=0.84 L=0.15
Xn_730_n2 n_730_x n_594 vss vss sky130_fd_pr__nfet_01v8 W=0.84 L=0.15
Xn_731_n n_731 n_730 vss vss sky130_fd_pr__nfet_01v8 W=0.42 L=0.15
Xn_731_p n_731 n_730 vdd vdd sky130_fd_pr__pfet_01v8 W=0.7 L=0.15
Xn_732_p1 n_732 n_731 n_732_x vdd sky130_fd_pr__pfet_01v8 W=1.4 L=0.15
Xn_732_p2 n_732_x n_4 vdd vdd sky130_fd_pr__pfet_01v8 W=1.4 L=0.15
Xn_732_n1 n_732 n_731 vss vss sky130_fd_pr__nfet_01v8 W=0.42 L=0.15
Xn_732_n2 n_732 n_4 vss vss sky130_fd_pr__nfet_01v8 W=0.42 L=0.15
Xn_733_n n_733 n_732 vss vss sky130_fd_pr__nfet_01v8 W=0.42 L=0.15
Xn_733_p n_733 n_732 vdd vdd sky130_fd_pr__pfet_01v8 W=0.7 L=0.15
Xn_735_p1 n_735 n_729 n_735_x vdd sky130_fd_pr__pfet_01v8 W=1.4 L=0.15
Xn_735_p2 n_735_x n_734 vdd vdd sky130_fd_pr__pfet_01v8 W=1.4 L=0.15
Xn_735_n1 n_735 n_729 vss vss sky130_fd_pr__nfet_01v8 W=0.42 L=0.15
Xn_735_n2 n_735 n_734 vss vss sky130_fd_pr__nfet_01v8 W=0.42 L=0.15
Xn_734_p1 n_734 n_733 n_734_x vdd sky130_fd_pr__pfet_01v8 W=1.4 L=0.15
Xn_734_p2 n_734_x n_735 vdd vdd sky130_fd_pr__pfet_01v8 W=1.4 L=0.15
Xn_734_n1 n_734 n_733 vss vss sky130_fd_pr__nfet_01v8 W=0.42 L=0.15
Xn_734_n2 n_734 n_735 vss vss sky130_fd_pr__nfet_01v8 W=0.42 L=0.15
Xn_736_n n_736 n_734 vss vss sky130_fd_pr__nfet_01v8 W=0.42 L=0.15
Xn_736_p n_736 n_734 vdd vdd sky130_fd_pr__pfet_01v8 W=0.7 L=0.15
Xn_737_n n_737 n_736 vss vss sky130_fd_pr__nfet_01v8 W=0.42 L=0.15
Xn_737_p n_737 n_736 vdd vdd sky130_fd_pr__pfet_01v8 W=0.7 L=0.15
Xn_738_n n_738 x_neg2 vss vss sky130_fd_pr__nfet_01v8 W=0.42 L=0.15
Xn_738_p n_738 x_neg2 vdd vdd sky130_fd_pr__pfet_01v8 W=0.7 L=0.15
Xn_739_p1 n_739 n_737 vdd vdd sky130_fd_pr__pfet_01v8 W=0.7 L=0.15
Xn_739_p2 n_739 n_738 vdd vdd sky130_fd_pr__pfet_01v8 W=0.7 L=0.15
Xn_739_n1 n_739 n_737 n_739_x vss sky130_fd_pr__nfet_01v8 W=0.84 L=0.15
Xn_739_n2 n_739_x n_738 vss vss sky130_fd_pr__nfet_01v8 W=0.84 L=0.15
Xxin_p_r2_n xin_p_r2 n_739 vss vss sky130_fd_pr__nfet_01v8 W=0.42 L=0.15
Xxin_p_r2_p xin_p_r2 n_739 vdd vdd sky130_fd_pr__pfet_01v8 W=0.7 L=0.15
Xn_740_p1 n_740 n_737 vdd vdd sky130_fd_pr__pfet_01v8 W=0.7 L=0.15
Xn_740_p2 n_740 x_neg2 vdd vdd sky130_fd_pr__pfet_01v8 W=0.7 L=0.15
Xn_740_n1 n_740 n_737 n_740_x vss sky130_fd_pr__nfet_01v8 W=0.84 L=0.15
Xn_740_n2 n_740_x x_neg2 vss vss sky130_fd_pr__nfet_01v8 W=0.84 L=0.15
Xxin_n_r2_n xin_n_r2 n_740 vss vss sky130_fd_pr__nfet_01v8 W=0.42 L=0.15
Xxin_n_r2_p xin_n_r2 n_740 vdd vdd sky130_fd_pr__pfet_01v8 W=0.7 L=0.15
Xn_741_p1 n_741 n_737 vdd vdd sky130_fd_pr__pfet_01v8 W=0.7 L=0.15
Xn_741_p2 n_741 lora_en vdd vdd sky130_fd_pr__pfet_01v8 W=0.7 L=0.15
Xn_741_n1 n_741 n_737 n_741_x vss sky130_fd_pr__nfet_01v8 W=0.84 L=0.15
Xn_741_n2 n_741_x lora_en vss vss sky130_fd_pr__nfet_01v8 W=0.84 L=0.15
Xxrd_en2_n xrd_en2 n_741 vss vss sky130_fd_pr__nfet_01v8 W=0.42 L=0.15
Xxrd_en2_p xrd_en2 n_741 vdd vdd sky130_fd_pr__pfet_01v8 W=0.7 L=0.15
Xn_742_p1 n_742 n_587 vdd vdd sky130_fd_pr__pfet_01v8 W=0.7 L=0.15
Xn_742_p2 n_742 x_mag12 vdd vdd sky130_fd_pr__pfet_01v8 W=0.7 L=0.15
Xn_742_n1 n_742 n_587 n_742_x vss sky130_fd_pr__nfet_01v8 W=0.84 L=0.15
Xn_742_n2 n_742_x x_mag12 vss vss sky130_fd_pr__nfet_01v8 W=0.84 L=0.15
Xn_743_n n_743 n_742 vss vss sky130_fd_pr__nfet_01v8 W=0.42 L=0.15
Xn_743_p n_743 n_742 vdd vdd sky130_fd_pr__pfet_01v8 W=0.7 L=0.15
Xn_744_p1 n_744 n_588 vdd vdd sky130_fd_pr__pfet_01v8 W=0.7 L=0.15
Xn_744_p2 n_744 x_mag13 vdd vdd sky130_fd_pr__pfet_01v8 W=0.7 L=0.15
Xn_744_n1 n_744 n_588 n_744_x vss sky130_fd_pr__nfet_01v8 W=0.84 L=0.15
Xn_744_n2 n_744_x x_mag13 vss vss sky130_fd_pr__nfet_01v8 W=0.84 L=0.15
Xn_745_p1 n_745 n_588 n_745_x vdd sky130_fd_pr__pfet_01v8 W=1.4 L=0.15
Xn_745_p2 n_745_x x_mag13 vdd vdd sky130_fd_pr__pfet_01v8 W=1.4 L=0.15
Xn_745_n1 n_745 n_588 vss vss sky130_fd_pr__nfet_01v8 W=0.42 L=0.15
Xn_745_n2 n_745 x_mag13 vss vss sky130_fd_pr__nfet_01v8 W=0.42 L=0.15
Xn_746_n n_746 n_745 vss vss sky130_fd_pr__nfet_01v8 W=0.42 L=0.15
Xn_746_p n_746 n_745 vdd vdd sky130_fd_pr__pfet_01v8 W=0.7 L=0.15
Xn_747_p1 n_747 n_743 vdd vdd sky130_fd_pr__pfet_01v8 W=0.7 L=0.15
Xn_747_p2 n_747 n_746 vdd vdd sky130_fd_pr__pfet_01v8 W=0.7 L=0.15
Xn_747_n1 n_747 n_743 n_747_x vss sky130_fd_pr__nfet_01v8 W=0.84 L=0.15
Xn_747_n2 n_747_x n_746 vss vss sky130_fd_pr__nfet_01v8 W=0.84 L=0.15
Xn_748_p1 n_748 n_744 vdd vdd sky130_fd_pr__pfet_01v8 W=0.7 L=0.15
Xn_748_p2 n_748 n_747 vdd vdd sky130_fd_pr__pfet_01v8 W=0.7 L=0.15
Xn_748_n1 n_748 n_744 n_748_x vss sky130_fd_pr__nfet_01v8 W=0.84 L=0.15
Xn_748_n2 n_748_x n_747 vss vss sky130_fd_pr__nfet_01v8 W=0.84 L=0.15
Xn_749_p1 n_749 n_589 vdd vdd sky130_fd_pr__pfet_01v8 W=0.7 L=0.15
Xn_749_p2 n_749 x_mag14 vdd vdd sky130_fd_pr__pfet_01v8 W=0.7 L=0.15
Xn_749_n1 n_749 n_589 n_749_x vss sky130_fd_pr__nfet_01v8 W=0.84 L=0.15
Xn_749_n2 n_749_x x_mag14 vss vss sky130_fd_pr__nfet_01v8 W=0.84 L=0.15
Xn_750_p1 n_750 n_589 n_750_x vdd sky130_fd_pr__pfet_01v8 W=1.4 L=0.15
Xn_750_p2 n_750_x x_mag14 vdd vdd sky130_fd_pr__pfet_01v8 W=1.4 L=0.15
Xn_750_n1 n_750 n_589 vss vss sky130_fd_pr__nfet_01v8 W=0.42 L=0.15
Xn_750_n2 n_750 x_mag14 vss vss sky130_fd_pr__nfet_01v8 W=0.42 L=0.15
Xn_751_n n_751 n_750 vss vss sky130_fd_pr__nfet_01v8 W=0.42 L=0.15
Xn_751_p n_751 n_750 vdd vdd sky130_fd_pr__pfet_01v8 W=0.7 L=0.15
Xn_752_p1 n_752 n_748 vdd vdd sky130_fd_pr__pfet_01v8 W=0.7 L=0.15
Xn_752_p2 n_752 n_751 vdd vdd sky130_fd_pr__pfet_01v8 W=0.7 L=0.15
Xn_752_n1 n_752 n_748 n_752_x vss sky130_fd_pr__nfet_01v8 W=0.84 L=0.15
Xn_752_n2 n_752_x n_751 vss vss sky130_fd_pr__nfet_01v8 W=0.84 L=0.15
Xn_753_p1 n_753 n_749 vdd vdd sky130_fd_pr__pfet_01v8 W=0.7 L=0.15
Xn_753_p2 n_753 n_752 vdd vdd sky130_fd_pr__pfet_01v8 W=0.7 L=0.15
Xn_753_n1 n_753 n_749 n_753_x vss sky130_fd_pr__nfet_01v8 W=0.84 L=0.15
Xn_753_n2 n_753_x n_752 vss vss sky130_fd_pr__nfet_01v8 W=0.84 L=0.15
Xn_754_p1 n_754 n_590 vdd vdd sky130_fd_pr__pfet_01v8 W=0.7 L=0.15
Xn_754_p2 n_754 x_mag15 vdd vdd sky130_fd_pr__pfet_01v8 W=0.7 L=0.15
Xn_754_n1 n_754 n_590 n_754_x vss sky130_fd_pr__nfet_01v8 W=0.84 L=0.15
Xn_754_n2 n_754_x x_mag15 vss vss sky130_fd_pr__nfet_01v8 W=0.84 L=0.15
Xn_755_p1 n_755 n_590 n_755_x vdd sky130_fd_pr__pfet_01v8 W=1.4 L=0.15
Xn_755_p2 n_755_x x_mag15 vdd vdd sky130_fd_pr__pfet_01v8 W=1.4 L=0.15
Xn_755_n1 n_755 n_590 vss vss sky130_fd_pr__nfet_01v8 W=0.42 L=0.15
Xn_755_n2 n_755 x_mag15 vss vss sky130_fd_pr__nfet_01v8 W=0.42 L=0.15
Xn_756_n n_756 n_755 vss vss sky130_fd_pr__nfet_01v8 W=0.42 L=0.15
Xn_756_p n_756 n_755 vdd vdd sky130_fd_pr__pfet_01v8 W=0.7 L=0.15
Xn_757_p1 n_757 n_753 vdd vdd sky130_fd_pr__pfet_01v8 W=0.7 L=0.15
Xn_757_p2 n_757 n_756 vdd vdd sky130_fd_pr__pfet_01v8 W=0.7 L=0.15
Xn_757_n1 n_757 n_753 n_757_x vss sky130_fd_pr__nfet_01v8 W=0.84 L=0.15
Xn_757_n2 n_757_x n_756 vss vss sky130_fd_pr__nfet_01v8 W=0.84 L=0.15
Xn_758_p1 n_758 n_754 vdd vdd sky130_fd_pr__pfet_01v8 W=0.7 L=0.15
Xn_758_p2 n_758 n_757 vdd vdd sky130_fd_pr__pfet_01v8 W=0.7 L=0.15
Xn_758_n1 n_758 n_754 n_758_x vss sky130_fd_pr__nfet_01v8 W=0.84 L=0.15
Xn_758_n2 n_758_x n_757 vss vss sky130_fd_pr__nfet_01v8 W=0.84 L=0.15
Xn_759_p1 n_759 n_403 vdd vdd sky130_fd_pr__pfet_01v8 W=0.7 L=0.15
Xn_759_p2 n_759 n_758 vdd vdd sky130_fd_pr__pfet_01v8 W=0.7 L=0.15
Xn_759_n1 n_759 n_403 n_759_x vss sky130_fd_pr__nfet_01v8 W=0.84 L=0.15
Xn_759_n2 n_759_x n_758 vss vss sky130_fd_pr__nfet_01v8 W=0.84 L=0.15
Xn_760_n n_760 n_759 vss vss sky130_fd_pr__nfet_01v8 W=0.42 L=0.15
Xn_760_p n_760 n_759 vdd vdd sky130_fd_pr__pfet_01v8 W=0.7 L=0.15
Xn_761_p1 n_761 n_440 vdd vdd sky130_fd_pr__pfet_01v8 W=0.7 L=0.15
Xn_761_p2 n_761 n_760 vdd vdd sky130_fd_pr__pfet_01v8 W=0.7 L=0.15
Xn_761_n1 n_761 n_440 n_761_x vss sky130_fd_pr__nfet_01v8 W=0.84 L=0.15
Xn_761_n2 n_761_x n_760 vss vss sky130_fd_pr__nfet_01v8 W=0.84 L=0.15
Xn_762_p1 n_762 n_591 vdd vdd sky130_fd_pr__pfet_01v8 W=0.7 L=0.15
Xn_762_p2 n_762 env3 vdd vdd sky130_fd_pr__pfet_01v8 W=0.7 L=0.15
Xn_762_n1 n_762 n_591 n_762_x vss sky130_fd_pr__nfet_01v8 W=0.84 L=0.15
Xn_762_n2 n_762_x env3 vss vss sky130_fd_pr__nfet_01v8 W=0.84 L=0.15
Xn_763_p1 n_763 n_761 vdd vdd sky130_fd_pr__pfet_01v8 W=0.7 L=0.15
Xn_763_p2 n_763 n_762 vdd vdd sky130_fd_pr__pfet_01v8 W=0.7 L=0.15
Xn_763_n1 n_763 n_761 n_763_x vss sky130_fd_pr__nfet_01v8 W=0.84 L=0.15
Xn_763_n2 n_763_x n_762 vss vss sky130_fd_pr__nfet_01v8 W=0.84 L=0.15
Xn_764_n n_764 n_763 vss vss sky130_fd_pr__nfet_01v8 W=0.42 L=0.15
Xn_764_p n_764 n_763 vdd vdd sky130_fd_pr__pfet_01v8 W=0.7 L=0.15
Xn_765_p1 n_765 n_763 n_765_x vdd sky130_fd_pr__pfet_01v8 W=1.4 L=0.15
Xn_765_p2 n_765_x n_202 vdd vdd sky130_fd_pr__pfet_01v8 W=1.4 L=0.15
Xn_765_n1 n_765 n_763 vss vss sky130_fd_pr__nfet_01v8 W=0.42 L=0.15
Xn_765_n2 n_765 n_202 vss vss sky130_fd_pr__nfet_01v8 W=0.42 L=0.15
Xn_766_p1 n_766 n_765 n_766_x vdd sky130_fd_pr__pfet_01v8 W=1.4 L=0.15
Xn_766_p2 n_766_x n_4 vdd vdd sky130_fd_pr__pfet_01v8 W=1.4 L=0.15
Xn_766_n1 n_766 n_765 vss vss sky130_fd_pr__nfet_01v8 W=0.42 L=0.15
Xn_766_n2 n_766 n_4 vss vss sky130_fd_pr__nfet_01v8 W=0.42 L=0.15
Xn_767_n n_767 n_766 vss vss sky130_fd_pr__nfet_01v8 W=0.42 L=0.15
Xn_767_p n_767 n_766 vdd vdd sky130_fd_pr__pfet_01v8 W=0.7 L=0.15
Xn_770_p1 n_770 n_764 n_770_x vdd sky130_fd_pr__pfet_01v8 W=1.4 L=0.15
Xn_770_p2 n_770_x n_202 vdd vdd sky130_fd_pr__pfet_01v8 W=1.4 L=0.15
Xn_770_n1 n_770 n_764 vss vss sky130_fd_pr__nfet_01v8 W=0.42 L=0.15
Xn_770_n2 n_770 n_202 vss vss sky130_fd_pr__nfet_01v8 W=0.42 L=0.15
Xn_769_p1 n_769 n_770 n_769_x vdd sky130_fd_pr__pfet_01v8 W=1.4 L=0.15
Xn_769_p2 n_769_x n_768 vdd vdd sky130_fd_pr__pfet_01v8 W=1.4 L=0.15
Xn_769_n1 n_769 n_770 vss vss sky130_fd_pr__nfet_01v8 W=0.42 L=0.15
Xn_769_n2 n_769 n_768 vss vss sky130_fd_pr__nfet_01v8 W=0.42 L=0.15
Xn_768_p1 n_768 n_767 n_768_x vdd sky130_fd_pr__pfet_01v8 W=1.4 L=0.15
Xn_768_p2 n_768_x n_769 vdd vdd sky130_fd_pr__pfet_01v8 W=1.4 L=0.15
Xn_768_n1 n_768 n_767 vss vss sky130_fd_pr__nfet_01v8 W=0.42 L=0.15
Xn_768_n2 n_768 n_769 vss vss sky130_fd_pr__nfet_01v8 W=0.42 L=0.15
Xn_771_p1 n_771 n_768 n_771_x vdd sky130_fd_pr__pfet_01v8 W=1.4 L=0.15
Xn_771_p2 n_771_x n_205 vdd vdd sky130_fd_pr__pfet_01v8 W=1.4 L=0.15
Xn_771_n1 n_771 n_768 vss vss sky130_fd_pr__nfet_01v8 W=0.42 L=0.15
Xn_771_n2 n_771 n_205 vss vss sky130_fd_pr__nfet_01v8 W=0.42 L=0.15
Xn_772_p1 n_772 n_771 n_772_x vdd sky130_fd_pr__pfet_01v8 W=1.4 L=0.15
Xn_772_p2 n_772_x n_4 vdd vdd sky130_fd_pr__pfet_01v8 W=1.4 L=0.15
Xn_772_n1 n_772 n_771 vss vss sky130_fd_pr__nfet_01v8 W=0.42 L=0.15
Xn_772_n2 n_772 n_4 vss vss sky130_fd_pr__nfet_01v8 W=0.42 L=0.15
Xn_773_n n_773 n_772 vss vss sky130_fd_pr__nfet_01v8 W=0.42 L=0.15
Xn_773_p n_773 n_772 vdd vdd sky130_fd_pr__pfet_01v8 W=0.7 L=0.15
Xn_775_p1 n_775 n_769 n_775_x vdd sky130_fd_pr__pfet_01v8 W=1.4 L=0.15
Xn_775_p2 n_775_x n_205 vdd vdd sky130_fd_pr__pfet_01v8 W=1.4 L=0.15
Xn_775_n1 n_775 n_769 vss vss sky130_fd_pr__nfet_01v8 W=0.42 L=0.15
Xn_775_n2 n_775 n_205 vss vss sky130_fd_pr__nfet_01v8 W=0.42 L=0.15
Xn_774_p1 n_774 n_775 n_774_x vdd sky130_fd_pr__pfet_01v8 W=1.4 L=0.15
Xn_774_p2 n_774_x env3 vdd vdd sky130_fd_pr__pfet_01v8 W=1.4 L=0.15
Xn_774_n1 n_774 n_775 vss vss sky130_fd_pr__nfet_01v8 W=0.42 L=0.15
Xn_774_n2 n_774 env3 vss vss sky130_fd_pr__nfet_01v8 W=0.42 L=0.15
Xenv3_p1 env3 n_773 env3_x vdd sky130_fd_pr__pfet_01v8 W=1.4 L=0.15
Xenv3_p2 env3_x n_774 vdd vdd sky130_fd_pr__pfet_01v8 W=1.4 L=0.15
Xenv3_n1 env3 n_773 vss vss sky130_fd_pr__nfet_01v8 W=0.42 L=0.15
Xenv3_n2 env3 n_774 vss vss sky130_fd_pr__nfet_01v8 W=0.42 L=0.15
Xn_776_n n_776 env3 vss vss sky130_fd_pr__nfet_01v8 W=0.42 L=0.15
Xn_776_p n_776 env3 vdd vdd sky130_fd_pr__pfet_01v8 W=0.7 L=0.15
Xn_777_p1 n_777 env3 vdd vdd sky130_fd_pr__pfet_01v8 W=0.7 L=0.15
Xn_777_p2 n_777 n_594 vdd vdd sky130_fd_pr__pfet_01v8 W=0.7 L=0.15
Xn_777_n1 n_777 env3 n_777_x vss sky130_fd_pr__nfet_01v8 W=0.84 L=0.15
Xn_777_n2 n_777_x n_594 vss vss sky130_fd_pr__nfet_01v8 W=0.84 L=0.15
Xn_778_n n_778 n_777 vss vss sky130_fd_pr__nfet_01v8 W=0.42 L=0.15
Xn_778_p n_778 n_777 vdd vdd sky130_fd_pr__pfet_01v8 W=0.7 L=0.15
Xn_779_p1 n_779 n_776 vdd vdd sky130_fd_pr__pfet_01v8 W=0.7 L=0.15
Xn_779_p2 n_779 n_594 vdd vdd sky130_fd_pr__pfet_01v8 W=0.7 L=0.15
Xn_779_n1 n_779 n_776 n_779_x vss sky130_fd_pr__nfet_01v8 W=0.84 L=0.15
Xn_779_n2 n_779_x n_594 vss vss sky130_fd_pr__nfet_01v8 W=0.84 L=0.15
Xn_780_n n_780 n_779 vss vss sky130_fd_pr__nfet_01v8 W=0.42 L=0.15
Xn_780_p n_780 n_779 vdd vdd sky130_fd_pr__pfet_01v8 W=0.7 L=0.15
Xn_781_p1 n_781 n_780 n_781_x vdd sky130_fd_pr__pfet_01v8 W=1.4 L=0.15
Xn_781_p2 n_781_x n_4 vdd vdd sky130_fd_pr__pfet_01v8 W=1.4 L=0.15
Xn_781_n1 n_781 n_780 vss vss sky130_fd_pr__nfet_01v8 W=0.42 L=0.15
Xn_781_n2 n_781 n_4 vss vss sky130_fd_pr__nfet_01v8 W=0.42 L=0.15
Xn_782_n n_782 n_781 vss vss sky130_fd_pr__nfet_01v8 W=0.42 L=0.15
Xn_782_p n_782 n_781 vdd vdd sky130_fd_pr__pfet_01v8 W=0.7 L=0.15
Xn_784_p1 n_784 n_778 n_784_x vdd sky130_fd_pr__pfet_01v8 W=1.4 L=0.15
Xn_784_p2 n_784_x n_783 vdd vdd sky130_fd_pr__pfet_01v8 W=1.4 L=0.15
Xn_784_n1 n_784 n_778 vss vss sky130_fd_pr__nfet_01v8 W=0.42 L=0.15
Xn_784_n2 n_784 n_783 vss vss sky130_fd_pr__nfet_01v8 W=0.42 L=0.15
Xn_783_p1 n_783 n_782 n_783_x vdd sky130_fd_pr__pfet_01v8 W=1.4 L=0.15
Xn_783_p2 n_783_x n_784 vdd vdd sky130_fd_pr__pfet_01v8 W=1.4 L=0.15
Xn_783_n1 n_783 n_782 vss vss sky130_fd_pr__nfet_01v8 W=0.42 L=0.15
Xn_783_n2 n_783 n_784 vss vss sky130_fd_pr__nfet_01v8 W=0.42 L=0.15
Xn_785_n n_785 n_783 vss vss sky130_fd_pr__nfet_01v8 W=0.42 L=0.15
Xn_785_p n_785 n_783 vdd vdd sky130_fd_pr__pfet_01v8 W=0.7 L=0.15
Xn_786_n n_786 n_785 vss vss sky130_fd_pr__nfet_01v8 W=0.42 L=0.15
Xn_786_p n_786 n_785 vdd vdd sky130_fd_pr__pfet_01v8 W=0.7 L=0.15
Xn_787_n n_787 x_neg3 vss vss sky130_fd_pr__nfet_01v8 W=0.42 L=0.15
Xn_787_p n_787 x_neg3 vdd vdd sky130_fd_pr__pfet_01v8 W=0.7 L=0.15
Xn_788_p1 n_788 n_786 vdd vdd sky130_fd_pr__pfet_01v8 W=0.7 L=0.15
Xn_788_p2 n_788 n_787 vdd vdd sky130_fd_pr__pfet_01v8 W=0.7 L=0.15
Xn_788_n1 n_788 n_786 n_788_x vss sky130_fd_pr__nfet_01v8 W=0.84 L=0.15
Xn_788_n2 n_788_x n_787 vss vss sky130_fd_pr__nfet_01v8 W=0.84 L=0.15
Xxin_p_r3_n xin_p_r3 n_788 vss vss sky130_fd_pr__nfet_01v8 W=0.42 L=0.15
Xxin_p_r3_p xin_p_r3 n_788 vdd vdd sky130_fd_pr__pfet_01v8 W=0.7 L=0.15
Xn_789_p1 n_789 n_786 vdd vdd sky130_fd_pr__pfet_01v8 W=0.7 L=0.15
Xn_789_p2 n_789 x_neg3 vdd vdd sky130_fd_pr__pfet_01v8 W=0.7 L=0.15
Xn_789_n1 n_789 n_786 n_789_x vss sky130_fd_pr__nfet_01v8 W=0.84 L=0.15
Xn_789_n2 n_789_x x_neg3 vss vss sky130_fd_pr__nfet_01v8 W=0.84 L=0.15
Xxin_n_r3_n xin_n_r3 n_789 vss vss sky130_fd_pr__nfet_01v8 W=0.42 L=0.15
Xxin_n_r3_p xin_n_r3 n_789 vdd vdd sky130_fd_pr__pfet_01v8 W=0.7 L=0.15
Xn_790_p1 n_790 n_786 vdd vdd sky130_fd_pr__pfet_01v8 W=0.7 L=0.15
Xn_790_p2 n_790 lora_en vdd vdd sky130_fd_pr__pfet_01v8 W=0.7 L=0.15
Xn_790_n1 n_790 n_786 n_790_x vss sky130_fd_pr__nfet_01v8 W=0.84 L=0.15
Xn_790_n2 n_790_x lora_en vss vss sky130_fd_pr__nfet_01v8 W=0.84 L=0.15
Xxrd_en3_n xrd_en3 n_790 vss vss sky130_fd_pr__nfet_01v8 W=0.42 L=0.15
Xxrd_en3_p xrd_en3 n_790 vdd vdd sky130_fd_pr__pfet_01v8 W=0.7 L=0.15
Xn_791_p1 n_791 n_587 vdd vdd sky130_fd_pr__pfet_01v8 W=0.7 L=0.15
Xn_791_p2 n_791 x_mag16 vdd vdd sky130_fd_pr__pfet_01v8 W=0.7 L=0.15
Xn_791_n1 n_791 n_587 n_791_x vss sky130_fd_pr__nfet_01v8 W=0.84 L=0.15
Xn_791_n2 n_791_x x_mag16 vss vss sky130_fd_pr__nfet_01v8 W=0.84 L=0.15
Xn_792_n n_792 n_791 vss vss sky130_fd_pr__nfet_01v8 W=0.42 L=0.15
Xn_792_p n_792 n_791 vdd vdd sky130_fd_pr__pfet_01v8 W=0.7 L=0.15
Xn_793_p1 n_793 n_588 vdd vdd sky130_fd_pr__pfet_01v8 W=0.7 L=0.15
Xn_793_p2 n_793 x_mag17 vdd vdd sky130_fd_pr__pfet_01v8 W=0.7 L=0.15
Xn_793_n1 n_793 n_588 n_793_x vss sky130_fd_pr__nfet_01v8 W=0.84 L=0.15
Xn_793_n2 n_793_x x_mag17 vss vss sky130_fd_pr__nfet_01v8 W=0.84 L=0.15
Xn_794_p1 n_794 n_588 n_794_x vdd sky130_fd_pr__pfet_01v8 W=1.4 L=0.15
Xn_794_p2 n_794_x x_mag17 vdd vdd sky130_fd_pr__pfet_01v8 W=1.4 L=0.15
Xn_794_n1 n_794 n_588 vss vss sky130_fd_pr__nfet_01v8 W=0.42 L=0.15
Xn_794_n2 n_794 x_mag17 vss vss sky130_fd_pr__nfet_01v8 W=0.42 L=0.15
Xn_795_n n_795 n_794 vss vss sky130_fd_pr__nfet_01v8 W=0.42 L=0.15
Xn_795_p n_795 n_794 vdd vdd sky130_fd_pr__pfet_01v8 W=0.7 L=0.15
Xn_796_p1 n_796 n_792 vdd vdd sky130_fd_pr__pfet_01v8 W=0.7 L=0.15
Xn_796_p2 n_796 n_795 vdd vdd sky130_fd_pr__pfet_01v8 W=0.7 L=0.15
Xn_796_n1 n_796 n_792 n_796_x vss sky130_fd_pr__nfet_01v8 W=0.84 L=0.15
Xn_796_n2 n_796_x n_795 vss vss sky130_fd_pr__nfet_01v8 W=0.84 L=0.15
Xn_797_p1 n_797 n_793 vdd vdd sky130_fd_pr__pfet_01v8 W=0.7 L=0.15
Xn_797_p2 n_797 n_796 vdd vdd sky130_fd_pr__pfet_01v8 W=0.7 L=0.15
Xn_797_n1 n_797 n_793 n_797_x vss sky130_fd_pr__nfet_01v8 W=0.84 L=0.15
Xn_797_n2 n_797_x n_796 vss vss sky130_fd_pr__nfet_01v8 W=0.84 L=0.15
Xn_798_p1 n_798 n_589 vdd vdd sky130_fd_pr__pfet_01v8 W=0.7 L=0.15
Xn_798_p2 n_798 x_mag18 vdd vdd sky130_fd_pr__pfet_01v8 W=0.7 L=0.15
Xn_798_n1 n_798 n_589 n_798_x vss sky130_fd_pr__nfet_01v8 W=0.84 L=0.15
Xn_798_n2 n_798_x x_mag18 vss vss sky130_fd_pr__nfet_01v8 W=0.84 L=0.15
Xn_799_p1 n_799 n_589 n_799_x vdd sky130_fd_pr__pfet_01v8 W=1.4 L=0.15
Xn_799_p2 n_799_x x_mag18 vdd vdd sky130_fd_pr__pfet_01v8 W=1.4 L=0.15
Xn_799_n1 n_799 n_589 vss vss sky130_fd_pr__nfet_01v8 W=0.42 L=0.15
Xn_799_n2 n_799 x_mag18 vss vss sky130_fd_pr__nfet_01v8 W=0.42 L=0.15
Xn_800_n n_800 n_799 vss vss sky130_fd_pr__nfet_01v8 W=0.42 L=0.15
Xn_800_p n_800 n_799 vdd vdd sky130_fd_pr__pfet_01v8 W=0.7 L=0.15
Xn_801_p1 n_801 n_797 vdd vdd sky130_fd_pr__pfet_01v8 W=0.7 L=0.15
Xn_801_p2 n_801 n_800 vdd vdd sky130_fd_pr__pfet_01v8 W=0.7 L=0.15
Xn_801_n1 n_801 n_797 n_801_x vss sky130_fd_pr__nfet_01v8 W=0.84 L=0.15
Xn_801_n2 n_801_x n_800 vss vss sky130_fd_pr__nfet_01v8 W=0.84 L=0.15
Xn_802_p1 n_802 n_798 vdd vdd sky130_fd_pr__pfet_01v8 W=0.7 L=0.15
Xn_802_p2 n_802 n_801 vdd vdd sky130_fd_pr__pfet_01v8 W=0.7 L=0.15
Xn_802_n1 n_802 n_798 n_802_x vss sky130_fd_pr__nfet_01v8 W=0.84 L=0.15
Xn_802_n2 n_802_x n_801 vss vss sky130_fd_pr__nfet_01v8 W=0.84 L=0.15
Xn_803_p1 n_803 n_590 vdd vdd sky130_fd_pr__pfet_01v8 W=0.7 L=0.15
Xn_803_p2 n_803 x_mag19 vdd vdd sky130_fd_pr__pfet_01v8 W=0.7 L=0.15
Xn_803_n1 n_803 n_590 n_803_x vss sky130_fd_pr__nfet_01v8 W=0.84 L=0.15
Xn_803_n2 n_803_x x_mag19 vss vss sky130_fd_pr__nfet_01v8 W=0.84 L=0.15
Xn_804_p1 n_804 n_590 n_804_x vdd sky130_fd_pr__pfet_01v8 W=1.4 L=0.15
Xn_804_p2 n_804_x x_mag19 vdd vdd sky130_fd_pr__pfet_01v8 W=1.4 L=0.15
Xn_804_n1 n_804 n_590 vss vss sky130_fd_pr__nfet_01v8 W=0.42 L=0.15
Xn_804_n2 n_804 x_mag19 vss vss sky130_fd_pr__nfet_01v8 W=0.42 L=0.15
Xn_805_n n_805 n_804 vss vss sky130_fd_pr__nfet_01v8 W=0.42 L=0.15
Xn_805_p n_805 n_804 vdd vdd sky130_fd_pr__pfet_01v8 W=0.7 L=0.15
Xn_806_p1 n_806 n_802 vdd vdd sky130_fd_pr__pfet_01v8 W=0.7 L=0.15
Xn_806_p2 n_806 n_805 vdd vdd sky130_fd_pr__pfet_01v8 W=0.7 L=0.15
Xn_806_n1 n_806 n_802 n_806_x vss sky130_fd_pr__nfet_01v8 W=0.84 L=0.15
Xn_806_n2 n_806_x n_805 vss vss sky130_fd_pr__nfet_01v8 W=0.84 L=0.15
Xn_807_p1 n_807 n_803 vdd vdd sky130_fd_pr__pfet_01v8 W=0.7 L=0.15
Xn_807_p2 n_807 n_806 vdd vdd sky130_fd_pr__pfet_01v8 W=0.7 L=0.15
Xn_807_n1 n_807 n_803 n_807_x vss sky130_fd_pr__nfet_01v8 W=0.84 L=0.15
Xn_807_n2 n_807_x n_806 vss vss sky130_fd_pr__nfet_01v8 W=0.84 L=0.15
Xn_808_p1 n_808 n_403 vdd vdd sky130_fd_pr__pfet_01v8 W=0.7 L=0.15
Xn_808_p2 n_808 n_807 vdd vdd sky130_fd_pr__pfet_01v8 W=0.7 L=0.15
Xn_808_n1 n_808 n_403 n_808_x vss sky130_fd_pr__nfet_01v8 W=0.84 L=0.15
Xn_808_n2 n_808_x n_807 vss vss sky130_fd_pr__nfet_01v8 W=0.84 L=0.15
Xn_809_n n_809 n_808 vss vss sky130_fd_pr__nfet_01v8 W=0.42 L=0.15
Xn_809_p n_809 n_808 vdd vdd sky130_fd_pr__pfet_01v8 W=0.7 L=0.15
Xn_810_p1 n_810 n_440 vdd vdd sky130_fd_pr__pfet_01v8 W=0.7 L=0.15
Xn_810_p2 n_810 n_809 vdd vdd sky130_fd_pr__pfet_01v8 W=0.7 L=0.15
Xn_810_n1 n_810 n_440 n_810_x vss sky130_fd_pr__nfet_01v8 W=0.84 L=0.15
Xn_810_n2 n_810_x n_809 vss vss sky130_fd_pr__nfet_01v8 W=0.84 L=0.15
Xn_811_p1 n_811 n_591 vdd vdd sky130_fd_pr__pfet_01v8 W=0.7 L=0.15
Xn_811_p2 n_811 env4 vdd vdd sky130_fd_pr__pfet_01v8 W=0.7 L=0.15
Xn_811_n1 n_811 n_591 n_811_x vss sky130_fd_pr__nfet_01v8 W=0.84 L=0.15
Xn_811_n2 n_811_x env4 vss vss sky130_fd_pr__nfet_01v8 W=0.84 L=0.15
Xn_812_p1 n_812 n_810 vdd vdd sky130_fd_pr__pfet_01v8 W=0.7 L=0.15
Xn_812_p2 n_812 n_811 vdd vdd sky130_fd_pr__pfet_01v8 W=0.7 L=0.15
Xn_812_n1 n_812 n_810 n_812_x vss sky130_fd_pr__nfet_01v8 W=0.84 L=0.15
Xn_812_n2 n_812_x n_811 vss vss sky130_fd_pr__nfet_01v8 W=0.84 L=0.15
Xn_813_n n_813 n_812 vss vss sky130_fd_pr__nfet_01v8 W=0.42 L=0.15
Xn_813_p n_813 n_812 vdd vdd sky130_fd_pr__pfet_01v8 W=0.7 L=0.15
Xn_814_p1 n_814 n_812 n_814_x vdd sky130_fd_pr__pfet_01v8 W=1.4 L=0.15
Xn_814_p2 n_814_x n_202 vdd vdd sky130_fd_pr__pfet_01v8 W=1.4 L=0.15
Xn_814_n1 n_814 n_812 vss vss sky130_fd_pr__nfet_01v8 W=0.42 L=0.15
Xn_814_n2 n_814 n_202 vss vss sky130_fd_pr__nfet_01v8 W=0.42 L=0.15
Xn_815_p1 n_815 n_814 n_815_x vdd sky130_fd_pr__pfet_01v8 W=1.4 L=0.15
Xn_815_p2 n_815_x n_4 vdd vdd sky130_fd_pr__pfet_01v8 W=1.4 L=0.15
Xn_815_n1 n_815 n_814 vss vss sky130_fd_pr__nfet_01v8 W=0.42 L=0.15
Xn_815_n2 n_815 n_4 vss vss sky130_fd_pr__nfet_01v8 W=0.42 L=0.15
Xn_816_n n_816 n_815 vss vss sky130_fd_pr__nfet_01v8 W=0.42 L=0.15
Xn_816_p n_816 n_815 vdd vdd sky130_fd_pr__pfet_01v8 W=0.7 L=0.15
Xn_819_p1 n_819 n_813 n_819_x vdd sky130_fd_pr__pfet_01v8 W=1.4 L=0.15
Xn_819_p2 n_819_x n_202 vdd vdd sky130_fd_pr__pfet_01v8 W=1.4 L=0.15
Xn_819_n1 n_819 n_813 vss vss sky130_fd_pr__nfet_01v8 W=0.42 L=0.15
Xn_819_n2 n_819 n_202 vss vss sky130_fd_pr__nfet_01v8 W=0.42 L=0.15
Xn_818_p1 n_818 n_819 n_818_x vdd sky130_fd_pr__pfet_01v8 W=1.4 L=0.15
Xn_818_p2 n_818_x n_817 vdd vdd sky130_fd_pr__pfet_01v8 W=1.4 L=0.15
Xn_818_n1 n_818 n_819 vss vss sky130_fd_pr__nfet_01v8 W=0.42 L=0.15
Xn_818_n2 n_818 n_817 vss vss sky130_fd_pr__nfet_01v8 W=0.42 L=0.15
Xn_817_p1 n_817 n_816 n_817_x vdd sky130_fd_pr__pfet_01v8 W=1.4 L=0.15
Xn_817_p2 n_817_x n_818 vdd vdd sky130_fd_pr__pfet_01v8 W=1.4 L=0.15
Xn_817_n1 n_817 n_816 vss vss sky130_fd_pr__nfet_01v8 W=0.42 L=0.15
Xn_817_n2 n_817 n_818 vss vss sky130_fd_pr__nfet_01v8 W=0.42 L=0.15
Xn_820_p1 n_820 n_817 n_820_x vdd sky130_fd_pr__pfet_01v8 W=1.4 L=0.15
Xn_820_p2 n_820_x n_205 vdd vdd sky130_fd_pr__pfet_01v8 W=1.4 L=0.15
Xn_820_n1 n_820 n_817 vss vss sky130_fd_pr__nfet_01v8 W=0.42 L=0.15
Xn_820_n2 n_820 n_205 vss vss sky130_fd_pr__nfet_01v8 W=0.42 L=0.15
Xn_821_p1 n_821 n_820 n_821_x vdd sky130_fd_pr__pfet_01v8 W=1.4 L=0.15
Xn_821_p2 n_821_x n_4 vdd vdd sky130_fd_pr__pfet_01v8 W=1.4 L=0.15
Xn_821_n1 n_821 n_820 vss vss sky130_fd_pr__nfet_01v8 W=0.42 L=0.15
Xn_821_n2 n_821 n_4 vss vss sky130_fd_pr__nfet_01v8 W=0.42 L=0.15
Xn_822_n n_822 n_821 vss vss sky130_fd_pr__nfet_01v8 W=0.42 L=0.15
Xn_822_p n_822 n_821 vdd vdd sky130_fd_pr__pfet_01v8 W=0.7 L=0.15
Xn_824_p1 n_824 n_818 n_824_x vdd sky130_fd_pr__pfet_01v8 W=1.4 L=0.15
Xn_824_p2 n_824_x n_205 vdd vdd sky130_fd_pr__pfet_01v8 W=1.4 L=0.15
Xn_824_n1 n_824 n_818 vss vss sky130_fd_pr__nfet_01v8 W=0.42 L=0.15
Xn_824_n2 n_824 n_205 vss vss sky130_fd_pr__nfet_01v8 W=0.42 L=0.15
Xn_823_p1 n_823 n_824 n_823_x vdd sky130_fd_pr__pfet_01v8 W=1.4 L=0.15
Xn_823_p2 n_823_x env4 vdd vdd sky130_fd_pr__pfet_01v8 W=1.4 L=0.15
Xn_823_n1 n_823 n_824 vss vss sky130_fd_pr__nfet_01v8 W=0.42 L=0.15
Xn_823_n2 n_823 env4 vss vss sky130_fd_pr__nfet_01v8 W=0.42 L=0.15
Xenv4_p1 env4 n_822 env4_x vdd sky130_fd_pr__pfet_01v8 W=1.4 L=0.15
Xenv4_p2 env4_x n_823 vdd vdd sky130_fd_pr__pfet_01v8 W=1.4 L=0.15
Xenv4_n1 env4 n_822 vss vss sky130_fd_pr__nfet_01v8 W=0.42 L=0.15
Xenv4_n2 env4 n_823 vss vss sky130_fd_pr__nfet_01v8 W=0.42 L=0.15
Xn_825_n n_825 env4 vss vss sky130_fd_pr__nfet_01v8 W=0.42 L=0.15
Xn_825_p n_825 env4 vdd vdd sky130_fd_pr__pfet_01v8 W=0.7 L=0.15
Xn_826_p1 n_826 env4 vdd vdd sky130_fd_pr__pfet_01v8 W=0.7 L=0.15
Xn_826_p2 n_826 n_594 vdd vdd sky130_fd_pr__pfet_01v8 W=0.7 L=0.15
Xn_826_n1 n_826 env4 n_826_x vss sky130_fd_pr__nfet_01v8 W=0.84 L=0.15
Xn_826_n2 n_826_x n_594 vss vss sky130_fd_pr__nfet_01v8 W=0.84 L=0.15
Xn_827_n n_827 n_826 vss vss sky130_fd_pr__nfet_01v8 W=0.42 L=0.15
Xn_827_p n_827 n_826 vdd vdd sky130_fd_pr__pfet_01v8 W=0.7 L=0.15
Xn_828_p1 n_828 n_825 vdd vdd sky130_fd_pr__pfet_01v8 W=0.7 L=0.15
Xn_828_p2 n_828 n_594 vdd vdd sky130_fd_pr__pfet_01v8 W=0.7 L=0.15
Xn_828_n1 n_828 n_825 n_828_x vss sky130_fd_pr__nfet_01v8 W=0.84 L=0.15
Xn_828_n2 n_828_x n_594 vss vss sky130_fd_pr__nfet_01v8 W=0.84 L=0.15
Xn_829_n n_829 n_828 vss vss sky130_fd_pr__nfet_01v8 W=0.42 L=0.15
Xn_829_p n_829 n_828 vdd vdd sky130_fd_pr__pfet_01v8 W=0.7 L=0.15
Xn_830_p1 n_830 n_829 n_830_x vdd sky130_fd_pr__pfet_01v8 W=1.4 L=0.15
Xn_830_p2 n_830_x n_4 vdd vdd sky130_fd_pr__pfet_01v8 W=1.4 L=0.15
Xn_830_n1 n_830 n_829 vss vss sky130_fd_pr__nfet_01v8 W=0.42 L=0.15
Xn_830_n2 n_830 n_4 vss vss sky130_fd_pr__nfet_01v8 W=0.42 L=0.15
Xn_831_n n_831 n_830 vss vss sky130_fd_pr__nfet_01v8 W=0.42 L=0.15
Xn_831_p n_831 n_830 vdd vdd sky130_fd_pr__pfet_01v8 W=0.7 L=0.15
Xn_833_p1 n_833 n_827 n_833_x vdd sky130_fd_pr__pfet_01v8 W=1.4 L=0.15
Xn_833_p2 n_833_x n_832 vdd vdd sky130_fd_pr__pfet_01v8 W=1.4 L=0.15
Xn_833_n1 n_833 n_827 vss vss sky130_fd_pr__nfet_01v8 W=0.42 L=0.15
Xn_833_n2 n_833 n_832 vss vss sky130_fd_pr__nfet_01v8 W=0.42 L=0.15
Xn_832_p1 n_832 n_831 n_832_x vdd sky130_fd_pr__pfet_01v8 W=1.4 L=0.15
Xn_832_p2 n_832_x n_833 vdd vdd sky130_fd_pr__pfet_01v8 W=1.4 L=0.15
Xn_832_n1 n_832 n_831 vss vss sky130_fd_pr__nfet_01v8 W=0.42 L=0.15
Xn_832_n2 n_832 n_833 vss vss sky130_fd_pr__nfet_01v8 W=0.42 L=0.15
Xn_834_n n_834 n_832 vss vss sky130_fd_pr__nfet_01v8 W=0.42 L=0.15
Xn_834_p n_834 n_832 vdd vdd sky130_fd_pr__pfet_01v8 W=0.7 L=0.15
Xn_835_n n_835 n_834 vss vss sky130_fd_pr__nfet_01v8 W=0.42 L=0.15
Xn_835_p n_835 n_834 vdd vdd sky130_fd_pr__pfet_01v8 W=0.7 L=0.15
Xn_836_n n_836 x_neg4 vss vss sky130_fd_pr__nfet_01v8 W=0.42 L=0.15
Xn_836_p n_836 x_neg4 vdd vdd sky130_fd_pr__pfet_01v8 W=0.7 L=0.15
Xn_837_p1 n_837 n_835 vdd vdd sky130_fd_pr__pfet_01v8 W=0.7 L=0.15
Xn_837_p2 n_837 n_836 vdd vdd sky130_fd_pr__pfet_01v8 W=0.7 L=0.15
Xn_837_n1 n_837 n_835 n_837_x vss sky130_fd_pr__nfet_01v8 W=0.84 L=0.15
Xn_837_n2 n_837_x n_836 vss vss sky130_fd_pr__nfet_01v8 W=0.84 L=0.15
Xxin_p_r4_n xin_p_r4 n_837 vss vss sky130_fd_pr__nfet_01v8 W=0.42 L=0.15
Xxin_p_r4_p xin_p_r4 n_837 vdd vdd sky130_fd_pr__pfet_01v8 W=0.7 L=0.15
Xn_838_p1 n_838 n_835 vdd vdd sky130_fd_pr__pfet_01v8 W=0.7 L=0.15
Xn_838_p2 n_838 x_neg4 vdd vdd sky130_fd_pr__pfet_01v8 W=0.7 L=0.15
Xn_838_n1 n_838 n_835 n_838_x vss sky130_fd_pr__nfet_01v8 W=0.84 L=0.15
Xn_838_n2 n_838_x x_neg4 vss vss sky130_fd_pr__nfet_01v8 W=0.84 L=0.15
Xxin_n_r4_n xin_n_r4 n_838 vss vss sky130_fd_pr__nfet_01v8 W=0.42 L=0.15
Xxin_n_r4_p xin_n_r4 n_838 vdd vdd sky130_fd_pr__pfet_01v8 W=0.7 L=0.15
Xn_839_p1 n_839 n_835 vdd vdd sky130_fd_pr__pfet_01v8 W=0.7 L=0.15
Xn_839_p2 n_839 lora_en vdd vdd sky130_fd_pr__pfet_01v8 W=0.7 L=0.15
Xn_839_n1 n_839 n_835 n_839_x vss sky130_fd_pr__nfet_01v8 W=0.84 L=0.15
Xn_839_n2 n_839_x lora_en vss vss sky130_fd_pr__nfet_01v8 W=0.84 L=0.15
Xxrd_en4_n xrd_en4 n_839 vss vss sky130_fd_pr__nfet_01v8 W=0.42 L=0.15
Xxrd_en4_p xrd_en4 n_839 vdd vdd sky130_fd_pr__pfet_01v8 W=0.7 L=0.15
Xn_840_p1 n_840 n_587 vdd vdd sky130_fd_pr__pfet_01v8 W=0.7 L=0.15
Xn_840_p2 n_840 x_mag20 vdd vdd sky130_fd_pr__pfet_01v8 W=0.7 L=0.15
Xn_840_n1 n_840 n_587 n_840_x vss sky130_fd_pr__nfet_01v8 W=0.84 L=0.15
Xn_840_n2 n_840_x x_mag20 vss vss sky130_fd_pr__nfet_01v8 W=0.84 L=0.15
Xn_841_n n_841 n_840 vss vss sky130_fd_pr__nfet_01v8 W=0.42 L=0.15
Xn_841_p n_841 n_840 vdd vdd sky130_fd_pr__pfet_01v8 W=0.7 L=0.15
Xn_842_p1 n_842 n_588 vdd vdd sky130_fd_pr__pfet_01v8 W=0.7 L=0.15
Xn_842_p2 n_842 x_mag21 vdd vdd sky130_fd_pr__pfet_01v8 W=0.7 L=0.15
Xn_842_n1 n_842 n_588 n_842_x vss sky130_fd_pr__nfet_01v8 W=0.84 L=0.15
Xn_842_n2 n_842_x x_mag21 vss vss sky130_fd_pr__nfet_01v8 W=0.84 L=0.15
Xn_843_p1 n_843 n_588 n_843_x vdd sky130_fd_pr__pfet_01v8 W=1.4 L=0.15
Xn_843_p2 n_843_x x_mag21 vdd vdd sky130_fd_pr__pfet_01v8 W=1.4 L=0.15
Xn_843_n1 n_843 n_588 vss vss sky130_fd_pr__nfet_01v8 W=0.42 L=0.15
Xn_843_n2 n_843 x_mag21 vss vss sky130_fd_pr__nfet_01v8 W=0.42 L=0.15
Xn_844_n n_844 n_843 vss vss sky130_fd_pr__nfet_01v8 W=0.42 L=0.15
Xn_844_p n_844 n_843 vdd vdd sky130_fd_pr__pfet_01v8 W=0.7 L=0.15
Xn_845_p1 n_845 n_841 vdd vdd sky130_fd_pr__pfet_01v8 W=0.7 L=0.15
Xn_845_p2 n_845 n_844 vdd vdd sky130_fd_pr__pfet_01v8 W=0.7 L=0.15
Xn_845_n1 n_845 n_841 n_845_x vss sky130_fd_pr__nfet_01v8 W=0.84 L=0.15
Xn_845_n2 n_845_x n_844 vss vss sky130_fd_pr__nfet_01v8 W=0.84 L=0.15
Xn_846_p1 n_846 n_842 vdd vdd sky130_fd_pr__pfet_01v8 W=0.7 L=0.15
Xn_846_p2 n_846 n_845 vdd vdd sky130_fd_pr__pfet_01v8 W=0.7 L=0.15
Xn_846_n1 n_846 n_842 n_846_x vss sky130_fd_pr__nfet_01v8 W=0.84 L=0.15
Xn_846_n2 n_846_x n_845 vss vss sky130_fd_pr__nfet_01v8 W=0.84 L=0.15
Xn_847_p1 n_847 n_589 vdd vdd sky130_fd_pr__pfet_01v8 W=0.7 L=0.15
Xn_847_p2 n_847 x_mag22 vdd vdd sky130_fd_pr__pfet_01v8 W=0.7 L=0.15
Xn_847_n1 n_847 n_589 n_847_x vss sky130_fd_pr__nfet_01v8 W=0.84 L=0.15
Xn_847_n2 n_847_x x_mag22 vss vss sky130_fd_pr__nfet_01v8 W=0.84 L=0.15
Xn_848_p1 n_848 n_589 n_848_x vdd sky130_fd_pr__pfet_01v8 W=1.4 L=0.15
Xn_848_p2 n_848_x x_mag22 vdd vdd sky130_fd_pr__pfet_01v8 W=1.4 L=0.15
Xn_848_n1 n_848 n_589 vss vss sky130_fd_pr__nfet_01v8 W=0.42 L=0.15
Xn_848_n2 n_848 x_mag22 vss vss sky130_fd_pr__nfet_01v8 W=0.42 L=0.15
Xn_849_n n_849 n_848 vss vss sky130_fd_pr__nfet_01v8 W=0.42 L=0.15
Xn_849_p n_849 n_848 vdd vdd sky130_fd_pr__pfet_01v8 W=0.7 L=0.15
Xn_850_p1 n_850 n_846 vdd vdd sky130_fd_pr__pfet_01v8 W=0.7 L=0.15
Xn_850_p2 n_850 n_849 vdd vdd sky130_fd_pr__pfet_01v8 W=0.7 L=0.15
Xn_850_n1 n_850 n_846 n_850_x vss sky130_fd_pr__nfet_01v8 W=0.84 L=0.15
Xn_850_n2 n_850_x n_849 vss vss sky130_fd_pr__nfet_01v8 W=0.84 L=0.15
Xn_851_p1 n_851 n_847 vdd vdd sky130_fd_pr__pfet_01v8 W=0.7 L=0.15
Xn_851_p2 n_851 n_850 vdd vdd sky130_fd_pr__pfet_01v8 W=0.7 L=0.15
Xn_851_n1 n_851 n_847 n_851_x vss sky130_fd_pr__nfet_01v8 W=0.84 L=0.15
Xn_851_n2 n_851_x n_850 vss vss sky130_fd_pr__nfet_01v8 W=0.84 L=0.15
Xn_852_p1 n_852 n_590 vdd vdd sky130_fd_pr__pfet_01v8 W=0.7 L=0.15
Xn_852_p2 n_852 x_mag23 vdd vdd sky130_fd_pr__pfet_01v8 W=0.7 L=0.15
Xn_852_n1 n_852 n_590 n_852_x vss sky130_fd_pr__nfet_01v8 W=0.84 L=0.15
Xn_852_n2 n_852_x x_mag23 vss vss sky130_fd_pr__nfet_01v8 W=0.84 L=0.15
Xn_853_p1 n_853 n_590 n_853_x vdd sky130_fd_pr__pfet_01v8 W=1.4 L=0.15
Xn_853_p2 n_853_x x_mag23 vdd vdd sky130_fd_pr__pfet_01v8 W=1.4 L=0.15
Xn_853_n1 n_853 n_590 vss vss sky130_fd_pr__nfet_01v8 W=0.42 L=0.15
Xn_853_n2 n_853 x_mag23 vss vss sky130_fd_pr__nfet_01v8 W=0.42 L=0.15
Xn_854_n n_854 n_853 vss vss sky130_fd_pr__nfet_01v8 W=0.42 L=0.15
Xn_854_p n_854 n_853 vdd vdd sky130_fd_pr__pfet_01v8 W=0.7 L=0.15
Xn_855_p1 n_855 n_851 vdd vdd sky130_fd_pr__pfet_01v8 W=0.7 L=0.15
Xn_855_p2 n_855 n_854 vdd vdd sky130_fd_pr__pfet_01v8 W=0.7 L=0.15
Xn_855_n1 n_855 n_851 n_855_x vss sky130_fd_pr__nfet_01v8 W=0.84 L=0.15
Xn_855_n2 n_855_x n_854 vss vss sky130_fd_pr__nfet_01v8 W=0.84 L=0.15
Xn_856_p1 n_856 n_852 vdd vdd sky130_fd_pr__pfet_01v8 W=0.7 L=0.15
Xn_856_p2 n_856 n_855 vdd vdd sky130_fd_pr__pfet_01v8 W=0.7 L=0.15
Xn_856_n1 n_856 n_852 n_856_x vss sky130_fd_pr__nfet_01v8 W=0.84 L=0.15
Xn_856_n2 n_856_x n_855 vss vss sky130_fd_pr__nfet_01v8 W=0.84 L=0.15
Xn_857_p1 n_857 n_403 vdd vdd sky130_fd_pr__pfet_01v8 W=0.7 L=0.15
Xn_857_p2 n_857 n_856 vdd vdd sky130_fd_pr__pfet_01v8 W=0.7 L=0.15
Xn_857_n1 n_857 n_403 n_857_x vss sky130_fd_pr__nfet_01v8 W=0.84 L=0.15
Xn_857_n2 n_857_x n_856 vss vss sky130_fd_pr__nfet_01v8 W=0.84 L=0.15
Xn_858_n n_858 n_857 vss vss sky130_fd_pr__nfet_01v8 W=0.42 L=0.15
Xn_858_p n_858 n_857 vdd vdd sky130_fd_pr__pfet_01v8 W=0.7 L=0.15
Xn_859_p1 n_859 n_440 vdd vdd sky130_fd_pr__pfet_01v8 W=0.7 L=0.15
Xn_859_p2 n_859 n_858 vdd vdd sky130_fd_pr__pfet_01v8 W=0.7 L=0.15
Xn_859_n1 n_859 n_440 n_859_x vss sky130_fd_pr__nfet_01v8 W=0.84 L=0.15
Xn_859_n2 n_859_x n_858 vss vss sky130_fd_pr__nfet_01v8 W=0.84 L=0.15
Xn_860_p1 n_860 n_591 vdd vdd sky130_fd_pr__pfet_01v8 W=0.7 L=0.15
Xn_860_p2 n_860 env5 vdd vdd sky130_fd_pr__pfet_01v8 W=0.7 L=0.15
Xn_860_n1 n_860 n_591 n_860_x vss sky130_fd_pr__nfet_01v8 W=0.84 L=0.15
Xn_860_n2 n_860_x env5 vss vss sky130_fd_pr__nfet_01v8 W=0.84 L=0.15
Xn_861_p1 n_861 n_859 vdd vdd sky130_fd_pr__pfet_01v8 W=0.7 L=0.15
Xn_861_p2 n_861 n_860 vdd vdd sky130_fd_pr__pfet_01v8 W=0.7 L=0.15
Xn_861_n1 n_861 n_859 n_861_x vss sky130_fd_pr__nfet_01v8 W=0.84 L=0.15
Xn_861_n2 n_861_x n_860 vss vss sky130_fd_pr__nfet_01v8 W=0.84 L=0.15
Xn_862_n n_862 n_861 vss vss sky130_fd_pr__nfet_01v8 W=0.42 L=0.15
Xn_862_p n_862 n_861 vdd vdd sky130_fd_pr__pfet_01v8 W=0.7 L=0.15
Xn_863_p1 n_863 n_861 n_863_x vdd sky130_fd_pr__pfet_01v8 W=1.4 L=0.15
Xn_863_p2 n_863_x n_202 vdd vdd sky130_fd_pr__pfet_01v8 W=1.4 L=0.15
Xn_863_n1 n_863 n_861 vss vss sky130_fd_pr__nfet_01v8 W=0.42 L=0.15
Xn_863_n2 n_863 n_202 vss vss sky130_fd_pr__nfet_01v8 W=0.42 L=0.15
Xn_864_p1 n_864 n_863 n_864_x vdd sky130_fd_pr__pfet_01v8 W=1.4 L=0.15
Xn_864_p2 n_864_x n_4 vdd vdd sky130_fd_pr__pfet_01v8 W=1.4 L=0.15
Xn_864_n1 n_864 n_863 vss vss sky130_fd_pr__nfet_01v8 W=0.42 L=0.15
Xn_864_n2 n_864 n_4 vss vss sky130_fd_pr__nfet_01v8 W=0.42 L=0.15
Xn_865_n n_865 n_864 vss vss sky130_fd_pr__nfet_01v8 W=0.42 L=0.15
Xn_865_p n_865 n_864 vdd vdd sky130_fd_pr__pfet_01v8 W=0.7 L=0.15
Xn_868_p1 n_868 n_862 n_868_x vdd sky130_fd_pr__pfet_01v8 W=1.4 L=0.15
Xn_868_p2 n_868_x n_202 vdd vdd sky130_fd_pr__pfet_01v8 W=1.4 L=0.15
Xn_868_n1 n_868 n_862 vss vss sky130_fd_pr__nfet_01v8 W=0.42 L=0.15
Xn_868_n2 n_868 n_202 vss vss sky130_fd_pr__nfet_01v8 W=0.42 L=0.15
Xn_867_p1 n_867 n_868 n_867_x vdd sky130_fd_pr__pfet_01v8 W=1.4 L=0.15
Xn_867_p2 n_867_x n_866 vdd vdd sky130_fd_pr__pfet_01v8 W=1.4 L=0.15
Xn_867_n1 n_867 n_868 vss vss sky130_fd_pr__nfet_01v8 W=0.42 L=0.15
Xn_867_n2 n_867 n_866 vss vss sky130_fd_pr__nfet_01v8 W=0.42 L=0.15
Xn_866_p1 n_866 n_865 n_866_x vdd sky130_fd_pr__pfet_01v8 W=1.4 L=0.15
Xn_866_p2 n_866_x n_867 vdd vdd sky130_fd_pr__pfet_01v8 W=1.4 L=0.15
Xn_866_n1 n_866 n_865 vss vss sky130_fd_pr__nfet_01v8 W=0.42 L=0.15
Xn_866_n2 n_866 n_867 vss vss sky130_fd_pr__nfet_01v8 W=0.42 L=0.15
Xn_869_p1 n_869 n_866 n_869_x vdd sky130_fd_pr__pfet_01v8 W=1.4 L=0.15
Xn_869_p2 n_869_x n_205 vdd vdd sky130_fd_pr__pfet_01v8 W=1.4 L=0.15
Xn_869_n1 n_869 n_866 vss vss sky130_fd_pr__nfet_01v8 W=0.42 L=0.15
Xn_869_n2 n_869 n_205 vss vss sky130_fd_pr__nfet_01v8 W=0.42 L=0.15
Xn_870_p1 n_870 n_869 n_870_x vdd sky130_fd_pr__pfet_01v8 W=1.4 L=0.15
Xn_870_p2 n_870_x n_4 vdd vdd sky130_fd_pr__pfet_01v8 W=1.4 L=0.15
Xn_870_n1 n_870 n_869 vss vss sky130_fd_pr__nfet_01v8 W=0.42 L=0.15
Xn_870_n2 n_870 n_4 vss vss sky130_fd_pr__nfet_01v8 W=0.42 L=0.15
Xn_871_n n_871 n_870 vss vss sky130_fd_pr__nfet_01v8 W=0.42 L=0.15
Xn_871_p n_871 n_870 vdd vdd sky130_fd_pr__pfet_01v8 W=0.7 L=0.15
Xn_873_p1 n_873 n_867 n_873_x vdd sky130_fd_pr__pfet_01v8 W=1.4 L=0.15
Xn_873_p2 n_873_x n_205 vdd vdd sky130_fd_pr__pfet_01v8 W=1.4 L=0.15
Xn_873_n1 n_873 n_867 vss vss sky130_fd_pr__nfet_01v8 W=0.42 L=0.15
Xn_873_n2 n_873 n_205 vss vss sky130_fd_pr__nfet_01v8 W=0.42 L=0.15
Xn_872_p1 n_872 n_873 n_872_x vdd sky130_fd_pr__pfet_01v8 W=1.4 L=0.15
Xn_872_p2 n_872_x env5 vdd vdd sky130_fd_pr__pfet_01v8 W=1.4 L=0.15
Xn_872_n1 n_872 n_873 vss vss sky130_fd_pr__nfet_01v8 W=0.42 L=0.15
Xn_872_n2 n_872 env5 vss vss sky130_fd_pr__nfet_01v8 W=0.42 L=0.15
Xenv5_p1 env5 n_871 env5_x vdd sky130_fd_pr__pfet_01v8 W=1.4 L=0.15
Xenv5_p2 env5_x n_872 vdd vdd sky130_fd_pr__pfet_01v8 W=1.4 L=0.15
Xenv5_n1 env5 n_871 vss vss sky130_fd_pr__nfet_01v8 W=0.42 L=0.15
Xenv5_n2 env5 n_872 vss vss sky130_fd_pr__nfet_01v8 W=0.42 L=0.15
Xn_874_n n_874 env5 vss vss sky130_fd_pr__nfet_01v8 W=0.42 L=0.15
Xn_874_p n_874 env5 vdd vdd sky130_fd_pr__pfet_01v8 W=0.7 L=0.15
Xn_875_p1 n_875 env5 vdd vdd sky130_fd_pr__pfet_01v8 W=0.7 L=0.15
Xn_875_p2 n_875 n_594 vdd vdd sky130_fd_pr__pfet_01v8 W=0.7 L=0.15
Xn_875_n1 n_875 env5 n_875_x vss sky130_fd_pr__nfet_01v8 W=0.84 L=0.15
Xn_875_n2 n_875_x n_594 vss vss sky130_fd_pr__nfet_01v8 W=0.84 L=0.15
Xn_876_n n_876 n_875 vss vss sky130_fd_pr__nfet_01v8 W=0.42 L=0.15
Xn_876_p n_876 n_875 vdd vdd sky130_fd_pr__pfet_01v8 W=0.7 L=0.15
Xn_877_p1 n_877 n_874 vdd vdd sky130_fd_pr__pfet_01v8 W=0.7 L=0.15
Xn_877_p2 n_877 n_594 vdd vdd sky130_fd_pr__pfet_01v8 W=0.7 L=0.15
Xn_877_n1 n_877 n_874 n_877_x vss sky130_fd_pr__nfet_01v8 W=0.84 L=0.15
Xn_877_n2 n_877_x n_594 vss vss sky130_fd_pr__nfet_01v8 W=0.84 L=0.15
Xn_878_n n_878 n_877 vss vss sky130_fd_pr__nfet_01v8 W=0.42 L=0.15
Xn_878_p n_878 n_877 vdd vdd sky130_fd_pr__pfet_01v8 W=0.7 L=0.15
Xn_879_p1 n_879 n_878 n_879_x vdd sky130_fd_pr__pfet_01v8 W=1.4 L=0.15
Xn_879_p2 n_879_x n_4 vdd vdd sky130_fd_pr__pfet_01v8 W=1.4 L=0.15
Xn_879_n1 n_879 n_878 vss vss sky130_fd_pr__nfet_01v8 W=0.42 L=0.15
Xn_879_n2 n_879 n_4 vss vss sky130_fd_pr__nfet_01v8 W=0.42 L=0.15
Xn_880_n n_880 n_879 vss vss sky130_fd_pr__nfet_01v8 W=0.42 L=0.15
Xn_880_p n_880 n_879 vdd vdd sky130_fd_pr__pfet_01v8 W=0.7 L=0.15
Xn_882_p1 n_882 n_876 n_882_x vdd sky130_fd_pr__pfet_01v8 W=1.4 L=0.15
Xn_882_p2 n_882_x n_881 vdd vdd sky130_fd_pr__pfet_01v8 W=1.4 L=0.15
Xn_882_n1 n_882 n_876 vss vss sky130_fd_pr__nfet_01v8 W=0.42 L=0.15
Xn_882_n2 n_882 n_881 vss vss sky130_fd_pr__nfet_01v8 W=0.42 L=0.15
Xn_881_p1 n_881 n_880 n_881_x vdd sky130_fd_pr__pfet_01v8 W=1.4 L=0.15
Xn_881_p2 n_881_x n_882 vdd vdd sky130_fd_pr__pfet_01v8 W=1.4 L=0.15
Xn_881_n1 n_881 n_880 vss vss sky130_fd_pr__nfet_01v8 W=0.42 L=0.15
Xn_881_n2 n_881 n_882 vss vss sky130_fd_pr__nfet_01v8 W=0.42 L=0.15
Xn_883_n n_883 n_881 vss vss sky130_fd_pr__nfet_01v8 W=0.42 L=0.15
Xn_883_p n_883 n_881 vdd vdd sky130_fd_pr__pfet_01v8 W=0.7 L=0.15
Xn_884_n n_884 n_883 vss vss sky130_fd_pr__nfet_01v8 W=0.42 L=0.15
Xn_884_p n_884 n_883 vdd vdd sky130_fd_pr__pfet_01v8 W=0.7 L=0.15
Xn_885_n n_885 x_neg5 vss vss sky130_fd_pr__nfet_01v8 W=0.42 L=0.15
Xn_885_p n_885 x_neg5 vdd vdd sky130_fd_pr__pfet_01v8 W=0.7 L=0.15
Xn_886_p1 n_886 n_884 vdd vdd sky130_fd_pr__pfet_01v8 W=0.7 L=0.15
Xn_886_p2 n_886 n_885 vdd vdd sky130_fd_pr__pfet_01v8 W=0.7 L=0.15
Xn_886_n1 n_886 n_884 n_886_x vss sky130_fd_pr__nfet_01v8 W=0.84 L=0.15
Xn_886_n2 n_886_x n_885 vss vss sky130_fd_pr__nfet_01v8 W=0.84 L=0.15
Xxin_p_r5_n xin_p_r5 n_886 vss vss sky130_fd_pr__nfet_01v8 W=0.42 L=0.15
Xxin_p_r5_p xin_p_r5 n_886 vdd vdd sky130_fd_pr__pfet_01v8 W=0.7 L=0.15
Xn_887_p1 n_887 n_884 vdd vdd sky130_fd_pr__pfet_01v8 W=0.7 L=0.15
Xn_887_p2 n_887 x_neg5 vdd vdd sky130_fd_pr__pfet_01v8 W=0.7 L=0.15
Xn_887_n1 n_887 n_884 n_887_x vss sky130_fd_pr__nfet_01v8 W=0.84 L=0.15
Xn_887_n2 n_887_x x_neg5 vss vss sky130_fd_pr__nfet_01v8 W=0.84 L=0.15
Xxin_n_r5_n xin_n_r5 n_887 vss vss sky130_fd_pr__nfet_01v8 W=0.42 L=0.15
Xxin_n_r5_p xin_n_r5 n_887 vdd vdd sky130_fd_pr__pfet_01v8 W=0.7 L=0.15
Xn_888_p1 n_888 n_884 vdd vdd sky130_fd_pr__pfet_01v8 W=0.7 L=0.15
Xn_888_p2 n_888 lora_en vdd vdd sky130_fd_pr__pfet_01v8 W=0.7 L=0.15
Xn_888_n1 n_888 n_884 n_888_x vss sky130_fd_pr__nfet_01v8 W=0.84 L=0.15
Xn_888_n2 n_888_x lora_en vss vss sky130_fd_pr__nfet_01v8 W=0.84 L=0.15
Xxrd_en5_n xrd_en5 n_888 vss vss sky130_fd_pr__nfet_01v8 W=0.42 L=0.15
Xxrd_en5_p xrd_en5 n_888 vdd vdd sky130_fd_pr__pfet_01v8 W=0.7 L=0.15
Xn_889_p1 n_889 n_587 vdd vdd sky130_fd_pr__pfet_01v8 W=0.7 L=0.15
Xn_889_p2 n_889 x_mag24 vdd vdd sky130_fd_pr__pfet_01v8 W=0.7 L=0.15
Xn_889_n1 n_889 n_587 n_889_x vss sky130_fd_pr__nfet_01v8 W=0.84 L=0.15
Xn_889_n2 n_889_x x_mag24 vss vss sky130_fd_pr__nfet_01v8 W=0.84 L=0.15
Xn_890_n n_890 n_889 vss vss sky130_fd_pr__nfet_01v8 W=0.42 L=0.15
Xn_890_p n_890 n_889 vdd vdd sky130_fd_pr__pfet_01v8 W=0.7 L=0.15
Xn_891_p1 n_891 n_588 vdd vdd sky130_fd_pr__pfet_01v8 W=0.7 L=0.15
Xn_891_p2 n_891 x_mag25 vdd vdd sky130_fd_pr__pfet_01v8 W=0.7 L=0.15
Xn_891_n1 n_891 n_588 n_891_x vss sky130_fd_pr__nfet_01v8 W=0.84 L=0.15
Xn_891_n2 n_891_x x_mag25 vss vss sky130_fd_pr__nfet_01v8 W=0.84 L=0.15
Xn_892_p1 n_892 n_588 n_892_x vdd sky130_fd_pr__pfet_01v8 W=1.4 L=0.15
Xn_892_p2 n_892_x x_mag25 vdd vdd sky130_fd_pr__pfet_01v8 W=1.4 L=0.15
Xn_892_n1 n_892 n_588 vss vss sky130_fd_pr__nfet_01v8 W=0.42 L=0.15
Xn_892_n2 n_892 x_mag25 vss vss sky130_fd_pr__nfet_01v8 W=0.42 L=0.15
Xn_893_n n_893 n_892 vss vss sky130_fd_pr__nfet_01v8 W=0.42 L=0.15
Xn_893_p n_893 n_892 vdd vdd sky130_fd_pr__pfet_01v8 W=0.7 L=0.15
Xn_894_p1 n_894 n_890 vdd vdd sky130_fd_pr__pfet_01v8 W=0.7 L=0.15
Xn_894_p2 n_894 n_893 vdd vdd sky130_fd_pr__pfet_01v8 W=0.7 L=0.15
Xn_894_n1 n_894 n_890 n_894_x vss sky130_fd_pr__nfet_01v8 W=0.84 L=0.15
Xn_894_n2 n_894_x n_893 vss vss sky130_fd_pr__nfet_01v8 W=0.84 L=0.15
Xn_895_p1 n_895 n_891 vdd vdd sky130_fd_pr__pfet_01v8 W=0.7 L=0.15
Xn_895_p2 n_895 n_894 vdd vdd sky130_fd_pr__pfet_01v8 W=0.7 L=0.15
Xn_895_n1 n_895 n_891 n_895_x vss sky130_fd_pr__nfet_01v8 W=0.84 L=0.15
Xn_895_n2 n_895_x n_894 vss vss sky130_fd_pr__nfet_01v8 W=0.84 L=0.15
Xn_896_p1 n_896 n_589 vdd vdd sky130_fd_pr__pfet_01v8 W=0.7 L=0.15
Xn_896_p2 n_896 x_mag26 vdd vdd sky130_fd_pr__pfet_01v8 W=0.7 L=0.15
Xn_896_n1 n_896 n_589 n_896_x vss sky130_fd_pr__nfet_01v8 W=0.84 L=0.15
Xn_896_n2 n_896_x x_mag26 vss vss sky130_fd_pr__nfet_01v8 W=0.84 L=0.15
Xn_897_p1 n_897 n_589 n_897_x vdd sky130_fd_pr__pfet_01v8 W=1.4 L=0.15
Xn_897_p2 n_897_x x_mag26 vdd vdd sky130_fd_pr__pfet_01v8 W=1.4 L=0.15
Xn_897_n1 n_897 n_589 vss vss sky130_fd_pr__nfet_01v8 W=0.42 L=0.15
Xn_897_n2 n_897 x_mag26 vss vss sky130_fd_pr__nfet_01v8 W=0.42 L=0.15
Xn_898_n n_898 n_897 vss vss sky130_fd_pr__nfet_01v8 W=0.42 L=0.15
Xn_898_p n_898 n_897 vdd vdd sky130_fd_pr__pfet_01v8 W=0.7 L=0.15
Xn_899_p1 n_899 n_895 vdd vdd sky130_fd_pr__pfet_01v8 W=0.7 L=0.15
Xn_899_p2 n_899 n_898 vdd vdd sky130_fd_pr__pfet_01v8 W=0.7 L=0.15
Xn_899_n1 n_899 n_895 n_899_x vss sky130_fd_pr__nfet_01v8 W=0.84 L=0.15
Xn_899_n2 n_899_x n_898 vss vss sky130_fd_pr__nfet_01v8 W=0.84 L=0.15
Xn_900_p1 n_900 n_896 vdd vdd sky130_fd_pr__pfet_01v8 W=0.7 L=0.15
Xn_900_p2 n_900 n_899 vdd vdd sky130_fd_pr__pfet_01v8 W=0.7 L=0.15
Xn_900_n1 n_900 n_896 n_900_x vss sky130_fd_pr__nfet_01v8 W=0.84 L=0.15
Xn_900_n2 n_900_x n_899 vss vss sky130_fd_pr__nfet_01v8 W=0.84 L=0.15
Xn_901_p1 n_901 n_590 vdd vdd sky130_fd_pr__pfet_01v8 W=0.7 L=0.15
Xn_901_p2 n_901 x_mag27 vdd vdd sky130_fd_pr__pfet_01v8 W=0.7 L=0.15
Xn_901_n1 n_901 n_590 n_901_x vss sky130_fd_pr__nfet_01v8 W=0.84 L=0.15
Xn_901_n2 n_901_x x_mag27 vss vss sky130_fd_pr__nfet_01v8 W=0.84 L=0.15
Xn_902_p1 n_902 n_590 n_902_x vdd sky130_fd_pr__pfet_01v8 W=1.4 L=0.15
Xn_902_p2 n_902_x x_mag27 vdd vdd sky130_fd_pr__pfet_01v8 W=1.4 L=0.15
Xn_902_n1 n_902 n_590 vss vss sky130_fd_pr__nfet_01v8 W=0.42 L=0.15
Xn_902_n2 n_902 x_mag27 vss vss sky130_fd_pr__nfet_01v8 W=0.42 L=0.15
Xn_903_n n_903 n_902 vss vss sky130_fd_pr__nfet_01v8 W=0.42 L=0.15
Xn_903_p n_903 n_902 vdd vdd sky130_fd_pr__pfet_01v8 W=0.7 L=0.15
Xn_904_p1 n_904 n_900 vdd vdd sky130_fd_pr__pfet_01v8 W=0.7 L=0.15
Xn_904_p2 n_904 n_903 vdd vdd sky130_fd_pr__pfet_01v8 W=0.7 L=0.15
Xn_904_n1 n_904 n_900 n_904_x vss sky130_fd_pr__nfet_01v8 W=0.84 L=0.15
Xn_904_n2 n_904_x n_903 vss vss sky130_fd_pr__nfet_01v8 W=0.84 L=0.15
Xn_905_p1 n_905 n_901 vdd vdd sky130_fd_pr__pfet_01v8 W=0.7 L=0.15
Xn_905_p2 n_905 n_904 vdd vdd sky130_fd_pr__pfet_01v8 W=0.7 L=0.15
Xn_905_n1 n_905 n_901 n_905_x vss sky130_fd_pr__nfet_01v8 W=0.84 L=0.15
Xn_905_n2 n_905_x n_904 vss vss sky130_fd_pr__nfet_01v8 W=0.84 L=0.15
Xn_906_p1 n_906 n_403 vdd vdd sky130_fd_pr__pfet_01v8 W=0.7 L=0.15
Xn_906_p2 n_906 n_905 vdd vdd sky130_fd_pr__pfet_01v8 W=0.7 L=0.15
Xn_906_n1 n_906 n_403 n_906_x vss sky130_fd_pr__nfet_01v8 W=0.84 L=0.15
Xn_906_n2 n_906_x n_905 vss vss sky130_fd_pr__nfet_01v8 W=0.84 L=0.15
Xn_907_n n_907 n_906 vss vss sky130_fd_pr__nfet_01v8 W=0.42 L=0.15
Xn_907_p n_907 n_906 vdd vdd sky130_fd_pr__pfet_01v8 W=0.7 L=0.15
Xn_908_p1 n_908 n_440 vdd vdd sky130_fd_pr__pfet_01v8 W=0.7 L=0.15
Xn_908_p2 n_908 n_907 vdd vdd sky130_fd_pr__pfet_01v8 W=0.7 L=0.15
Xn_908_n1 n_908 n_440 n_908_x vss sky130_fd_pr__nfet_01v8 W=0.84 L=0.15
Xn_908_n2 n_908_x n_907 vss vss sky130_fd_pr__nfet_01v8 W=0.84 L=0.15
Xn_909_p1 n_909 n_591 vdd vdd sky130_fd_pr__pfet_01v8 W=0.7 L=0.15
Xn_909_p2 n_909 env6 vdd vdd sky130_fd_pr__pfet_01v8 W=0.7 L=0.15
Xn_909_n1 n_909 n_591 n_909_x vss sky130_fd_pr__nfet_01v8 W=0.84 L=0.15
Xn_909_n2 n_909_x env6 vss vss sky130_fd_pr__nfet_01v8 W=0.84 L=0.15
Xn_910_p1 n_910 n_908 vdd vdd sky130_fd_pr__pfet_01v8 W=0.7 L=0.15
Xn_910_p2 n_910 n_909 vdd vdd sky130_fd_pr__pfet_01v8 W=0.7 L=0.15
Xn_910_n1 n_910 n_908 n_910_x vss sky130_fd_pr__nfet_01v8 W=0.84 L=0.15
Xn_910_n2 n_910_x n_909 vss vss sky130_fd_pr__nfet_01v8 W=0.84 L=0.15
Xn_911_n n_911 n_910 vss vss sky130_fd_pr__nfet_01v8 W=0.42 L=0.15
Xn_911_p n_911 n_910 vdd vdd sky130_fd_pr__pfet_01v8 W=0.7 L=0.15
Xn_912_p1 n_912 n_910 n_912_x vdd sky130_fd_pr__pfet_01v8 W=1.4 L=0.15
Xn_912_p2 n_912_x n_202 vdd vdd sky130_fd_pr__pfet_01v8 W=1.4 L=0.15
Xn_912_n1 n_912 n_910 vss vss sky130_fd_pr__nfet_01v8 W=0.42 L=0.15
Xn_912_n2 n_912 n_202 vss vss sky130_fd_pr__nfet_01v8 W=0.42 L=0.15
Xn_913_p1 n_913 n_912 n_913_x vdd sky130_fd_pr__pfet_01v8 W=1.4 L=0.15
Xn_913_p2 n_913_x n_4 vdd vdd sky130_fd_pr__pfet_01v8 W=1.4 L=0.15
Xn_913_n1 n_913 n_912 vss vss sky130_fd_pr__nfet_01v8 W=0.42 L=0.15
Xn_913_n2 n_913 n_4 vss vss sky130_fd_pr__nfet_01v8 W=0.42 L=0.15
Xn_914_n n_914 n_913 vss vss sky130_fd_pr__nfet_01v8 W=0.42 L=0.15
Xn_914_p n_914 n_913 vdd vdd sky130_fd_pr__pfet_01v8 W=0.7 L=0.15
Xn_917_p1 n_917 n_911 n_917_x vdd sky130_fd_pr__pfet_01v8 W=1.4 L=0.15
Xn_917_p2 n_917_x n_202 vdd vdd sky130_fd_pr__pfet_01v8 W=1.4 L=0.15
Xn_917_n1 n_917 n_911 vss vss sky130_fd_pr__nfet_01v8 W=0.42 L=0.15
Xn_917_n2 n_917 n_202 vss vss sky130_fd_pr__nfet_01v8 W=0.42 L=0.15
Xn_916_p1 n_916 n_917 n_916_x vdd sky130_fd_pr__pfet_01v8 W=1.4 L=0.15
Xn_916_p2 n_916_x n_915 vdd vdd sky130_fd_pr__pfet_01v8 W=1.4 L=0.15
Xn_916_n1 n_916 n_917 vss vss sky130_fd_pr__nfet_01v8 W=0.42 L=0.15
Xn_916_n2 n_916 n_915 vss vss sky130_fd_pr__nfet_01v8 W=0.42 L=0.15
Xn_915_p1 n_915 n_914 n_915_x vdd sky130_fd_pr__pfet_01v8 W=1.4 L=0.15
Xn_915_p2 n_915_x n_916 vdd vdd sky130_fd_pr__pfet_01v8 W=1.4 L=0.15
Xn_915_n1 n_915 n_914 vss vss sky130_fd_pr__nfet_01v8 W=0.42 L=0.15
Xn_915_n2 n_915 n_916 vss vss sky130_fd_pr__nfet_01v8 W=0.42 L=0.15
Xn_918_p1 n_918 n_915 n_918_x vdd sky130_fd_pr__pfet_01v8 W=1.4 L=0.15
Xn_918_p2 n_918_x n_205 vdd vdd sky130_fd_pr__pfet_01v8 W=1.4 L=0.15
Xn_918_n1 n_918 n_915 vss vss sky130_fd_pr__nfet_01v8 W=0.42 L=0.15
Xn_918_n2 n_918 n_205 vss vss sky130_fd_pr__nfet_01v8 W=0.42 L=0.15
Xn_919_p1 n_919 n_918 n_919_x vdd sky130_fd_pr__pfet_01v8 W=1.4 L=0.15
Xn_919_p2 n_919_x n_4 vdd vdd sky130_fd_pr__pfet_01v8 W=1.4 L=0.15
Xn_919_n1 n_919 n_918 vss vss sky130_fd_pr__nfet_01v8 W=0.42 L=0.15
Xn_919_n2 n_919 n_4 vss vss sky130_fd_pr__nfet_01v8 W=0.42 L=0.15
Xn_920_n n_920 n_919 vss vss sky130_fd_pr__nfet_01v8 W=0.42 L=0.15
Xn_920_p n_920 n_919 vdd vdd sky130_fd_pr__pfet_01v8 W=0.7 L=0.15
Xn_922_p1 n_922 n_916 n_922_x vdd sky130_fd_pr__pfet_01v8 W=1.4 L=0.15
Xn_922_p2 n_922_x n_205 vdd vdd sky130_fd_pr__pfet_01v8 W=1.4 L=0.15
Xn_922_n1 n_922 n_916 vss vss sky130_fd_pr__nfet_01v8 W=0.42 L=0.15
Xn_922_n2 n_922 n_205 vss vss sky130_fd_pr__nfet_01v8 W=0.42 L=0.15
Xn_921_p1 n_921 n_922 n_921_x vdd sky130_fd_pr__pfet_01v8 W=1.4 L=0.15
Xn_921_p2 n_921_x env6 vdd vdd sky130_fd_pr__pfet_01v8 W=1.4 L=0.15
Xn_921_n1 n_921 n_922 vss vss sky130_fd_pr__nfet_01v8 W=0.42 L=0.15
Xn_921_n2 n_921 env6 vss vss sky130_fd_pr__nfet_01v8 W=0.42 L=0.15
Xenv6_p1 env6 n_920 env6_x vdd sky130_fd_pr__pfet_01v8 W=1.4 L=0.15
Xenv6_p2 env6_x n_921 vdd vdd sky130_fd_pr__pfet_01v8 W=1.4 L=0.15
Xenv6_n1 env6 n_920 vss vss sky130_fd_pr__nfet_01v8 W=0.42 L=0.15
Xenv6_n2 env6 n_921 vss vss sky130_fd_pr__nfet_01v8 W=0.42 L=0.15
Xn_923_n n_923 env6 vss vss sky130_fd_pr__nfet_01v8 W=0.42 L=0.15
Xn_923_p n_923 env6 vdd vdd sky130_fd_pr__pfet_01v8 W=0.7 L=0.15
Xn_924_p1 n_924 env6 vdd vdd sky130_fd_pr__pfet_01v8 W=0.7 L=0.15
Xn_924_p2 n_924 n_594 vdd vdd sky130_fd_pr__pfet_01v8 W=0.7 L=0.15
Xn_924_n1 n_924 env6 n_924_x vss sky130_fd_pr__nfet_01v8 W=0.84 L=0.15
Xn_924_n2 n_924_x n_594 vss vss sky130_fd_pr__nfet_01v8 W=0.84 L=0.15
Xn_925_n n_925 n_924 vss vss sky130_fd_pr__nfet_01v8 W=0.42 L=0.15
Xn_925_p n_925 n_924 vdd vdd sky130_fd_pr__pfet_01v8 W=0.7 L=0.15
Xn_926_p1 n_926 n_923 vdd vdd sky130_fd_pr__pfet_01v8 W=0.7 L=0.15
Xn_926_p2 n_926 n_594 vdd vdd sky130_fd_pr__pfet_01v8 W=0.7 L=0.15
Xn_926_n1 n_926 n_923 n_926_x vss sky130_fd_pr__nfet_01v8 W=0.84 L=0.15
Xn_926_n2 n_926_x n_594 vss vss sky130_fd_pr__nfet_01v8 W=0.84 L=0.15
Xn_927_n n_927 n_926 vss vss sky130_fd_pr__nfet_01v8 W=0.42 L=0.15
Xn_927_p n_927 n_926 vdd vdd sky130_fd_pr__pfet_01v8 W=0.7 L=0.15
Xn_928_p1 n_928 n_927 n_928_x vdd sky130_fd_pr__pfet_01v8 W=1.4 L=0.15
Xn_928_p2 n_928_x n_4 vdd vdd sky130_fd_pr__pfet_01v8 W=1.4 L=0.15
Xn_928_n1 n_928 n_927 vss vss sky130_fd_pr__nfet_01v8 W=0.42 L=0.15
Xn_928_n2 n_928 n_4 vss vss sky130_fd_pr__nfet_01v8 W=0.42 L=0.15
Xn_929_n n_929 n_928 vss vss sky130_fd_pr__nfet_01v8 W=0.42 L=0.15
Xn_929_p n_929 n_928 vdd vdd sky130_fd_pr__pfet_01v8 W=0.7 L=0.15
Xn_931_p1 n_931 n_925 n_931_x vdd sky130_fd_pr__pfet_01v8 W=1.4 L=0.15
Xn_931_p2 n_931_x n_930 vdd vdd sky130_fd_pr__pfet_01v8 W=1.4 L=0.15
Xn_931_n1 n_931 n_925 vss vss sky130_fd_pr__nfet_01v8 W=0.42 L=0.15
Xn_931_n2 n_931 n_930 vss vss sky130_fd_pr__nfet_01v8 W=0.42 L=0.15
Xn_930_p1 n_930 n_929 n_930_x vdd sky130_fd_pr__pfet_01v8 W=1.4 L=0.15
Xn_930_p2 n_930_x n_931 vdd vdd sky130_fd_pr__pfet_01v8 W=1.4 L=0.15
Xn_930_n1 n_930 n_929 vss vss sky130_fd_pr__nfet_01v8 W=0.42 L=0.15
Xn_930_n2 n_930 n_931 vss vss sky130_fd_pr__nfet_01v8 W=0.42 L=0.15
Xn_932_n n_932 n_930 vss vss sky130_fd_pr__nfet_01v8 W=0.42 L=0.15
Xn_932_p n_932 n_930 vdd vdd sky130_fd_pr__pfet_01v8 W=0.7 L=0.15
Xn_933_n n_933 n_932 vss vss sky130_fd_pr__nfet_01v8 W=0.42 L=0.15
Xn_933_p n_933 n_932 vdd vdd sky130_fd_pr__pfet_01v8 W=0.7 L=0.15
Xn_934_n n_934 x_neg6 vss vss sky130_fd_pr__nfet_01v8 W=0.42 L=0.15
Xn_934_p n_934 x_neg6 vdd vdd sky130_fd_pr__pfet_01v8 W=0.7 L=0.15
Xn_935_p1 n_935 n_933 vdd vdd sky130_fd_pr__pfet_01v8 W=0.7 L=0.15
Xn_935_p2 n_935 n_934 vdd vdd sky130_fd_pr__pfet_01v8 W=0.7 L=0.15
Xn_935_n1 n_935 n_933 n_935_x vss sky130_fd_pr__nfet_01v8 W=0.84 L=0.15
Xn_935_n2 n_935_x n_934 vss vss sky130_fd_pr__nfet_01v8 W=0.84 L=0.15
Xxin_p_r6_n xin_p_r6 n_935 vss vss sky130_fd_pr__nfet_01v8 W=0.42 L=0.15
Xxin_p_r6_p xin_p_r6 n_935 vdd vdd sky130_fd_pr__pfet_01v8 W=0.7 L=0.15
Xn_936_p1 n_936 n_933 vdd vdd sky130_fd_pr__pfet_01v8 W=0.7 L=0.15
Xn_936_p2 n_936 x_neg6 vdd vdd sky130_fd_pr__pfet_01v8 W=0.7 L=0.15
Xn_936_n1 n_936 n_933 n_936_x vss sky130_fd_pr__nfet_01v8 W=0.84 L=0.15
Xn_936_n2 n_936_x x_neg6 vss vss sky130_fd_pr__nfet_01v8 W=0.84 L=0.15
Xxin_n_r6_n xin_n_r6 n_936 vss vss sky130_fd_pr__nfet_01v8 W=0.42 L=0.15
Xxin_n_r6_p xin_n_r6 n_936 vdd vdd sky130_fd_pr__pfet_01v8 W=0.7 L=0.15
Xn_937_p1 n_937 n_933 vdd vdd sky130_fd_pr__pfet_01v8 W=0.7 L=0.15
Xn_937_p2 n_937 lora_en vdd vdd sky130_fd_pr__pfet_01v8 W=0.7 L=0.15
Xn_937_n1 n_937 n_933 n_937_x vss sky130_fd_pr__nfet_01v8 W=0.84 L=0.15
Xn_937_n2 n_937_x lora_en vss vss sky130_fd_pr__nfet_01v8 W=0.84 L=0.15
Xxrd_en6_n xrd_en6 n_937 vss vss sky130_fd_pr__nfet_01v8 W=0.42 L=0.15
Xxrd_en6_p xrd_en6 n_937 vdd vdd sky130_fd_pr__pfet_01v8 W=0.7 L=0.15
Xn_938_p1 n_938 n_587 vdd vdd sky130_fd_pr__pfet_01v8 W=0.7 L=0.15
Xn_938_p2 n_938 x_mag28 vdd vdd sky130_fd_pr__pfet_01v8 W=0.7 L=0.15
Xn_938_n1 n_938 n_587 n_938_x vss sky130_fd_pr__nfet_01v8 W=0.84 L=0.15
Xn_938_n2 n_938_x x_mag28 vss vss sky130_fd_pr__nfet_01v8 W=0.84 L=0.15
Xn_939_n n_939 n_938 vss vss sky130_fd_pr__nfet_01v8 W=0.42 L=0.15
Xn_939_p n_939 n_938 vdd vdd sky130_fd_pr__pfet_01v8 W=0.7 L=0.15
Xn_940_p1 n_940 n_588 vdd vdd sky130_fd_pr__pfet_01v8 W=0.7 L=0.15
Xn_940_p2 n_940 x_mag29 vdd vdd sky130_fd_pr__pfet_01v8 W=0.7 L=0.15
Xn_940_n1 n_940 n_588 n_940_x vss sky130_fd_pr__nfet_01v8 W=0.84 L=0.15
Xn_940_n2 n_940_x x_mag29 vss vss sky130_fd_pr__nfet_01v8 W=0.84 L=0.15
Xn_941_p1 n_941 n_588 n_941_x vdd sky130_fd_pr__pfet_01v8 W=1.4 L=0.15
Xn_941_p2 n_941_x x_mag29 vdd vdd sky130_fd_pr__pfet_01v8 W=1.4 L=0.15
Xn_941_n1 n_941 n_588 vss vss sky130_fd_pr__nfet_01v8 W=0.42 L=0.15
Xn_941_n2 n_941 x_mag29 vss vss sky130_fd_pr__nfet_01v8 W=0.42 L=0.15
Xn_942_n n_942 n_941 vss vss sky130_fd_pr__nfet_01v8 W=0.42 L=0.15
Xn_942_p n_942 n_941 vdd vdd sky130_fd_pr__pfet_01v8 W=0.7 L=0.15
Xn_943_p1 n_943 n_939 vdd vdd sky130_fd_pr__pfet_01v8 W=0.7 L=0.15
Xn_943_p2 n_943 n_942 vdd vdd sky130_fd_pr__pfet_01v8 W=0.7 L=0.15
Xn_943_n1 n_943 n_939 n_943_x vss sky130_fd_pr__nfet_01v8 W=0.84 L=0.15
Xn_943_n2 n_943_x n_942 vss vss sky130_fd_pr__nfet_01v8 W=0.84 L=0.15
Xn_944_p1 n_944 n_940 vdd vdd sky130_fd_pr__pfet_01v8 W=0.7 L=0.15
Xn_944_p2 n_944 n_943 vdd vdd sky130_fd_pr__pfet_01v8 W=0.7 L=0.15
Xn_944_n1 n_944 n_940 n_944_x vss sky130_fd_pr__nfet_01v8 W=0.84 L=0.15
Xn_944_n2 n_944_x n_943 vss vss sky130_fd_pr__nfet_01v8 W=0.84 L=0.15
Xn_945_p1 n_945 n_589 vdd vdd sky130_fd_pr__pfet_01v8 W=0.7 L=0.15
Xn_945_p2 n_945 x_mag30 vdd vdd sky130_fd_pr__pfet_01v8 W=0.7 L=0.15
Xn_945_n1 n_945 n_589 n_945_x vss sky130_fd_pr__nfet_01v8 W=0.84 L=0.15
Xn_945_n2 n_945_x x_mag30 vss vss sky130_fd_pr__nfet_01v8 W=0.84 L=0.15
Xn_946_p1 n_946 n_589 n_946_x vdd sky130_fd_pr__pfet_01v8 W=1.4 L=0.15
Xn_946_p2 n_946_x x_mag30 vdd vdd sky130_fd_pr__pfet_01v8 W=1.4 L=0.15
Xn_946_n1 n_946 n_589 vss vss sky130_fd_pr__nfet_01v8 W=0.42 L=0.15
Xn_946_n2 n_946 x_mag30 vss vss sky130_fd_pr__nfet_01v8 W=0.42 L=0.15
Xn_947_n n_947 n_946 vss vss sky130_fd_pr__nfet_01v8 W=0.42 L=0.15
Xn_947_p n_947 n_946 vdd vdd sky130_fd_pr__pfet_01v8 W=0.7 L=0.15
Xn_948_p1 n_948 n_944 vdd vdd sky130_fd_pr__pfet_01v8 W=0.7 L=0.15
Xn_948_p2 n_948 n_947 vdd vdd sky130_fd_pr__pfet_01v8 W=0.7 L=0.15
Xn_948_n1 n_948 n_944 n_948_x vss sky130_fd_pr__nfet_01v8 W=0.84 L=0.15
Xn_948_n2 n_948_x n_947 vss vss sky130_fd_pr__nfet_01v8 W=0.84 L=0.15
Xn_949_p1 n_949 n_945 vdd vdd sky130_fd_pr__pfet_01v8 W=0.7 L=0.15
Xn_949_p2 n_949 n_948 vdd vdd sky130_fd_pr__pfet_01v8 W=0.7 L=0.15
Xn_949_n1 n_949 n_945 n_949_x vss sky130_fd_pr__nfet_01v8 W=0.84 L=0.15
Xn_949_n2 n_949_x n_948 vss vss sky130_fd_pr__nfet_01v8 W=0.84 L=0.15
Xn_950_p1 n_950 n_590 vdd vdd sky130_fd_pr__pfet_01v8 W=0.7 L=0.15
Xn_950_p2 n_950 x_mag31 vdd vdd sky130_fd_pr__pfet_01v8 W=0.7 L=0.15
Xn_950_n1 n_950 n_590 n_950_x vss sky130_fd_pr__nfet_01v8 W=0.84 L=0.15
Xn_950_n2 n_950_x x_mag31 vss vss sky130_fd_pr__nfet_01v8 W=0.84 L=0.15
Xn_951_p1 n_951 n_590 n_951_x vdd sky130_fd_pr__pfet_01v8 W=1.4 L=0.15
Xn_951_p2 n_951_x x_mag31 vdd vdd sky130_fd_pr__pfet_01v8 W=1.4 L=0.15
Xn_951_n1 n_951 n_590 vss vss sky130_fd_pr__nfet_01v8 W=0.42 L=0.15
Xn_951_n2 n_951 x_mag31 vss vss sky130_fd_pr__nfet_01v8 W=0.42 L=0.15
Xn_952_n n_952 n_951 vss vss sky130_fd_pr__nfet_01v8 W=0.42 L=0.15
Xn_952_p n_952 n_951 vdd vdd sky130_fd_pr__pfet_01v8 W=0.7 L=0.15
Xn_953_p1 n_953 n_949 vdd vdd sky130_fd_pr__pfet_01v8 W=0.7 L=0.15
Xn_953_p2 n_953 n_952 vdd vdd sky130_fd_pr__pfet_01v8 W=0.7 L=0.15
Xn_953_n1 n_953 n_949 n_953_x vss sky130_fd_pr__nfet_01v8 W=0.84 L=0.15
Xn_953_n2 n_953_x n_952 vss vss sky130_fd_pr__nfet_01v8 W=0.84 L=0.15
Xn_954_p1 n_954 n_950 vdd vdd sky130_fd_pr__pfet_01v8 W=0.7 L=0.15
Xn_954_p2 n_954 n_953 vdd vdd sky130_fd_pr__pfet_01v8 W=0.7 L=0.15
Xn_954_n1 n_954 n_950 n_954_x vss sky130_fd_pr__nfet_01v8 W=0.84 L=0.15
Xn_954_n2 n_954_x n_953 vss vss sky130_fd_pr__nfet_01v8 W=0.84 L=0.15
Xn_955_p1 n_955 n_403 vdd vdd sky130_fd_pr__pfet_01v8 W=0.7 L=0.15
Xn_955_p2 n_955 n_954 vdd vdd sky130_fd_pr__pfet_01v8 W=0.7 L=0.15
Xn_955_n1 n_955 n_403 n_955_x vss sky130_fd_pr__nfet_01v8 W=0.84 L=0.15
Xn_955_n2 n_955_x n_954 vss vss sky130_fd_pr__nfet_01v8 W=0.84 L=0.15
Xn_956_n n_956 n_955 vss vss sky130_fd_pr__nfet_01v8 W=0.42 L=0.15
Xn_956_p n_956 n_955 vdd vdd sky130_fd_pr__pfet_01v8 W=0.7 L=0.15
Xn_957_p1 n_957 n_440 vdd vdd sky130_fd_pr__pfet_01v8 W=0.7 L=0.15
Xn_957_p2 n_957 n_956 vdd vdd sky130_fd_pr__pfet_01v8 W=0.7 L=0.15
Xn_957_n1 n_957 n_440 n_957_x vss sky130_fd_pr__nfet_01v8 W=0.84 L=0.15
Xn_957_n2 n_957_x n_956 vss vss sky130_fd_pr__nfet_01v8 W=0.84 L=0.15
Xn_958_p1 n_958 n_591 vdd vdd sky130_fd_pr__pfet_01v8 W=0.7 L=0.15
Xn_958_p2 n_958 env7 vdd vdd sky130_fd_pr__pfet_01v8 W=0.7 L=0.15
Xn_958_n1 n_958 n_591 n_958_x vss sky130_fd_pr__nfet_01v8 W=0.84 L=0.15
Xn_958_n2 n_958_x env7 vss vss sky130_fd_pr__nfet_01v8 W=0.84 L=0.15
Xn_959_p1 n_959 n_957 vdd vdd sky130_fd_pr__pfet_01v8 W=0.7 L=0.15
Xn_959_p2 n_959 n_958 vdd vdd sky130_fd_pr__pfet_01v8 W=0.7 L=0.15
Xn_959_n1 n_959 n_957 n_959_x vss sky130_fd_pr__nfet_01v8 W=0.84 L=0.15
Xn_959_n2 n_959_x n_958 vss vss sky130_fd_pr__nfet_01v8 W=0.84 L=0.15
Xn_960_n n_960 n_959 vss vss sky130_fd_pr__nfet_01v8 W=0.42 L=0.15
Xn_960_p n_960 n_959 vdd vdd sky130_fd_pr__pfet_01v8 W=0.7 L=0.15
Xn_961_p1 n_961 n_959 n_961_x vdd sky130_fd_pr__pfet_01v8 W=1.4 L=0.15
Xn_961_p2 n_961_x n_202 vdd vdd sky130_fd_pr__pfet_01v8 W=1.4 L=0.15
Xn_961_n1 n_961 n_959 vss vss sky130_fd_pr__nfet_01v8 W=0.42 L=0.15
Xn_961_n2 n_961 n_202 vss vss sky130_fd_pr__nfet_01v8 W=0.42 L=0.15
Xn_962_p1 n_962 n_961 n_962_x vdd sky130_fd_pr__pfet_01v8 W=1.4 L=0.15
Xn_962_p2 n_962_x n_4 vdd vdd sky130_fd_pr__pfet_01v8 W=1.4 L=0.15
Xn_962_n1 n_962 n_961 vss vss sky130_fd_pr__nfet_01v8 W=0.42 L=0.15
Xn_962_n2 n_962 n_4 vss vss sky130_fd_pr__nfet_01v8 W=0.42 L=0.15
Xn_963_n n_963 n_962 vss vss sky130_fd_pr__nfet_01v8 W=0.42 L=0.15
Xn_963_p n_963 n_962 vdd vdd sky130_fd_pr__pfet_01v8 W=0.7 L=0.15
Xn_966_p1 n_966 n_960 n_966_x vdd sky130_fd_pr__pfet_01v8 W=1.4 L=0.15
Xn_966_p2 n_966_x n_202 vdd vdd sky130_fd_pr__pfet_01v8 W=1.4 L=0.15
Xn_966_n1 n_966 n_960 vss vss sky130_fd_pr__nfet_01v8 W=0.42 L=0.15
Xn_966_n2 n_966 n_202 vss vss sky130_fd_pr__nfet_01v8 W=0.42 L=0.15
Xn_965_p1 n_965 n_966 n_965_x vdd sky130_fd_pr__pfet_01v8 W=1.4 L=0.15
Xn_965_p2 n_965_x n_964 vdd vdd sky130_fd_pr__pfet_01v8 W=1.4 L=0.15
Xn_965_n1 n_965 n_966 vss vss sky130_fd_pr__nfet_01v8 W=0.42 L=0.15
Xn_965_n2 n_965 n_964 vss vss sky130_fd_pr__nfet_01v8 W=0.42 L=0.15
Xn_964_p1 n_964 n_963 n_964_x vdd sky130_fd_pr__pfet_01v8 W=1.4 L=0.15
Xn_964_p2 n_964_x n_965 vdd vdd sky130_fd_pr__pfet_01v8 W=1.4 L=0.15
Xn_964_n1 n_964 n_963 vss vss sky130_fd_pr__nfet_01v8 W=0.42 L=0.15
Xn_964_n2 n_964 n_965 vss vss sky130_fd_pr__nfet_01v8 W=0.42 L=0.15
Xn_967_p1 n_967 n_964 n_967_x vdd sky130_fd_pr__pfet_01v8 W=1.4 L=0.15
Xn_967_p2 n_967_x n_205 vdd vdd sky130_fd_pr__pfet_01v8 W=1.4 L=0.15
Xn_967_n1 n_967 n_964 vss vss sky130_fd_pr__nfet_01v8 W=0.42 L=0.15
Xn_967_n2 n_967 n_205 vss vss sky130_fd_pr__nfet_01v8 W=0.42 L=0.15
Xn_968_p1 n_968 n_967 n_968_x vdd sky130_fd_pr__pfet_01v8 W=1.4 L=0.15
Xn_968_p2 n_968_x n_4 vdd vdd sky130_fd_pr__pfet_01v8 W=1.4 L=0.15
Xn_968_n1 n_968 n_967 vss vss sky130_fd_pr__nfet_01v8 W=0.42 L=0.15
Xn_968_n2 n_968 n_4 vss vss sky130_fd_pr__nfet_01v8 W=0.42 L=0.15
Xn_969_n n_969 n_968 vss vss sky130_fd_pr__nfet_01v8 W=0.42 L=0.15
Xn_969_p n_969 n_968 vdd vdd sky130_fd_pr__pfet_01v8 W=0.7 L=0.15
Xn_971_p1 n_971 n_965 n_971_x vdd sky130_fd_pr__pfet_01v8 W=1.4 L=0.15
Xn_971_p2 n_971_x n_205 vdd vdd sky130_fd_pr__pfet_01v8 W=1.4 L=0.15
Xn_971_n1 n_971 n_965 vss vss sky130_fd_pr__nfet_01v8 W=0.42 L=0.15
Xn_971_n2 n_971 n_205 vss vss sky130_fd_pr__nfet_01v8 W=0.42 L=0.15
Xn_970_p1 n_970 n_971 n_970_x vdd sky130_fd_pr__pfet_01v8 W=1.4 L=0.15
Xn_970_p2 n_970_x env7 vdd vdd sky130_fd_pr__pfet_01v8 W=1.4 L=0.15
Xn_970_n1 n_970 n_971 vss vss sky130_fd_pr__nfet_01v8 W=0.42 L=0.15
Xn_970_n2 n_970 env7 vss vss sky130_fd_pr__nfet_01v8 W=0.42 L=0.15
Xenv7_p1 env7 n_969 env7_x vdd sky130_fd_pr__pfet_01v8 W=1.4 L=0.15
Xenv7_p2 env7_x n_970 vdd vdd sky130_fd_pr__pfet_01v8 W=1.4 L=0.15
Xenv7_n1 env7 n_969 vss vss sky130_fd_pr__nfet_01v8 W=0.42 L=0.15
Xenv7_n2 env7 n_970 vss vss sky130_fd_pr__nfet_01v8 W=0.42 L=0.15
Xn_972_n n_972 env7 vss vss sky130_fd_pr__nfet_01v8 W=0.42 L=0.15
Xn_972_p n_972 env7 vdd vdd sky130_fd_pr__pfet_01v8 W=0.7 L=0.15
Xn_973_p1 n_973 env7 vdd vdd sky130_fd_pr__pfet_01v8 W=0.7 L=0.15
Xn_973_p2 n_973 n_594 vdd vdd sky130_fd_pr__pfet_01v8 W=0.7 L=0.15
Xn_973_n1 n_973 env7 n_973_x vss sky130_fd_pr__nfet_01v8 W=0.84 L=0.15
Xn_973_n2 n_973_x n_594 vss vss sky130_fd_pr__nfet_01v8 W=0.84 L=0.15
Xn_974_n n_974 n_973 vss vss sky130_fd_pr__nfet_01v8 W=0.42 L=0.15
Xn_974_p n_974 n_973 vdd vdd sky130_fd_pr__pfet_01v8 W=0.7 L=0.15
Xn_975_p1 n_975 n_972 vdd vdd sky130_fd_pr__pfet_01v8 W=0.7 L=0.15
Xn_975_p2 n_975 n_594 vdd vdd sky130_fd_pr__pfet_01v8 W=0.7 L=0.15
Xn_975_n1 n_975 n_972 n_975_x vss sky130_fd_pr__nfet_01v8 W=0.84 L=0.15
Xn_975_n2 n_975_x n_594 vss vss sky130_fd_pr__nfet_01v8 W=0.84 L=0.15
Xn_976_n n_976 n_975 vss vss sky130_fd_pr__nfet_01v8 W=0.42 L=0.15
Xn_976_p n_976 n_975 vdd vdd sky130_fd_pr__pfet_01v8 W=0.7 L=0.15
Xn_977_p1 n_977 n_976 n_977_x vdd sky130_fd_pr__pfet_01v8 W=1.4 L=0.15
Xn_977_p2 n_977_x n_4 vdd vdd sky130_fd_pr__pfet_01v8 W=1.4 L=0.15
Xn_977_n1 n_977 n_976 vss vss sky130_fd_pr__nfet_01v8 W=0.42 L=0.15
Xn_977_n2 n_977 n_4 vss vss sky130_fd_pr__nfet_01v8 W=0.42 L=0.15
Xn_978_n n_978 n_977 vss vss sky130_fd_pr__nfet_01v8 W=0.42 L=0.15
Xn_978_p n_978 n_977 vdd vdd sky130_fd_pr__pfet_01v8 W=0.7 L=0.15
Xn_980_p1 n_980 n_974 n_980_x vdd sky130_fd_pr__pfet_01v8 W=1.4 L=0.15
Xn_980_p2 n_980_x n_979 vdd vdd sky130_fd_pr__pfet_01v8 W=1.4 L=0.15
Xn_980_n1 n_980 n_974 vss vss sky130_fd_pr__nfet_01v8 W=0.42 L=0.15
Xn_980_n2 n_980 n_979 vss vss sky130_fd_pr__nfet_01v8 W=0.42 L=0.15
Xn_979_p1 n_979 n_978 n_979_x vdd sky130_fd_pr__pfet_01v8 W=1.4 L=0.15
Xn_979_p2 n_979_x n_980 vdd vdd sky130_fd_pr__pfet_01v8 W=1.4 L=0.15
Xn_979_n1 n_979 n_978 vss vss sky130_fd_pr__nfet_01v8 W=0.42 L=0.15
Xn_979_n2 n_979 n_980 vss vss sky130_fd_pr__nfet_01v8 W=0.42 L=0.15
Xn_981_n n_981 n_979 vss vss sky130_fd_pr__nfet_01v8 W=0.42 L=0.15
Xn_981_p n_981 n_979 vdd vdd sky130_fd_pr__pfet_01v8 W=0.7 L=0.15
Xn_982_n n_982 n_981 vss vss sky130_fd_pr__nfet_01v8 W=0.42 L=0.15
Xn_982_p n_982 n_981 vdd vdd sky130_fd_pr__pfet_01v8 W=0.7 L=0.15
Xn_983_n n_983 x_neg7 vss vss sky130_fd_pr__nfet_01v8 W=0.42 L=0.15
Xn_983_p n_983 x_neg7 vdd vdd sky130_fd_pr__pfet_01v8 W=0.7 L=0.15
Xn_984_p1 n_984 n_982 vdd vdd sky130_fd_pr__pfet_01v8 W=0.7 L=0.15
Xn_984_p2 n_984 n_983 vdd vdd sky130_fd_pr__pfet_01v8 W=0.7 L=0.15
Xn_984_n1 n_984 n_982 n_984_x vss sky130_fd_pr__nfet_01v8 W=0.84 L=0.15
Xn_984_n2 n_984_x n_983 vss vss sky130_fd_pr__nfet_01v8 W=0.84 L=0.15
Xxin_p_r7_n xin_p_r7 n_984 vss vss sky130_fd_pr__nfet_01v8 W=0.42 L=0.15
Xxin_p_r7_p xin_p_r7 n_984 vdd vdd sky130_fd_pr__pfet_01v8 W=0.7 L=0.15
Xn_985_p1 n_985 n_982 vdd vdd sky130_fd_pr__pfet_01v8 W=0.7 L=0.15
Xn_985_p2 n_985 x_neg7 vdd vdd sky130_fd_pr__pfet_01v8 W=0.7 L=0.15
Xn_985_n1 n_985 n_982 n_985_x vss sky130_fd_pr__nfet_01v8 W=0.84 L=0.15
Xn_985_n2 n_985_x x_neg7 vss vss sky130_fd_pr__nfet_01v8 W=0.84 L=0.15
Xxin_n_r7_n xin_n_r7 n_985 vss vss sky130_fd_pr__nfet_01v8 W=0.42 L=0.15
Xxin_n_r7_p xin_n_r7 n_985 vdd vdd sky130_fd_pr__pfet_01v8 W=0.7 L=0.15
Xn_986_p1 n_986 n_982 vdd vdd sky130_fd_pr__pfet_01v8 W=0.7 L=0.15
Xn_986_p2 n_986 lora_en vdd vdd sky130_fd_pr__pfet_01v8 W=0.7 L=0.15
Xn_986_n1 n_986 n_982 n_986_x vss sky130_fd_pr__nfet_01v8 W=0.84 L=0.15
Xn_986_n2 n_986_x lora_en vss vss sky130_fd_pr__nfet_01v8 W=0.84 L=0.15
Xxrd_en7_n xrd_en7 n_986 vss vss sky130_fd_pr__nfet_01v8 W=0.42 L=0.15
Xxrd_en7_p xrd_en7 n_986 vdd vdd sky130_fd_pr__pfet_01v8 W=0.7 L=0.15
Xn_987_p1 n_987 n_587 vdd vdd sky130_fd_pr__pfet_01v8 W=0.7 L=0.15
Xn_987_p2 n_987 x_mag32 vdd vdd sky130_fd_pr__pfet_01v8 W=0.7 L=0.15
Xn_987_n1 n_987 n_587 n_987_x vss sky130_fd_pr__nfet_01v8 W=0.84 L=0.15
Xn_987_n2 n_987_x x_mag32 vss vss sky130_fd_pr__nfet_01v8 W=0.84 L=0.15
Xn_988_n n_988 n_987 vss vss sky130_fd_pr__nfet_01v8 W=0.42 L=0.15
Xn_988_p n_988 n_987 vdd vdd sky130_fd_pr__pfet_01v8 W=0.7 L=0.15
Xn_989_p1 n_989 n_588 vdd vdd sky130_fd_pr__pfet_01v8 W=0.7 L=0.15
Xn_989_p2 n_989 x_mag33 vdd vdd sky130_fd_pr__pfet_01v8 W=0.7 L=0.15
Xn_989_n1 n_989 n_588 n_989_x vss sky130_fd_pr__nfet_01v8 W=0.84 L=0.15
Xn_989_n2 n_989_x x_mag33 vss vss sky130_fd_pr__nfet_01v8 W=0.84 L=0.15
Xn_990_p1 n_990 n_588 n_990_x vdd sky130_fd_pr__pfet_01v8 W=1.4 L=0.15
Xn_990_p2 n_990_x x_mag33 vdd vdd sky130_fd_pr__pfet_01v8 W=1.4 L=0.15
Xn_990_n1 n_990 n_588 vss vss sky130_fd_pr__nfet_01v8 W=0.42 L=0.15
Xn_990_n2 n_990 x_mag33 vss vss sky130_fd_pr__nfet_01v8 W=0.42 L=0.15
Xn_991_n n_991 n_990 vss vss sky130_fd_pr__nfet_01v8 W=0.42 L=0.15
Xn_991_p n_991 n_990 vdd vdd sky130_fd_pr__pfet_01v8 W=0.7 L=0.15
Xn_992_p1 n_992 n_988 vdd vdd sky130_fd_pr__pfet_01v8 W=0.7 L=0.15
Xn_992_p2 n_992 n_991 vdd vdd sky130_fd_pr__pfet_01v8 W=0.7 L=0.15
Xn_992_n1 n_992 n_988 n_992_x vss sky130_fd_pr__nfet_01v8 W=0.84 L=0.15
Xn_992_n2 n_992_x n_991 vss vss sky130_fd_pr__nfet_01v8 W=0.84 L=0.15
Xn_993_p1 n_993 n_989 vdd vdd sky130_fd_pr__pfet_01v8 W=0.7 L=0.15
Xn_993_p2 n_993 n_992 vdd vdd sky130_fd_pr__pfet_01v8 W=0.7 L=0.15
Xn_993_n1 n_993 n_989 n_993_x vss sky130_fd_pr__nfet_01v8 W=0.84 L=0.15
Xn_993_n2 n_993_x n_992 vss vss sky130_fd_pr__nfet_01v8 W=0.84 L=0.15
Xn_994_p1 n_994 n_589 vdd vdd sky130_fd_pr__pfet_01v8 W=0.7 L=0.15
Xn_994_p2 n_994 x_mag34 vdd vdd sky130_fd_pr__pfet_01v8 W=0.7 L=0.15
Xn_994_n1 n_994 n_589 n_994_x vss sky130_fd_pr__nfet_01v8 W=0.84 L=0.15
Xn_994_n2 n_994_x x_mag34 vss vss sky130_fd_pr__nfet_01v8 W=0.84 L=0.15
Xn_995_p1 n_995 n_589 n_995_x vdd sky130_fd_pr__pfet_01v8 W=1.4 L=0.15
Xn_995_p2 n_995_x x_mag34 vdd vdd sky130_fd_pr__pfet_01v8 W=1.4 L=0.15
Xn_995_n1 n_995 n_589 vss vss sky130_fd_pr__nfet_01v8 W=0.42 L=0.15
Xn_995_n2 n_995 x_mag34 vss vss sky130_fd_pr__nfet_01v8 W=0.42 L=0.15
Xn_996_n n_996 n_995 vss vss sky130_fd_pr__nfet_01v8 W=0.42 L=0.15
Xn_996_p n_996 n_995 vdd vdd sky130_fd_pr__pfet_01v8 W=0.7 L=0.15
Xn_997_p1 n_997 n_993 vdd vdd sky130_fd_pr__pfet_01v8 W=0.7 L=0.15
Xn_997_p2 n_997 n_996 vdd vdd sky130_fd_pr__pfet_01v8 W=0.7 L=0.15
Xn_997_n1 n_997 n_993 n_997_x vss sky130_fd_pr__nfet_01v8 W=0.84 L=0.15
Xn_997_n2 n_997_x n_996 vss vss sky130_fd_pr__nfet_01v8 W=0.84 L=0.15
Xn_998_p1 n_998 n_994 vdd vdd sky130_fd_pr__pfet_01v8 W=0.7 L=0.15
Xn_998_p2 n_998 n_997 vdd vdd sky130_fd_pr__pfet_01v8 W=0.7 L=0.15
Xn_998_n1 n_998 n_994 n_998_x vss sky130_fd_pr__nfet_01v8 W=0.84 L=0.15
Xn_998_n2 n_998_x n_997 vss vss sky130_fd_pr__nfet_01v8 W=0.84 L=0.15
Xn_999_p1 n_999 n_590 vdd vdd sky130_fd_pr__pfet_01v8 W=0.7 L=0.15
Xn_999_p2 n_999 x_mag35 vdd vdd sky130_fd_pr__pfet_01v8 W=0.7 L=0.15
Xn_999_n1 n_999 n_590 n_999_x vss sky130_fd_pr__nfet_01v8 W=0.84 L=0.15
Xn_999_n2 n_999_x x_mag35 vss vss sky130_fd_pr__nfet_01v8 W=0.84 L=0.15
Xn_1000_p1 n_1000 n_590 n_1000_x vdd sky130_fd_pr__pfet_01v8 W=1.4 L=0.15
Xn_1000_p2 n_1000_x x_mag35 vdd vdd sky130_fd_pr__pfet_01v8 W=1.4 L=0.15
Xn_1000_n1 n_1000 n_590 vss vss sky130_fd_pr__nfet_01v8 W=0.42 L=0.15
Xn_1000_n2 n_1000 x_mag35 vss vss sky130_fd_pr__nfet_01v8 W=0.42 L=0.15
Xn_1001_n n_1001 n_1000 vss vss sky130_fd_pr__nfet_01v8 W=0.42 L=0.15
Xn_1001_p n_1001 n_1000 vdd vdd sky130_fd_pr__pfet_01v8 W=0.7 L=0.15
Xn_1002_p1 n_1002 n_998 vdd vdd sky130_fd_pr__pfet_01v8 W=0.7 L=0.15
Xn_1002_p2 n_1002 n_1001 vdd vdd sky130_fd_pr__pfet_01v8 W=0.7 L=0.15
Xn_1002_n1 n_1002 n_998 n_1002_x vss sky130_fd_pr__nfet_01v8 W=0.84 L=0.15
Xn_1002_n2 n_1002_x n_1001 vss vss sky130_fd_pr__nfet_01v8 W=0.84 L=0.15
Xn_1003_p1 n_1003 n_999 vdd vdd sky130_fd_pr__pfet_01v8 W=0.7 L=0.15
Xn_1003_p2 n_1003 n_1002 vdd vdd sky130_fd_pr__pfet_01v8 W=0.7 L=0.15
Xn_1003_n1 n_1003 n_999 n_1003_x vss sky130_fd_pr__nfet_01v8 W=0.84 L=0.15
Xn_1003_n2 n_1003_x n_1002 vss vss sky130_fd_pr__nfet_01v8 W=0.84 L=0.15
Xn_1004_p1 n_1004 n_403 vdd vdd sky130_fd_pr__pfet_01v8 W=0.7 L=0.15
Xn_1004_p2 n_1004 n_1003 vdd vdd sky130_fd_pr__pfet_01v8 W=0.7 L=0.15
Xn_1004_n1 n_1004 n_403 n_1004_x vss sky130_fd_pr__nfet_01v8 W=0.84 L=0.15
Xn_1004_n2 n_1004_x n_1003 vss vss sky130_fd_pr__nfet_01v8 W=0.84 L=0.15
Xn_1005_n n_1005 n_1004 vss vss sky130_fd_pr__nfet_01v8 W=0.42 L=0.15
Xn_1005_p n_1005 n_1004 vdd vdd sky130_fd_pr__pfet_01v8 W=0.7 L=0.15
Xn_1006_p1 n_1006 n_440 vdd vdd sky130_fd_pr__pfet_01v8 W=0.7 L=0.15
Xn_1006_p2 n_1006 n_1005 vdd vdd sky130_fd_pr__pfet_01v8 W=0.7 L=0.15
Xn_1006_n1 n_1006 n_440 n_1006_x vss sky130_fd_pr__nfet_01v8 W=0.84 L=0.15
Xn_1006_n2 n_1006_x n_1005 vss vss sky130_fd_pr__nfet_01v8 W=0.84 L=0.15
Xn_1007_p1 n_1007 n_591 vdd vdd sky130_fd_pr__pfet_01v8 W=0.7 L=0.15
Xn_1007_p2 n_1007 env8 vdd vdd sky130_fd_pr__pfet_01v8 W=0.7 L=0.15
Xn_1007_n1 n_1007 n_591 n_1007_x vss sky130_fd_pr__nfet_01v8 W=0.84 L=0.15
Xn_1007_n2 n_1007_x env8 vss vss sky130_fd_pr__nfet_01v8 W=0.84 L=0.15
Xn_1008_p1 n_1008 n_1006 vdd vdd sky130_fd_pr__pfet_01v8 W=0.7 L=0.15
Xn_1008_p2 n_1008 n_1007 vdd vdd sky130_fd_pr__pfet_01v8 W=0.7 L=0.15
Xn_1008_n1 n_1008 n_1006 n_1008_x vss sky130_fd_pr__nfet_01v8 W=0.84 L=0.15
Xn_1008_n2 n_1008_x n_1007 vss vss sky130_fd_pr__nfet_01v8 W=0.84 L=0.15
Xn_1009_n n_1009 n_1008 vss vss sky130_fd_pr__nfet_01v8 W=0.42 L=0.15
Xn_1009_p n_1009 n_1008 vdd vdd sky130_fd_pr__pfet_01v8 W=0.7 L=0.15
Xn_1010_p1 n_1010 n_1008 n_1010_x vdd sky130_fd_pr__pfet_01v8 W=1.4 L=0.15
Xn_1010_p2 n_1010_x n_202 vdd vdd sky130_fd_pr__pfet_01v8 W=1.4 L=0.15
Xn_1010_n1 n_1010 n_1008 vss vss sky130_fd_pr__nfet_01v8 W=0.42 L=0.15
Xn_1010_n2 n_1010 n_202 vss vss sky130_fd_pr__nfet_01v8 W=0.42 L=0.15
Xn_1011_p1 n_1011 n_1010 n_1011_x vdd sky130_fd_pr__pfet_01v8 W=1.4 L=0.15
Xn_1011_p2 n_1011_x n_4 vdd vdd sky130_fd_pr__pfet_01v8 W=1.4 L=0.15
Xn_1011_n1 n_1011 n_1010 vss vss sky130_fd_pr__nfet_01v8 W=0.42 L=0.15
Xn_1011_n2 n_1011 n_4 vss vss sky130_fd_pr__nfet_01v8 W=0.42 L=0.15
Xn_1012_n n_1012 n_1011 vss vss sky130_fd_pr__nfet_01v8 W=0.42 L=0.15
Xn_1012_p n_1012 n_1011 vdd vdd sky130_fd_pr__pfet_01v8 W=0.7 L=0.15
Xn_1015_p1 n_1015 n_1009 n_1015_x vdd sky130_fd_pr__pfet_01v8 W=1.4 L=0.15
Xn_1015_p2 n_1015_x n_202 vdd vdd sky130_fd_pr__pfet_01v8 W=1.4 L=0.15
Xn_1015_n1 n_1015 n_1009 vss vss sky130_fd_pr__nfet_01v8 W=0.42 L=0.15
Xn_1015_n2 n_1015 n_202 vss vss sky130_fd_pr__nfet_01v8 W=0.42 L=0.15
Xn_1014_p1 n_1014 n_1015 n_1014_x vdd sky130_fd_pr__pfet_01v8 W=1.4 L=0.15
Xn_1014_p2 n_1014_x n_1013 vdd vdd sky130_fd_pr__pfet_01v8 W=1.4 L=0.15
Xn_1014_n1 n_1014 n_1015 vss vss sky130_fd_pr__nfet_01v8 W=0.42 L=0.15
Xn_1014_n2 n_1014 n_1013 vss vss sky130_fd_pr__nfet_01v8 W=0.42 L=0.15
Xn_1013_p1 n_1013 n_1012 n_1013_x vdd sky130_fd_pr__pfet_01v8 W=1.4 L=0.15
Xn_1013_p2 n_1013_x n_1014 vdd vdd sky130_fd_pr__pfet_01v8 W=1.4 L=0.15
Xn_1013_n1 n_1013 n_1012 vss vss sky130_fd_pr__nfet_01v8 W=0.42 L=0.15
Xn_1013_n2 n_1013 n_1014 vss vss sky130_fd_pr__nfet_01v8 W=0.42 L=0.15
Xn_1016_p1 n_1016 n_1013 n_1016_x vdd sky130_fd_pr__pfet_01v8 W=1.4 L=0.15
Xn_1016_p2 n_1016_x n_205 vdd vdd sky130_fd_pr__pfet_01v8 W=1.4 L=0.15
Xn_1016_n1 n_1016 n_1013 vss vss sky130_fd_pr__nfet_01v8 W=0.42 L=0.15
Xn_1016_n2 n_1016 n_205 vss vss sky130_fd_pr__nfet_01v8 W=0.42 L=0.15
Xn_1017_p1 n_1017 n_1016 n_1017_x vdd sky130_fd_pr__pfet_01v8 W=1.4 L=0.15
Xn_1017_p2 n_1017_x n_4 vdd vdd sky130_fd_pr__pfet_01v8 W=1.4 L=0.15
Xn_1017_n1 n_1017 n_1016 vss vss sky130_fd_pr__nfet_01v8 W=0.42 L=0.15
Xn_1017_n2 n_1017 n_4 vss vss sky130_fd_pr__nfet_01v8 W=0.42 L=0.15
Xn_1018_n n_1018 n_1017 vss vss sky130_fd_pr__nfet_01v8 W=0.42 L=0.15
Xn_1018_p n_1018 n_1017 vdd vdd sky130_fd_pr__pfet_01v8 W=0.7 L=0.15
Xn_1020_p1 n_1020 n_1014 n_1020_x vdd sky130_fd_pr__pfet_01v8 W=1.4 L=0.15
Xn_1020_p2 n_1020_x n_205 vdd vdd sky130_fd_pr__pfet_01v8 W=1.4 L=0.15
Xn_1020_n1 n_1020 n_1014 vss vss sky130_fd_pr__nfet_01v8 W=0.42 L=0.15
Xn_1020_n2 n_1020 n_205 vss vss sky130_fd_pr__nfet_01v8 W=0.42 L=0.15
Xn_1019_p1 n_1019 n_1020 n_1019_x vdd sky130_fd_pr__pfet_01v8 W=1.4 L=0.15
Xn_1019_p2 n_1019_x env8 vdd vdd sky130_fd_pr__pfet_01v8 W=1.4 L=0.15
Xn_1019_n1 n_1019 n_1020 vss vss sky130_fd_pr__nfet_01v8 W=0.42 L=0.15
Xn_1019_n2 n_1019 env8 vss vss sky130_fd_pr__nfet_01v8 W=0.42 L=0.15
Xenv8_p1 env8 n_1018 env8_x vdd sky130_fd_pr__pfet_01v8 W=1.4 L=0.15
Xenv8_p2 env8_x n_1019 vdd vdd sky130_fd_pr__pfet_01v8 W=1.4 L=0.15
Xenv8_n1 env8 n_1018 vss vss sky130_fd_pr__nfet_01v8 W=0.42 L=0.15
Xenv8_n2 env8 n_1019 vss vss sky130_fd_pr__nfet_01v8 W=0.42 L=0.15
Xn_1021_n n_1021 env8 vss vss sky130_fd_pr__nfet_01v8 W=0.42 L=0.15
Xn_1021_p n_1021 env8 vdd vdd sky130_fd_pr__pfet_01v8 W=0.7 L=0.15
Xn_1022_p1 n_1022 env8 vdd vdd sky130_fd_pr__pfet_01v8 W=0.7 L=0.15
Xn_1022_p2 n_1022 n_594 vdd vdd sky130_fd_pr__pfet_01v8 W=0.7 L=0.15
Xn_1022_n1 n_1022 env8 n_1022_x vss sky130_fd_pr__nfet_01v8 W=0.84 L=0.15
Xn_1022_n2 n_1022_x n_594 vss vss sky130_fd_pr__nfet_01v8 W=0.84 L=0.15
Xn_1023_n n_1023 n_1022 vss vss sky130_fd_pr__nfet_01v8 W=0.42 L=0.15
Xn_1023_p n_1023 n_1022 vdd vdd sky130_fd_pr__pfet_01v8 W=0.7 L=0.15
Xn_1024_p1 n_1024 n_1021 vdd vdd sky130_fd_pr__pfet_01v8 W=0.7 L=0.15
Xn_1024_p2 n_1024 n_594 vdd vdd sky130_fd_pr__pfet_01v8 W=0.7 L=0.15
Xn_1024_n1 n_1024 n_1021 n_1024_x vss sky130_fd_pr__nfet_01v8 W=0.84 L=0.15
Xn_1024_n2 n_1024_x n_594 vss vss sky130_fd_pr__nfet_01v8 W=0.84 L=0.15
Xn_1025_n n_1025 n_1024 vss vss sky130_fd_pr__nfet_01v8 W=0.42 L=0.15
Xn_1025_p n_1025 n_1024 vdd vdd sky130_fd_pr__pfet_01v8 W=0.7 L=0.15
Xn_1026_p1 n_1026 n_1025 n_1026_x vdd sky130_fd_pr__pfet_01v8 W=1.4 L=0.15
Xn_1026_p2 n_1026_x n_4 vdd vdd sky130_fd_pr__pfet_01v8 W=1.4 L=0.15
Xn_1026_n1 n_1026 n_1025 vss vss sky130_fd_pr__nfet_01v8 W=0.42 L=0.15
Xn_1026_n2 n_1026 n_4 vss vss sky130_fd_pr__nfet_01v8 W=0.42 L=0.15
Xn_1027_n n_1027 n_1026 vss vss sky130_fd_pr__nfet_01v8 W=0.42 L=0.15
Xn_1027_p n_1027 n_1026 vdd vdd sky130_fd_pr__pfet_01v8 W=0.7 L=0.15
Xn_1029_p1 n_1029 n_1023 n_1029_x vdd sky130_fd_pr__pfet_01v8 W=1.4 L=0.15
Xn_1029_p2 n_1029_x n_1028 vdd vdd sky130_fd_pr__pfet_01v8 W=1.4 L=0.15
Xn_1029_n1 n_1029 n_1023 vss vss sky130_fd_pr__nfet_01v8 W=0.42 L=0.15
Xn_1029_n2 n_1029 n_1028 vss vss sky130_fd_pr__nfet_01v8 W=0.42 L=0.15
Xn_1028_p1 n_1028 n_1027 n_1028_x vdd sky130_fd_pr__pfet_01v8 W=1.4 L=0.15
Xn_1028_p2 n_1028_x n_1029 vdd vdd sky130_fd_pr__pfet_01v8 W=1.4 L=0.15
Xn_1028_n1 n_1028 n_1027 vss vss sky130_fd_pr__nfet_01v8 W=0.42 L=0.15
Xn_1028_n2 n_1028 n_1029 vss vss sky130_fd_pr__nfet_01v8 W=0.42 L=0.15
Xn_1030_n n_1030 n_1028 vss vss sky130_fd_pr__nfet_01v8 W=0.42 L=0.15
Xn_1030_p n_1030 n_1028 vdd vdd sky130_fd_pr__pfet_01v8 W=0.7 L=0.15
Xn_1031_n n_1031 n_1030 vss vss sky130_fd_pr__nfet_01v8 W=0.42 L=0.15
Xn_1031_p n_1031 n_1030 vdd vdd sky130_fd_pr__pfet_01v8 W=0.7 L=0.15
Xn_1032_n n_1032 x_neg8 vss vss sky130_fd_pr__nfet_01v8 W=0.42 L=0.15
Xn_1032_p n_1032 x_neg8 vdd vdd sky130_fd_pr__pfet_01v8 W=0.7 L=0.15
Xn_1033_p1 n_1033 n_1031 vdd vdd sky130_fd_pr__pfet_01v8 W=0.7 L=0.15
Xn_1033_p2 n_1033 n_1032 vdd vdd sky130_fd_pr__pfet_01v8 W=0.7 L=0.15
Xn_1033_n1 n_1033 n_1031 n_1033_x vss sky130_fd_pr__nfet_01v8 W=0.84 L=0.15
Xn_1033_n2 n_1033_x n_1032 vss vss sky130_fd_pr__nfet_01v8 W=0.84 L=0.15
Xxin_p_r8_n xin_p_r8 n_1033 vss vss sky130_fd_pr__nfet_01v8 W=0.42 L=0.15
Xxin_p_r8_p xin_p_r8 n_1033 vdd vdd sky130_fd_pr__pfet_01v8 W=0.7 L=0.15
Xn_1034_p1 n_1034 n_1031 vdd vdd sky130_fd_pr__pfet_01v8 W=0.7 L=0.15
Xn_1034_p2 n_1034 x_neg8 vdd vdd sky130_fd_pr__pfet_01v8 W=0.7 L=0.15
Xn_1034_n1 n_1034 n_1031 n_1034_x vss sky130_fd_pr__nfet_01v8 W=0.84 L=0.15
Xn_1034_n2 n_1034_x x_neg8 vss vss sky130_fd_pr__nfet_01v8 W=0.84 L=0.15
Xxin_n_r8_n xin_n_r8 n_1034 vss vss sky130_fd_pr__nfet_01v8 W=0.42 L=0.15
Xxin_n_r8_p xin_n_r8 n_1034 vdd vdd sky130_fd_pr__pfet_01v8 W=0.7 L=0.15
Xn_1035_p1 n_1035 n_1031 vdd vdd sky130_fd_pr__pfet_01v8 W=0.7 L=0.15
Xn_1035_p2 n_1035 lora_en vdd vdd sky130_fd_pr__pfet_01v8 W=0.7 L=0.15
Xn_1035_n1 n_1035 n_1031 n_1035_x vss sky130_fd_pr__nfet_01v8 W=0.84 L=0.15
Xn_1035_n2 n_1035_x lora_en vss vss sky130_fd_pr__nfet_01v8 W=0.84 L=0.15
Xxrd_en8_n xrd_en8 n_1035 vss vss sky130_fd_pr__nfet_01v8 W=0.42 L=0.15
Xxrd_en8_p xrd_en8 n_1035 vdd vdd sky130_fd_pr__pfet_01v8 W=0.7 L=0.15
Xn_1036_p1 n_1036 n_587 vdd vdd sky130_fd_pr__pfet_01v8 W=0.7 L=0.15
Xn_1036_p2 n_1036 x_mag36 vdd vdd sky130_fd_pr__pfet_01v8 W=0.7 L=0.15
Xn_1036_n1 n_1036 n_587 n_1036_x vss sky130_fd_pr__nfet_01v8 W=0.84 L=0.15
Xn_1036_n2 n_1036_x x_mag36 vss vss sky130_fd_pr__nfet_01v8 W=0.84 L=0.15
Xn_1037_n n_1037 n_1036 vss vss sky130_fd_pr__nfet_01v8 W=0.42 L=0.15
Xn_1037_p n_1037 n_1036 vdd vdd sky130_fd_pr__pfet_01v8 W=0.7 L=0.15
Xn_1038_p1 n_1038 n_588 vdd vdd sky130_fd_pr__pfet_01v8 W=0.7 L=0.15
Xn_1038_p2 n_1038 x_mag37 vdd vdd sky130_fd_pr__pfet_01v8 W=0.7 L=0.15
Xn_1038_n1 n_1038 n_588 n_1038_x vss sky130_fd_pr__nfet_01v8 W=0.84 L=0.15
Xn_1038_n2 n_1038_x x_mag37 vss vss sky130_fd_pr__nfet_01v8 W=0.84 L=0.15
Xn_1039_p1 n_1039 n_588 n_1039_x vdd sky130_fd_pr__pfet_01v8 W=1.4 L=0.15
Xn_1039_p2 n_1039_x x_mag37 vdd vdd sky130_fd_pr__pfet_01v8 W=1.4 L=0.15
Xn_1039_n1 n_1039 n_588 vss vss sky130_fd_pr__nfet_01v8 W=0.42 L=0.15
Xn_1039_n2 n_1039 x_mag37 vss vss sky130_fd_pr__nfet_01v8 W=0.42 L=0.15
Xn_1040_n n_1040 n_1039 vss vss sky130_fd_pr__nfet_01v8 W=0.42 L=0.15
Xn_1040_p n_1040 n_1039 vdd vdd sky130_fd_pr__pfet_01v8 W=0.7 L=0.15
Xn_1041_p1 n_1041 n_1037 vdd vdd sky130_fd_pr__pfet_01v8 W=0.7 L=0.15
Xn_1041_p2 n_1041 n_1040 vdd vdd sky130_fd_pr__pfet_01v8 W=0.7 L=0.15
Xn_1041_n1 n_1041 n_1037 n_1041_x vss sky130_fd_pr__nfet_01v8 W=0.84 L=0.15
Xn_1041_n2 n_1041_x n_1040 vss vss sky130_fd_pr__nfet_01v8 W=0.84 L=0.15
Xn_1042_p1 n_1042 n_1038 vdd vdd sky130_fd_pr__pfet_01v8 W=0.7 L=0.15
Xn_1042_p2 n_1042 n_1041 vdd vdd sky130_fd_pr__pfet_01v8 W=0.7 L=0.15
Xn_1042_n1 n_1042 n_1038 n_1042_x vss sky130_fd_pr__nfet_01v8 W=0.84 L=0.15
Xn_1042_n2 n_1042_x n_1041 vss vss sky130_fd_pr__nfet_01v8 W=0.84 L=0.15
Xn_1043_p1 n_1043 n_589 vdd vdd sky130_fd_pr__pfet_01v8 W=0.7 L=0.15
Xn_1043_p2 n_1043 x_mag38 vdd vdd sky130_fd_pr__pfet_01v8 W=0.7 L=0.15
Xn_1043_n1 n_1043 n_589 n_1043_x vss sky130_fd_pr__nfet_01v8 W=0.84 L=0.15
Xn_1043_n2 n_1043_x x_mag38 vss vss sky130_fd_pr__nfet_01v8 W=0.84 L=0.15
Xn_1044_p1 n_1044 n_589 n_1044_x vdd sky130_fd_pr__pfet_01v8 W=1.4 L=0.15
Xn_1044_p2 n_1044_x x_mag38 vdd vdd sky130_fd_pr__pfet_01v8 W=1.4 L=0.15
Xn_1044_n1 n_1044 n_589 vss vss sky130_fd_pr__nfet_01v8 W=0.42 L=0.15
Xn_1044_n2 n_1044 x_mag38 vss vss sky130_fd_pr__nfet_01v8 W=0.42 L=0.15
Xn_1045_n n_1045 n_1044 vss vss sky130_fd_pr__nfet_01v8 W=0.42 L=0.15
Xn_1045_p n_1045 n_1044 vdd vdd sky130_fd_pr__pfet_01v8 W=0.7 L=0.15
Xn_1046_p1 n_1046 n_1042 vdd vdd sky130_fd_pr__pfet_01v8 W=0.7 L=0.15
Xn_1046_p2 n_1046 n_1045 vdd vdd sky130_fd_pr__pfet_01v8 W=0.7 L=0.15
Xn_1046_n1 n_1046 n_1042 n_1046_x vss sky130_fd_pr__nfet_01v8 W=0.84 L=0.15
Xn_1046_n2 n_1046_x n_1045 vss vss sky130_fd_pr__nfet_01v8 W=0.84 L=0.15
Xn_1047_p1 n_1047 n_1043 vdd vdd sky130_fd_pr__pfet_01v8 W=0.7 L=0.15
Xn_1047_p2 n_1047 n_1046 vdd vdd sky130_fd_pr__pfet_01v8 W=0.7 L=0.15
Xn_1047_n1 n_1047 n_1043 n_1047_x vss sky130_fd_pr__nfet_01v8 W=0.84 L=0.15
Xn_1047_n2 n_1047_x n_1046 vss vss sky130_fd_pr__nfet_01v8 W=0.84 L=0.15
Xn_1048_p1 n_1048 n_590 vdd vdd sky130_fd_pr__pfet_01v8 W=0.7 L=0.15
Xn_1048_p2 n_1048 x_mag39 vdd vdd sky130_fd_pr__pfet_01v8 W=0.7 L=0.15
Xn_1048_n1 n_1048 n_590 n_1048_x vss sky130_fd_pr__nfet_01v8 W=0.84 L=0.15
Xn_1048_n2 n_1048_x x_mag39 vss vss sky130_fd_pr__nfet_01v8 W=0.84 L=0.15
Xn_1049_p1 n_1049 n_590 n_1049_x vdd sky130_fd_pr__pfet_01v8 W=1.4 L=0.15
Xn_1049_p2 n_1049_x x_mag39 vdd vdd sky130_fd_pr__pfet_01v8 W=1.4 L=0.15
Xn_1049_n1 n_1049 n_590 vss vss sky130_fd_pr__nfet_01v8 W=0.42 L=0.15
Xn_1049_n2 n_1049 x_mag39 vss vss sky130_fd_pr__nfet_01v8 W=0.42 L=0.15
Xn_1050_n n_1050 n_1049 vss vss sky130_fd_pr__nfet_01v8 W=0.42 L=0.15
Xn_1050_p n_1050 n_1049 vdd vdd sky130_fd_pr__pfet_01v8 W=0.7 L=0.15
Xn_1051_p1 n_1051 n_1047 vdd vdd sky130_fd_pr__pfet_01v8 W=0.7 L=0.15
Xn_1051_p2 n_1051 n_1050 vdd vdd sky130_fd_pr__pfet_01v8 W=0.7 L=0.15
Xn_1051_n1 n_1051 n_1047 n_1051_x vss sky130_fd_pr__nfet_01v8 W=0.84 L=0.15
Xn_1051_n2 n_1051_x n_1050 vss vss sky130_fd_pr__nfet_01v8 W=0.84 L=0.15
Xn_1052_p1 n_1052 n_1048 vdd vdd sky130_fd_pr__pfet_01v8 W=0.7 L=0.15
Xn_1052_p2 n_1052 n_1051 vdd vdd sky130_fd_pr__pfet_01v8 W=0.7 L=0.15
Xn_1052_n1 n_1052 n_1048 n_1052_x vss sky130_fd_pr__nfet_01v8 W=0.84 L=0.15
Xn_1052_n2 n_1052_x n_1051 vss vss sky130_fd_pr__nfet_01v8 W=0.84 L=0.15
Xn_1053_p1 n_1053 n_403 vdd vdd sky130_fd_pr__pfet_01v8 W=0.7 L=0.15
Xn_1053_p2 n_1053 n_1052 vdd vdd sky130_fd_pr__pfet_01v8 W=0.7 L=0.15
Xn_1053_n1 n_1053 n_403 n_1053_x vss sky130_fd_pr__nfet_01v8 W=0.84 L=0.15
Xn_1053_n2 n_1053_x n_1052 vss vss sky130_fd_pr__nfet_01v8 W=0.84 L=0.15
Xn_1054_n n_1054 n_1053 vss vss sky130_fd_pr__nfet_01v8 W=0.42 L=0.15
Xn_1054_p n_1054 n_1053 vdd vdd sky130_fd_pr__pfet_01v8 W=0.7 L=0.15
Xn_1055_p1 n_1055 n_440 vdd vdd sky130_fd_pr__pfet_01v8 W=0.7 L=0.15
Xn_1055_p2 n_1055 n_1054 vdd vdd sky130_fd_pr__pfet_01v8 W=0.7 L=0.15
Xn_1055_n1 n_1055 n_440 n_1055_x vss sky130_fd_pr__nfet_01v8 W=0.84 L=0.15
Xn_1055_n2 n_1055_x n_1054 vss vss sky130_fd_pr__nfet_01v8 W=0.84 L=0.15
Xn_1056_p1 n_1056 n_591 vdd vdd sky130_fd_pr__pfet_01v8 W=0.7 L=0.15
Xn_1056_p2 n_1056 env9 vdd vdd sky130_fd_pr__pfet_01v8 W=0.7 L=0.15
Xn_1056_n1 n_1056 n_591 n_1056_x vss sky130_fd_pr__nfet_01v8 W=0.84 L=0.15
Xn_1056_n2 n_1056_x env9 vss vss sky130_fd_pr__nfet_01v8 W=0.84 L=0.15
Xn_1057_p1 n_1057 n_1055 vdd vdd sky130_fd_pr__pfet_01v8 W=0.7 L=0.15
Xn_1057_p2 n_1057 n_1056 vdd vdd sky130_fd_pr__pfet_01v8 W=0.7 L=0.15
Xn_1057_n1 n_1057 n_1055 n_1057_x vss sky130_fd_pr__nfet_01v8 W=0.84 L=0.15
Xn_1057_n2 n_1057_x n_1056 vss vss sky130_fd_pr__nfet_01v8 W=0.84 L=0.15
Xn_1058_n n_1058 n_1057 vss vss sky130_fd_pr__nfet_01v8 W=0.42 L=0.15
Xn_1058_p n_1058 n_1057 vdd vdd sky130_fd_pr__pfet_01v8 W=0.7 L=0.15
Xn_1059_p1 n_1059 n_1057 n_1059_x vdd sky130_fd_pr__pfet_01v8 W=1.4 L=0.15
Xn_1059_p2 n_1059_x n_202 vdd vdd sky130_fd_pr__pfet_01v8 W=1.4 L=0.15
Xn_1059_n1 n_1059 n_1057 vss vss sky130_fd_pr__nfet_01v8 W=0.42 L=0.15
Xn_1059_n2 n_1059 n_202 vss vss sky130_fd_pr__nfet_01v8 W=0.42 L=0.15
Xn_1060_p1 n_1060 n_1059 n_1060_x vdd sky130_fd_pr__pfet_01v8 W=1.4 L=0.15
Xn_1060_p2 n_1060_x n_4 vdd vdd sky130_fd_pr__pfet_01v8 W=1.4 L=0.15
Xn_1060_n1 n_1060 n_1059 vss vss sky130_fd_pr__nfet_01v8 W=0.42 L=0.15
Xn_1060_n2 n_1060 n_4 vss vss sky130_fd_pr__nfet_01v8 W=0.42 L=0.15
Xn_1061_n n_1061 n_1060 vss vss sky130_fd_pr__nfet_01v8 W=0.42 L=0.15
Xn_1061_p n_1061 n_1060 vdd vdd sky130_fd_pr__pfet_01v8 W=0.7 L=0.15
Xn_1064_p1 n_1064 n_1058 n_1064_x vdd sky130_fd_pr__pfet_01v8 W=1.4 L=0.15
Xn_1064_p2 n_1064_x n_202 vdd vdd sky130_fd_pr__pfet_01v8 W=1.4 L=0.15
Xn_1064_n1 n_1064 n_1058 vss vss sky130_fd_pr__nfet_01v8 W=0.42 L=0.15
Xn_1064_n2 n_1064 n_202 vss vss sky130_fd_pr__nfet_01v8 W=0.42 L=0.15
Xn_1063_p1 n_1063 n_1064 n_1063_x vdd sky130_fd_pr__pfet_01v8 W=1.4 L=0.15
Xn_1063_p2 n_1063_x n_1062 vdd vdd sky130_fd_pr__pfet_01v8 W=1.4 L=0.15
Xn_1063_n1 n_1063 n_1064 vss vss sky130_fd_pr__nfet_01v8 W=0.42 L=0.15
Xn_1063_n2 n_1063 n_1062 vss vss sky130_fd_pr__nfet_01v8 W=0.42 L=0.15
Xn_1062_p1 n_1062 n_1061 n_1062_x vdd sky130_fd_pr__pfet_01v8 W=1.4 L=0.15
Xn_1062_p2 n_1062_x n_1063 vdd vdd sky130_fd_pr__pfet_01v8 W=1.4 L=0.15
Xn_1062_n1 n_1062 n_1061 vss vss sky130_fd_pr__nfet_01v8 W=0.42 L=0.15
Xn_1062_n2 n_1062 n_1063 vss vss sky130_fd_pr__nfet_01v8 W=0.42 L=0.15
Xn_1065_p1 n_1065 n_1062 n_1065_x vdd sky130_fd_pr__pfet_01v8 W=1.4 L=0.15
Xn_1065_p2 n_1065_x n_205 vdd vdd sky130_fd_pr__pfet_01v8 W=1.4 L=0.15
Xn_1065_n1 n_1065 n_1062 vss vss sky130_fd_pr__nfet_01v8 W=0.42 L=0.15
Xn_1065_n2 n_1065 n_205 vss vss sky130_fd_pr__nfet_01v8 W=0.42 L=0.15
Xn_1066_p1 n_1066 n_1065 n_1066_x vdd sky130_fd_pr__pfet_01v8 W=1.4 L=0.15
Xn_1066_p2 n_1066_x n_4 vdd vdd sky130_fd_pr__pfet_01v8 W=1.4 L=0.15
Xn_1066_n1 n_1066 n_1065 vss vss sky130_fd_pr__nfet_01v8 W=0.42 L=0.15
Xn_1066_n2 n_1066 n_4 vss vss sky130_fd_pr__nfet_01v8 W=0.42 L=0.15
Xn_1067_n n_1067 n_1066 vss vss sky130_fd_pr__nfet_01v8 W=0.42 L=0.15
Xn_1067_p n_1067 n_1066 vdd vdd sky130_fd_pr__pfet_01v8 W=0.7 L=0.15
Xn_1069_p1 n_1069 n_1063 n_1069_x vdd sky130_fd_pr__pfet_01v8 W=1.4 L=0.15
Xn_1069_p2 n_1069_x n_205 vdd vdd sky130_fd_pr__pfet_01v8 W=1.4 L=0.15
Xn_1069_n1 n_1069 n_1063 vss vss sky130_fd_pr__nfet_01v8 W=0.42 L=0.15
Xn_1069_n2 n_1069 n_205 vss vss sky130_fd_pr__nfet_01v8 W=0.42 L=0.15
Xn_1068_p1 n_1068 n_1069 n_1068_x vdd sky130_fd_pr__pfet_01v8 W=1.4 L=0.15
Xn_1068_p2 n_1068_x env9 vdd vdd sky130_fd_pr__pfet_01v8 W=1.4 L=0.15
Xn_1068_n1 n_1068 n_1069 vss vss sky130_fd_pr__nfet_01v8 W=0.42 L=0.15
Xn_1068_n2 n_1068 env9 vss vss sky130_fd_pr__nfet_01v8 W=0.42 L=0.15
Xenv9_p1 env9 n_1067 env9_x vdd sky130_fd_pr__pfet_01v8 W=1.4 L=0.15
Xenv9_p2 env9_x n_1068 vdd vdd sky130_fd_pr__pfet_01v8 W=1.4 L=0.15
Xenv9_n1 env9 n_1067 vss vss sky130_fd_pr__nfet_01v8 W=0.42 L=0.15
Xenv9_n2 env9 n_1068 vss vss sky130_fd_pr__nfet_01v8 W=0.42 L=0.15
Xn_1070_n n_1070 env9 vss vss sky130_fd_pr__nfet_01v8 W=0.42 L=0.15
Xn_1070_p n_1070 env9 vdd vdd sky130_fd_pr__pfet_01v8 W=0.7 L=0.15
Xn_1071_p1 n_1071 env9 vdd vdd sky130_fd_pr__pfet_01v8 W=0.7 L=0.15
Xn_1071_p2 n_1071 n_594 vdd vdd sky130_fd_pr__pfet_01v8 W=0.7 L=0.15
Xn_1071_n1 n_1071 env9 n_1071_x vss sky130_fd_pr__nfet_01v8 W=0.84 L=0.15
Xn_1071_n2 n_1071_x n_594 vss vss sky130_fd_pr__nfet_01v8 W=0.84 L=0.15
Xn_1072_n n_1072 n_1071 vss vss sky130_fd_pr__nfet_01v8 W=0.42 L=0.15
Xn_1072_p n_1072 n_1071 vdd vdd sky130_fd_pr__pfet_01v8 W=0.7 L=0.15
Xn_1073_p1 n_1073 n_1070 vdd vdd sky130_fd_pr__pfet_01v8 W=0.7 L=0.15
Xn_1073_p2 n_1073 n_594 vdd vdd sky130_fd_pr__pfet_01v8 W=0.7 L=0.15
Xn_1073_n1 n_1073 n_1070 n_1073_x vss sky130_fd_pr__nfet_01v8 W=0.84 L=0.15
Xn_1073_n2 n_1073_x n_594 vss vss sky130_fd_pr__nfet_01v8 W=0.84 L=0.15
Xn_1074_n n_1074 n_1073 vss vss sky130_fd_pr__nfet_01v8 W=0.42 L=0.15
Xn_1074_p n_1074 n_1073 vdd vdd sky130_fd_pr__pfet_01v8 W=0.7 L=0.15
Xn_1075_p1 n_1075 n_1074 n_1075_x vdd sky130_fd_pr__pfet_01v8 W=1.4 L=0.15
Xn_1075_p2 n_1075_x n_4 vdd vdd sky130_fd_pr__pfet_01v8 W=1.4 L=0.15
Xn_1075_n1 n_1075 n_1074 vss vss sky130_fd_pr__nfet_01v8 W=0.42 L=0.15
Xn_1075_n2 n_1075 n_4 vss vss sky130_fd_pr__nfet_01v8 W=0.42 L=0.15
Xn_1076_n n_1076 n_1075 vss vss sky130_fd_pr__nfet_01v8 W=0.42 L=0.15
Xn_1076_p n_1076 n_1075 vdd vdd sky130_fd_pr__pfet_01v8 W=0.7 L=0.15
Xn_1078_p1 n_1078 n_1072 n_1078_x vdd sky130_fd_pr__pfet_01v8 W=1.4 L=0.15
Xn_1078_p2 n_1078_x n_1077 vdd vdd sky130_fd_pr__pfet_01v8 W=1.4 L=0.15
Xn_1078_n1 n_1078 n_1072 vss vss sky130_fd_pr__nfet_01v8 W=0.42 L=0.15
Xn_1078_n2 n_1078 n_1077 vss vss sky130_fd_pr__nfet_01v8 W=0.42 L=0.15
Xn_1077_p1 n_1077 n_1076 n_1077_x vdd sky130_fd_pr__pfet_01v8 W=1.4 L=0.15
Xn_1077_p2 n_1077_x n_1078 vdd vdd sky130_fd_pr__pfet_01v8 W=1.4 L=0.15
Xn_1077_n1 n_1077 n_1076 vss vss sky130_fd_pr__nfet_01v8 W=0.42 L=0.15
Xn_1077_n2 n_1077 n_1078 vss vss sky130_fd_pr__nfet_01v8 W=0.42 L=0.15
Xn_1079_n n_1079 n_1077 vss vss sky130_fd_pr__nfet_01v8 W=0.42 L=0.15
Xn_1079_p n_1079 n_1077 vdd vdd sky130_fd_pr__pfet_01v8 W=0.7 L=0.15
Xn_1080_n n_1080 n_1079 vss vss sky130_fd_pr__nfet_01v8 W=0.42 L=0.15
Xn_1080_p n_1080 n_1079 vdd vdd sky130_fd_pr__pfet_01v8 W=0.7 L=0.15
Xn_1081_n n_1081 x_neg9 vss vss sky130_fd_pr__nfet_01v8 W=0.42 L=0.15
Xn_1081_p n_1081 x_neg9 vdd vdd sky130_fd_pr__pfet_01v8 W=0.7 L=0.15
Xn_1082_p1 n_1082 n_1080 vdd vdd sky130_fd_pr__pfet_01v8 W=0.7 L=0.15
Xn_1082_p2 n_1082 n_1081 vdd vdd sky130_fd_pr__pfet_01v8 W=0.7 L=0.15
Xn_1082_n1 n_1082 n_1080 n_1082_x vss sky130_fd_pr__nfet_01v8 W=0.84 L=0.15
Xn_1082_n2 n_1082_x n_1081 vss vss sky130_fd_pr__nfet_01v8 W=0.84 L=0.15
Xxin_p_r9_n xin_p_r9 n_1082 vss vss sky130_fd_pr__nfet_01v8 W=0.42 L=0.15
Xxin_p_r9_p xin_p_r9 n_1082 vdd vdd sky130_fd_pr__pfet_01v8 W=0.7 L=0.15
Xn_1083_p1 n_1083 n_1080 vdd vdd sky130_fd_pr__pfet_01v8 W=0.7 L=0.15
Xn_1083_p2 n_1083 x_neg9 vdd vdd sky130_fd_pr__pfet_01v8 W=0.7 L=0.15
Xn_1083_n1 n_1083 n_1080 n_1083_x vss sky130_fd_pr__nfet_01v8 W=0.84 L=0.15
Xn_1083_n2 n_1083_x x_neg9 vss vss sky130_fd_pr__nfet_01v8 W=0.84 L=0.15
Xxin_n_r9_n xin_n_r9 n_1083 vss vss sky130_fd_pr__nfet_01v8 W=0.42 L=0.15
Xxin_n_r9_p xin_n_r9 n_1083 vdd vdd sky130_fd_pr__pfet_01v8 W=0.7 L=0.15
Xn_1084_p1 n_1084 n_1080 vdd vdd sky130_fd_pr__pfet_01v8 W=0.7 L=0.15
Xn_1084_p2 n_1084 lora_en vdd vdd sky130_fd_pr__pfet_01v8 W=0.7 L=0.15
Xn_1084_n1 n_1084 n_1080 n_1084_x vss sky130_fd_pr__nfet_01v8 W=0.84 L=0.15
Xn_1084_n2 n_1084_x lora_en vss vss sky130_fd_pr__nfet_01v8 W=0.84 L=0.15
Xxrd_en9_n xrd_en9 n_1084 vss vss sky130_fd_pr__nfet_01v8 W=0.42 L=0.15
Xxrd_en9_p xrd_en9 n_1084 vdd vdd sky130_fd_pr__pfet_01v8 W=0.7 L=0.15
Xn_1085_p1 n_1085 n_587 vdd vdd sky130_fd_pr__pfet_01v8 W=0.7 L=0.15
Xn_1085_p2 n_1085 x_mag40 vdd vdd sky130_fd_pr__pfet_01v8 W=0.7 L=0.15
Xn_1085_n1 n_1085 n_587 n_1085_x vss sky130_fd_pr__nfet_01v8 W=0.84 L=0.15
Xn_1085_n2 n_1085_x x_mag40 vss vss sky130_fd_pr__nfet_01v8 W=0.84 L=0.15
Xn_1086_n n_1086 n_1085 vss vss sky130_fd_pr__nfet_01v8 W=0.42 L=0.15
Xn_1086_p n_1086 n_1085 vdd vdd sky130_fd_pr__pfet_01v8 W=0.7 L=0.15
Xn_1087_p1 n_1087 n_588 vdd vdd sky130_fd_pr__pfet_01v8 W=0.7 L=0.15
Xn_1087_p2 n_1087 x_mag41 vdd vdd sky130_fd_pr__pfet_01v8 W=0.7 L=0.15
Xn_1087_n1 n_1087 n_588 n_1087_x vss sky130_fd_pr__nfet_01v8 W=0.84 L=0.15
Xn_1087_n2 n_1087_x x_mag41 vss vss sky130_fd_pr__nfet_01v8 W=0.84 L=0.15
Xn_1088_p1 n_1088 n_588 n_1088_x vdd sky130_fd_pr__pfet_01v8 W=1.4 L=0.15
Xn_1088_p2 n_1088_x x_mag41 vdd vdd sky130_fd_pr__pfet_01v8 W=1.4 L=0.15
Xn_1088_n1 n_1088 n_588 vss vss sky130_fd_pr__nfet_01v8 W=0.42 L=0.15
Xn_1088_n2 n_1088 x_mag41 vss vss sky130_fd_pr__nfet_01v8 W=0.42 L=0.15
Xn_1089_n n_1089 n_1088 vss vss sky130_fd_pr__nfet_01v8 W=0.42 L=0.15
Xn_1089_p n_1089 n_1088 vdd vdd sky130_fd_pr__pfet_01v8 W=0.7 L=0.15
Xn_1090_p1 n_1090 n_1086 vdd vdd sky130_fd_pr__pfet_01v8 W=0.7 L=0.15
Xn_1090_p2 n_1090 n_1089 vdd vdd sky130_fd_pr__pfet_01v8 W=0.7 L=0.15
Xn_1090_n1 n_1090 n_1086 n_1090_x vss sky130_fd_pr__nfet_01v8 W=0.84 L=0.15
Xn_1090_n2 n_1090_x n_1089 vss vss sky130_fd_pr__nfet_01v8 W=0.84 L=0.15
Xn_1091_p1 n_1091 n_1087 vdd vdd sky130_fd_pr__pfet_01v8 W=0.7 L=0.15
Xn_1091_p2 n_1091 n_1090 vdd vdd sky130_fd_pr__pfet_01v8 W=0.7 L=0.15
Xn_1091_n1 n_1091 n_1087 n_1091_x vss sky130_fd_pr__nfet_01v8 W=0.84 L=0.15
Xn_1091_n2 n_1091_x n_1090 vss vss sky130_fd_pr__nfet_01v8 W=0.84 L=0.15
Xn_1092_p1 n_1092 n_589 vdd vdd sky130_fd_pr__pfet_01v8 W=0.7 L=0.15
Xn_1092_p2 n_1092 x_mag42 vdd vdd sky130_fd_pr__pfet_01v8 W=0.7 L=0.15
Xn_1092_n1 n_1092 n_589 n_1092_x vss sky130_fd_pr__nfet_01v8 W=0.84 L=0.15
Xn_1092_n2 n_1092_x x_mag42 vss vss sky130_fd_pr__nfet_01v8 W=0.84 L=0.15
Xn_1093_p1 n_1093 n_589 n_1093_x vdd sky130_fd_pr__pfet_01v8 W=1.4 L=0.15
Xn_1093_p2 n_1093_x x_mag42 vdd vdd sky130_fd_pr__pfet_01v8 W=1.4 L=0.15
Xn_1093_n1 n_1093 n_589 vss vss sky130_fd_pr__nfet_01v8 W=0.42 L=0.15
Xn_1093_n2 n_1093 x_mag42 vss vss sky130_fd_pr__nfet_01v8 W=0.42 L=0.15
Xn_1094_n n_1094 n_1093 vss vss sky130_fd_pr__nfet_01v8 W=0.42 L=0.15
Xn_1094_p n_1094 n_1093 vdd vdd sky130_fd_pr__pfet_01v8 W=0.7 L=0.15
Xn_1095_p1 n_1095 n_1091 vdd vdd sky130_fd_pr__pfet_01v8 W=0.7 L=0.15
Xn_1095_p2 n_1095 n_1094 vdd vdd sky130_fd_pr__pfet_01v8 W=0.7 L=0.15
Xn_1095_n1 n_1095 n_1091 n_1095_x vss sky130_fd_pr__nfet_01v8 W=0.84 L=0.15
Xn_1095_n2 n_1095_x n_1094 vss vss sky130_fd_pr__nfet_01v8 W=0.84 L=0.15
Xn_1096_p1 n_1096 n_1092 vdd vdd sky130_fd_pr__pfet_01v8 W=0.7 L=0.15
Xn_1096_p2 n_1096 n_1095 vdd vdd sky130_fd_pr__pfet_01v8 W=0.7 L=0.15
Xn_1096_n1 n_1096 n_1092 n_1096_x vss sky130_fd_pr__nfet_01v8 W=0.84 L=0.15
Xn_1096_n2 n_1096_x n_1095 vss vss sky130_fd_pr__nfet_01v8 W=0.84 L=0.15
Xn_1097_p1 n_1097 n_590 vdd vdd sky130_fd_pr__pfet_01v8 W=0.7 L=0.15
Xn_1097_p2 n_1097 x_mag43 vdd vdd sky130_fd_pr__pfet_01v8 W=0.7 L=0.15
Xn_1097_n1 n_1097 n_590 n_1097_x vss sky130_fd_pr__nfet_01v8 W=0.84 L=0.15
Xn_1097_n2 n_1097_x x_mag43 vss vss sky130_fd_pr__nfet_01v8 W=0.84 L=0.15
Xn_1098_p1 n_1098 n_590 n_1098_x vdd sky130_fd_pr__pfet_01v8 W=1.4 L=0.15
Xn_1098_p2 n_1098_x x_mag43 vdd vdd sky130_fd_pr__pfet_01v8 W=1.4 L=0.15
Xn_1098_n1 n_1098 n_590 vss vss sky130_fd_pr__nfet_01v8 W=0.42 L=0.15
Xn_1098_n2 n_1098 x_mag43 vss vss sky130_fd_pr__nfet_01v8 W=0.42 L=0.15
Xn_1099_n n_1099 n_1098 vss vss sky130_fd_pr__nfet_01v8 W=0.42 L=0.15
Xn_1099_p n_1099 n_1098 vdd vdd sky130_fd_pr__pfet_01v8 W=0.7 L=0.15
Xn_1100_p1 n_1100 n_1096 vdd vdd sky130_fd_pr__pfet_01v8 W=0.7 L=0.15
Xn_1100_p2 n_1100 n_1099 vdd vdd sky130_fd_pr__pfet_01v8 W=0.7 L=0.15
Xn_1100_n1 n_1100 n_1096 n_1100_x vss sky130_fd_pr__nfet_01v8 W=0.84 L=0.15
Xn_1100_n2 n_1100_x n_1099 vss vss sky130_fd_pr__nfet_01v8 W=0.84 L=0.15
Xn_1101_p1 n_1101 n_1097 vdd vdd sky130_fd_pr__pfet_01v8 W=0.7 L=0.15
Xn_1101_p2 n_1101 n_1100 vdd vdd sky130_fd_pr__pfet_01v8 W=0.7 L=0.15
Xn_1101_n1 n_1101 n_1097 n_1101_x vss sky130_fd_pr__nfet_01v8 W=0.84 L=0.15
Xn_1101_n2 n_1101_x n_1100 vss vss sky130_fd_pr__nfet_01v8 W=0.84 L=0.15
Xn_1102_p1 n_1102 n_403 vdd vdd sky130_fd_pr__pfet_01v8 W=0.7 L=0.15
Xn_1102_p2 n_1102 n_1101 vdd vdd sky130_fd_pr__pfet_01v8 W=0.7 L=0.15
Xn_1102_n1 n_1102 n_403 n_1102_x vss sky130_fd_pr__nfet_01v8 W=0.84 L=0.15
Xn_1102_n2 n_1102_x n_1101 vss vss sky130_fd_pr__nfet_01v8 W=0.84 L=0.15
Xn_1103_n n_1103 n_1102 vss vss sky130_fd_pr__nfet_01v8 W=0.42 L=0.15
Xn_1103_p n_1103 n_1102 vdd vdd sky130_fd_pr__pfet_01v8 W=0.7 L=0.15
Xn_1104_p1 n_1104 n_440 vdd vdd sky130_fd_pr__pfet_01v8 W=0.7 L=0.15
Xn_1104_p2 n_1104 n_1103 vdd vdd sky130_fd_pr__pfet_01v8 W=0.7 L=0.15
Xn_1104_n1 n_1104 n_440 n_1104_x vss sky130_fd_pr__nfet_01v8 W=0.84 L=0.15
Xn_1104_n2 n_1104_x n_1103 vss vss sky130_fd_pr__nfet_01v8 W=0.84 L=0.15
Xn_1105_p1 n_1105 n_591 vdd vdd sky130_fd_pr__pfet_01v8 W=0.7 L=0.15
Xn_1105_p2 n_1105 env10 vdd vdd sky130_fd_pr__pfet_01v8 W=0.7 L=0.15
Xn_1105_n1 n_1105 n_591 n_1105_x vss sky130_fd_pr__nfet_01v8 W=0.84 L=0.15
Xn_1105_n2 n_1105_x env10 vss vss sky130_fd_pr__nfet_01v8 W=0.84 L=0.15
Xn_1106_p1 n_1106 n_1104 vdd vdd sky130_fd_pr__pfet_01v8 W=0.7 L=0.15
Xn_1106_p2 n_1106 n_1105 vdd vdd sky130_fd_pr__pfet_01v8 W=0.7 L=0.15
Xn_1106_n1 n_1106 n_1104 n_1106_x vss sky130_fd_pr__nfet_01v8 W=0.84 L=0.15
Xn_1106_n2 n_1106_x n_1105 vss vss sky130_fd_pr__nfet_01v8 W=0.84 L=0.15
Xn_1107_n n_1107 n_1106 vss vss sky130_fd_pr__nfet_01v8 W=0.42 L=0.15
Xn_1107_p n_1107 n_1106 vdd vdd sky130_fd_pr__pfet_01v8 W=0.7 L=0.15
Xn_1108_p1 n_1108 n_1106 n_1108_x vdd sky130_fd_pr__pfet_01v8 W=1.4 L=0.15
Xn_1108_p2 n_1108_x n_202 vdd vdd sky130_fd_pr__pfet_01v8 W=1.4 L=0.15
Xn_1108_n1 n_1108 n_1106 vss vss sky130_fd_pr__nfet_01v8 W=0.42 L=0.15
Xn_1108_n2 n_1108 n_202 vss vss sky130_fd_pr__nfet_01v8 W=0.42 L=0.15
Xn_1109_p1 n_1109 n_1108 n_1109_x vdd sky130_fd_pr__pfet_01v8 W=1.4 L=0.15
Xn_1109_p2 n_1109_x n_4 vdd vdd sky130_fd_pr__pfet_01v8 W=1.4 L=0.15
Xn_1109_n1 n_1109 n_1108 vss vss sky130_fd_pr__nfet_01v8 W=0.42 L=0.15
Xn_1109_n2 n_1109 n_4 vss vss sky130_fd_pr__nfet_01v8 W=0.42 L=0.15
Xn_1110_n n_1110 n_1109 vss vss sky130_fd_pr__nfet_01v8 W=0.42 L=0.15
Xn_1110_p n_1110 n_1109 vdd vdd sky130_fd_pr__pfet_01v8 W=0.7 L=0.15
Xn_1113_p1 n_1113 n_1107 n_1113_x vdd sky130_fd_pr__pfet_01v8 W=1.4 L=0.15
Xn_1113_p2 n_1113_x n_202 vdd vdd sky130_fd_pr__pfet_01v8 W=1.4 L=0.15
Xn_1113_n1 n_1113 n_1107 vss vss sky130_fd_pr__nfet_01v8 W=0.42 L=0.15
Xn_1113_n2 n_1113 n_202 vss vss sky130_fd_pr__nfet_01v8 W=0.42 L=0.15
Xn_1112_p1 n_1112 n_1113 n_1112_x vdd sky130_fd_pr__pfet_01v8 W=1.4 L=0.15
Xn_1112_p2 n_1112_x n_1111 vdd vdd sky130_fd_pr__pfet_01v8 W=1.4 L=0.15
Xn_1112_n1 n_1112 n_1113 vss vss sky130_fd_pr__nfet_01v8 W=0.42 L=0.15
Xn_1112_n2 n_1112 n_1111 vss vss sky130_fd_pr__nfet_01v8 W=0.42 L=0.15
Xn_1111_p1 n_1111 n_1110 n_1111_x vdd sky130_fd_pr__pfet_01v8 W=1.4 L=0.15
Xn_1111_p2 n_1111_x n_1112 vdd vdd sky130_fd_pr__pfet_01v8 W=1.4 L=0.15
Xn_1111_n1 n_1111 n_1110 vss vss sky130_fd_pr__nfet_01v8 W=0.42 L=0.15
Xn_1111_n2 n_1111 n_1112 vss vss sky130_fd_pr__nfet_01v8 W=0.42 L=0.15
Xn_1114_p1 n_1114 n_1111 n_1114_x vdd sky130_fd_pr__pfet_01v8 W=1.4 L=0.15
Xn_1114_p2 n_1114_x n_205 vdd vdd sky130_fd_pr__pfet_01v8 W=1.4 L=0.15
Xn_1114_n1 n_1114 n_1111 vss vss sky130_fd_pr__nfet_01v8 W=0.42 L=0.15
Xn_1114_n2 n_1114 n_205 vss vss sky130_fd_pr__nfet_01v8 W=0.42 L=0.15
Xn_1115_p1 n_1115 n_1114 n_1115_x vdd sky130_fd_pr__pfet_01v8 W=1.4 L=0.15
Xn_1115_p2 n_1115_x n_4 vdd vdd sky130_fd_pr__pfet_01v8 W=1.4 L=0.15
Xn_1115_n1 n_1115 n_1114 vss vss sky130_fd_pr__nfet_01v8 W=0.42 L=0.15
Xn_1115_n2 n_1115 n_4 vss vss sky130_fd_pr__nfet_01v8 W=0.42 L=0.15
Xn_1116_n n_1116 n_1115 vss vss sky130_fd_pr__nfet_01v8 W=0.42 L=0.15
Xn_1116_p n_1116 n_1115 vdd vdd sky130_fd_pr__pfet_01v8 W=0.7 L=0.15
Xn_1118_p1 n_1118 n_1112 n_1118_x vdd sky130_fd_pr__pfet_01v8 W=1.4 L=0.15
Xn_1118_p2 n_1118_x n_205 vdd vdd sky130_fd_pr__pfet_01v8 W=1.4 L=0.15
Xn_1118_n1 n_1118 n_1112 vss vss sky130_fd_pr__nfet_01v8 W=0.42 L=0.15
Xn_1118_n2 n_1118 n_205 vss vss sky130_fd_pr__nfet_01v8 W=0.42 L=0.15
Xn_1117_p1 n_1117 n_1118 n_1117_x vdd sky130_fd_pr__pfet_01v8 W=1.4 L=0.15
Xn_1117_p2 n_1117_x env10 vdd vdd sky130_fd_pr__pfet_01v8 W=1.4 L=0.15
Xn_1117_n1 n_1117 n_1118 vss vss sky130_fd_pr__nfet_01v8 W=0.42 L=0.15
Xn_1117_n2 n_1117 env10 vss vss sky130_fd_pr__nfet_01v8 W=0.42 L=0.15
Xenv10_p1 env10 n_1116 env10_x vdd sky130_fd_pr__pfet_01v8 W=1.4 L=0.15
Xenv10_p2 env10_x n_1117 vdd vdd sky130_fd_pr__pfet_01v8 W=1.4 L=0.15
Xenv10_n1 env10 n_1116 vss vss sky130_fd_pr__nfet_01v8 W=0.42 L=0.15
Xenv10_n2 env10 n_1117 vss vss sky130_fd_pr__nfet_01v8 W=0.42 L=0.15
Xn_1119_n n_1119 env10 vss vss sky130_fd_pr__nfet_01v8 W=0.42 L=0.15
Xn_1119_p n_1119 env10 vdd vdd sky130_fd_pr__pfet_01v8 W=0.7 L=0.15
Xn_1120_p1 n_1120 env10 vdd vdd sky130_fd_pr__pfet_01v8 W=0.7 L=0.15
Xn_1120_p2 n_1120 n_594 vdd vdd sky130_fd_pr__pfet_01v8 W=0.7 L=0.15
Xn_1120_n1 n_1120 env10 n_1120_x vss sky130_fd_pr__nfet_01v8 W=0.84 L=0.15
Xn_1120_n2 n_1120_x n_594 vss vss sky130_fd_pr__nfet_01v8 W=0.84 L=0.15
Xn_1121_n n_1121 n_1120 vss vss sky130_fd_pr__nfet_01v8 W=0.42 L=0.15
Xn_1121_p n_1121 n_1120 vdd vdd sky130_fd_pr__pfet_01v8 W=0.7 L=0.15
Xn_1122_p1 n_1122 n_1119 vdd vdd sky130_fd_pr__pfet_01v8 W=0.7 L=0.15
Xn_1122_p2 n_1122 n_594 vdd vdd sky130_fd_pr__pfet_01v8 W=0.7 L=0.15
Xn_1122_n1 n_1122 n_1119 n_1122_x vss sky130_fd_pr__nfet_01v8 W=0.84 L=0.15
Xn_1122_n2 n_1122_x n_594 vss vss sky130_fd_pr__nfet_01v8 W=0.84 L=0.15
Xn_1123_n n_1123 n_1122 vss vss sky130_fd_pr__nfet_01v8 W=0.42 L=0.15
Xn_1123_p n_1123 n_1122 vdd vdd sky130_fd_pr__pfet_01v8 W=0.7 L=0.15
Xn_1124_p1 n_1124 n_1123 n_1124_x vdd sky130_fd_pr__pfet_01v8 W=1.4 L=0.15
Xn_1124_p2 n_1124_x n_4 vdd vdd sky130_fd_pr__pfet_01v8 W=1.4 L=0.15
Xn_1124_n1 n_1124 n_1123 vss vss sky130_fd_pr__nfet_01v8 W=0.42 L=0.15
Xn_1124_n2 n_1124 n_4 vss vss sky130_fd_pr__nfet_01v8 W=0.42 L=0.15
Xn_1125_n n_1125 n_1124 vss vss sky130_fd_pr__nfet_01v8 W=0.42 L=0.15
Xn_1125_p n_1125 n_1124 vdd vdd sky130_fd_pr__pfet_01v8 W=0.7 L=0.15
Xn_1127_p1 n_1127 n_1121 n_1127_x vdd sky130_fd_pr__pfet_01v8 W=1.4 L=0.15
Xn_1127_p2 n_1127_x n_1126 vdd vdd sky130_fd_pr__pfet_01v8 W=1.4 L=0.15
Xn_1127_n1 n_1127 n_1121 vss vss sky130_fd_pr__nfet_01v8 W=0.42 L=0.15
Xn_1127_n2 n_1127 n_1126 vss vss sky130_fd_pr__nfet_01v8 W=0.42 L=0.15
Xn_1126_p1 n_1126 n_1125 n_1126_x vdd sky130_fd_pr__pfet_01v8 W=1.4 L=0.15
Xn_1126_p2 n_1126_x n_1127 vdd vdd sky130_fd_pr__pfet_01v8 W=1.4 L=0.15
Xn_1126_n1 n_1126 n_1125 vss vss sky130_fd_pr__nfet_01v8 W=0.42 L=0.15
Xn_1126_n2 n_1126 n_1127 vss vss sky130_fd_pr__nfet_01v8 W=0.42 L=0.15
Xn_1128_n n_1128 n_1126 vss vss sky130_fd_pr__nfet_01v8 W=0.42 L=0.15
Xn_1128_p n_1128 n_1126 vdd vdd sky130_fd_pr__pfet_01v8 W=0.7 L=0.15
Xn_1129_n n_1129 n_1128 vss vss sky130_fd_pr__nfet_01v8 W=0.42 L=0.15
Xn_1129_p n_1129 n_1128 vdd vdd sky130_fd_pr__pfet_01v8 W=0.7 L=0.15
Xn_1130_n n_1130 x_neg10 vss vss sky130_fd_pr__nfet_01v8 W=0.42 L=0.15
Xn_1130_p n_1130 x_neg10 vdd vdd sky130_fd_pr__pfet_01v8 W=0.7 L=0.15
Xn_1131_p1 n_1131 n_1129 vdd vdd sky130_fd_pr__pfet_01v8 W=0.7 L=0.15
Xn_1131_p2 n_1131 n_1130 vdd vdd sky130_fd_pr__pfet_01v8 W=0.7 L=0.15
Xn_1131_n1 n_1131 n_1129 n_1131_x vss sky130_fd_pr__nfet_01v8 W=0.84 L=0.15
Xn_1131_n2 n_1131_x n_1130 vss vss sky130_fd_pr__nfet_01v8 W=0.84 L=0.15
Xxin_p_r10_n xin_p_r10 n_1131 vss vss sky130_fd_pr__nfet_01v8 W=0.42 L=0.15
Xxin_p_r10_p xin_p_r10 n_1131 vdd vdd sky130_fd_pr__pfet_01v8 W=0.7 L=0.15
Xn_1132_p1 n_1132 n_1129 vdd vdd sky130_fd_pr__pfet_01v8 W=0.7 L=0.15
Xn_1132_p2 n_1132 x_neg10 vdd vdd sky130_fd_pr__pfet_01v8 W=0.7 L=0.15
Xn_1132_n1 n_1132 n_1129 n_1132_x vss sky130_fd_pr__nfet_01v8 W=0.84 L=0.15
Xn_1132_n2 n_1132_x x_neg10 vss vss sky130_fd_pr__nfet_01v8 W=0.84 L=0.15
Xxin_n_r10_n xin_n_r10 n_1132 vss vss sky130_fd_pr__nfet_01v8 W=0.42 L=0.15
Xxin_n_r10_p xin_n_r10 n_1132 vdd vdd sky130_fd_pr__pfet_01v8 W=0.7 L=0.15
Xn_1133_p1 n_1133 n_1129 vdd vdd sky130_fd_pr__pfet_01v8 W=0.7 L=0.15
Xn_1133_p2 n_1133 lora_en vdd vdd sky130_fd_pr__pfet_01v8 W=0.7 L=0.15
Xn_1133_n1 n_1133 n_1129 n_1133_x vss sky130_fd_pr__nfet_01v8 W=0.84 L=0.15
Xn_1133_n2 n_1133_x lora_en vss vss sky130_fd_pr__nfet_01v8 W=0.84 L=0.15
Xxrd_en10_n xrd_en10 n_1133 vss vss sky130_fd_pr__nfet_01v8 W=0.42 L=0.15
Xxrd_en10_p xrd_en10 n_1133 vdd vdd sky130_fd_pr__pfet_01v8 W=0.7 L=0.15
Xn_1134_p1 n_1134 n_587 vdd vdd sky130_fd_pr__pfet_01v8 W=0.7 L=0.15
Xn_1134_p2 n_1134 x_mag44 vdd vdd sky130_fd_pr__pfet_01v8 W=0.7 L=0.15
Xn_1134_n1 n_1134 n_587 n_1134_x vss sky130_fd_pr__nfet_01v8 W=0.84 L=0.15
Xn_1134_n2 n_1134_x x_mag44 vss vss sky130_fd_pr__nfet_01v8 W=0.84 L=0.15
Xn_1135_n n_1135 n_1134 vss vss sky130_fd_pr__nfet_01v8 W=0.42 L=0.15
Xn_1135_p n_1135 n_1134 vdd vdd sky130_fd_pr__pfet_01v8 W=0.7 L=0.15
Xn_1136_p1 n_1136 n_588 vdd vdd sky130_fd_pr__pfet_01v8 W=0.7 L=0.15
Xn_1136_p2 n_1136 x_mag45 vdd vdd sky130_fd_pr__pfet_01v8 W=0.7 L=0.15
Xn_1136_n1 n_1136 n_588 n_1136_x vss sky130_fd_pr__nfet_01v8 W=0.84 L=0.15
Xn_1136_n2 n_1136_x x_mag45 vss vss sky130_fd_pr__nfet_01v8 W=0.84 L=0.15
Xn_1137_p1 n_1137 n_588 n_1137_x vdd sky130_fd_pr__pfet_01v8 W=1.4 L=0.15
Xn_1137_p2 n_1137_x x_mag45 vdd vdd sky130_fd_pr__pfet_01v8 W=1.4 L=0.15
Xn_1137_n1 n_1137 n_588 vss vss sky130_fd_pr__nfet_01v8 W=0.42 L=0.15
Xn_1137_n2 n_1137 x_mag45 vss vss sky130_fd_pr__nfet_01v8 W=0.42 L=0.15
Xn_1138_n n_1138 n_1137 vss vss sky130_fd_pr__nfet_01v8 W=0.42 L=0.15
Xn_1138_p n_1138 n_1137 vdd vdd sky130_fd_pr__pfet_01v8 W=0.7 L=0.15
Xn_1139_p1 n_1139 n_1135 vdd vdd sky130_fd_pr__pfet_01v8 W=0.7 L=0.15
Xn_1139_p2 n_1139 n_1138 vdd vdd sky130_fd_pr__pfet_01v8 W=0.7 L=0.15
Xn_1139_n1 n_1139 n_1135 n_1139_x vss sky130_fd_pr__nfet_01v8 W=0.84 L=0.15
Xn_1139_n2 n_1139_x n_1138 vss vss sky130_fd_pr__nfet_01v8 W=0.84 L=0.15
Xn_1140_p1 n_1140 n_1136 vdd vdd sky130_fd_pr__pfet_01v8 W=0.7 L=0.15
Xn_1140_p2 n_1140 n_1139 vdd vdd sky130_fd_pr__pfet_01v8 W=0.7 L=0.15
Xn_1140_n1 n_1140 n_1136 n_1140_x vss sky130_fd_pr__nfet_01v8 W=0.84 L=0.15
Xn_1140_n2 n_1140_x n_1139 vss vss sky130_fd_pr__nfet_01v8 W=0.84 L=0.15
Xn_1141_p1 n_1141 n_589 vdd vdd sky130_fd_pr__pfet_01v8 W=0.7 L=0.15
Xn_1141_p2 n_1141 x_mag46 vdd vdd sky130_fd_pr__pfet_01v8 W=0.7 L=0.15
Xn_1141_n1 n_1141 n_589 n_1141_x vss sky130_fd_pr__nfet_01v8 W=0.84 L=0.15
Xn_1141_n2 n_1141_x x_mag46 vss vss sky130_fd_pr__nfet_01v8 W=0.84 L=0.15
Xn_1142_p1 n_1142 n_589 n_1142_x vdd sky130_fd_pr__pfet_01v8 W=1.4 L=0.15
Xn_1142_p2 n_1142_x x_mag46 vdd vdd sky130_fd_pr__pfet_01v8 W=1.4 L=0.15
Xn_1142_n1 n_1142 n_589 vss vss sky130_fd_pr__nfet_01v8 W=0.42 L=0.15
Xn_1142_n2 n_1142 x_mag46 vss vss sky130_fd_pr__nfet_01v8 W=0.42 L=0.15
Xn_1143_n n_1143 n_1142 vss vss sky130_fd_pr__nfet_01v8 W=0.42 L=0.15
Xn_1143_p n_1143 n_1142 vdd vdd sky130_fd_pr__pfet_01v8 W=0.7 L=0.15
Xn_1144_p1 n_1144 n_1140 vdd vdd sky130_fd_pr__pfet_01v8 W=0.7 L=0.15
Xn_1144_p2 n_1144 n_1143 vdd vdd sky130_fd_pr__pfet_01v8 W=0.7 L=0.15
Xn_1144_n1 n_1144 n_1140 n_1144_x vss sky130_fd_pr__nfet_01v8 W=0.84 L=0.15
Xn_1144_n2 n_1144_x n_1143 vss vss sky130_fd_pr__nfet_01v8 W=0.84 L=0.15
Xn_1145_p1 n_1145 n_1141 vdd vdd sky130_fd_pr__pfet_01v8 W=0.7 L=0.15
Xn_1145_p2 n_1145 n_1144 vdd vdd sky130_fd_pr__pfet_01v8 W=0.7 L=0.15
Xn_1145_n1 n_1145 n_1141 n_1145_x vss sky130_fd_pr__nfet_01v8 W=0.84 L=0.15
Xn_1145_n2 n_1145_x n_1144 vss vss sky130_fd_pr__nfet_01v8 W=0.84 L=0.15
Xn_1146_p1 n_1146 n_590 vdd vdd sky130_fd_pr__pfet_01v8 W=0.7 L=0.15
Xn_1146_p2 n_1146 x_mag47 vdd vdd sky130_fd_pr__pfet_01v8 W=0.7 L=0.15
Xn_1146_n1 n_1146 n_590 n_1146_x vss sky130_fd_pr__nfet_01v8 W=0.84 L=0.15
Xn_1146_n2 n_1146_x x_mag47 vss vss sky130_fd_pr__nfet_01v8 W=0.84 L=0.15
Xn_1147_p1 n_1147 n_590 n_1147_x vdd sky130_fd_pr__pfet_01v8 W=1.4 L=0.15
Xn_1147_p2 n_1147_x x_mag47 vdd vdd sky130_fd_pr__pfet_01v8 W=1.4 L=0.15
Xn_1147_n1 n_1147 n_590 vss vss sky130_fd_pr__nfet_01v8 W=0.42 L=0.15
Xn_1147_n2 n_1147 x_mag47 vss vss sky130_fd_pr__nfet_01v8 W=0.42 L=0.15
Xn_1148_n n_1148 n_1147 vss vss sky130_fd_pr__nfet_01v8 W=0.42 L=0.15
Xn_1148_p n_1148 n_1147 vdd vdd sky130_fd_pr__pfet_01v8 W=0.7 L=0.15
Xn_1149_p1 n_1149 n_1145 vdd vdd sky130_fd_pr__pfet_01v8 W=0.7 L=0.15
Xn_1149_p2 n_1149 n_1148 vdd vdd sky130_fd_pr__pfet_01v8 W=0.7 L=0.15
Xn_1149_n1 n_1149 n_1145 n_1149_x vss sky130_fd_pr__nfet_01v8 W=0.84 L=0.15
Xn_1149_n2 n_1149_x n_1148 vss vss sky130_fd_pr__nfet_01v8 W=0.84 L=0.15
Xn_1150_p1 n_1150 n_1146 vdd vdd sky130_fd_pr__pfet_01v8 W=0.7 L=0.15
Xn_1150_p2 n_1150 n_1149 vdd vdd sky130_fd_pr__pfet_01v8 W=0.7 L=0.15
Xn_1150_n1 n_1150 n_1146 n_1150_x vss sky130_fd_pr__nfet_01v8 W=0.84 L=0.15
Xn_1150_n2 n_1150_x n_1149 vss vss sky130_fd_pr__nfet_01v8 W=0.84 L=0.15
Xn_1151_p1 n_1151 n_403 vdd vdd sky130_fd_pr__pfet_01v8 W=0.7 L=0.15
Xn_1151_p2 n_1151 n_1150 vdd vdd sky130_fd_pr__pfet_01v8 W=0.7 L=0.15
Xn_1151_n1 n_1151 n_403 n_1151_x vss sky130_fd_pr__nfet_01v8 W=0.84 L=0.15
Xn_1151_n2 n_1151_x n_1150 vss vss sky130_fd_pr__nfet_01v8 W=0.84 L=0.15
Xn_1152_n n_1152 n_1151 vss vss sky130_fd_pr__nfet_01v8 W=0.42 L=0.15
Xn_1152_p n_1152 n_1151 vdd vdd sky130_fd_pr__pfet_01v8 W=0.7 L=0.15
Xn_1153_p1 n_1153 n_440 vdd vdd sky130_fd_pr__pfet_01v8 W=0.7 L=0.15
Xn_1153_p2 n_1153 n_1152 vdd vdd sky130_fd_pr__pfet_01v8 W=0.7 L=0.15
Xn_1153_n1 n_1153 n_440 n_1153_x vss sky130_fd_pr__nfet_01v8 W=0.84 L=0.15
Xn_1153_n2 n_1153_x n_1152 vss vss sky130_fd_pr__nfet_01v8 W=0.84 L=0.15
Xn_1154_p1 n_1154 n_591 vdd vdd sky130_fd_pr__pfet_01v8 W=0.7 L=0.15
Xn_1154_p2 n_1154 env11 vdd vdd sky130_fd_pr__pfet_01v8 W=0.7 L=0.15
Xn_1154_n1 n_1154 n_591 n_1154_x vss sky130_fd_pr__nfet_01v8 W=0.84 L=0.15
Xn_1154_n2 n_1154_x env11 vss vss sky130_fd_pr__nfet_01v8 W=0.84 L=0.15
Xn_1155_p1 n_1155 n_1153 vdd vdd sky130_fd_pr__pfet_01v8 W=0.7 L=0.15
Xn_1155_p2 n_1155 n_1154 vdd vdd sky130_fd_pr__pfet_01v8 W=0.7 L=0.15
Xn_1155_n1 n_1155 n_1153 n_1155_x vss sky130_fd_pr__nfet_01v8 W=0.84 L=0.15
Xn_1155_n2 n_1155_x n_1154 vss vss sky130_fd_pr__nfet_01v8 W=0.84 L=0.15
Xn_1156_n n_1156 n_1155 vss vss sky130_fd_pr__nfet_01v8 W=0.42 L=0.15
Xn_1156_p n_1156 n_1155 vdd vdd sky130_fd_pr__pfet_01v8 W=0.7 L=0.15
Xn_1157_p1 n_1157 n_1155 n_1157_x vdd sky130_fd_pr__pfet_01v8 W=1.4 L=0.15
Xn_1157_p2 n_1157_x n_202 vdd vdd sky130_fd_pr__pfet_01v8 W=1.4 L=0.15
Xn_1157_n1 n_1157 n_1155 vss vss sky130_fd_pr__nfet_01v8 W=0.42 L=0.15
Xn_1157_n2 n_1157 n_202 vss vss sky130_fd_pr__nfet_01v8 W=0.42 L=0.15
Xn_1158_p1 n_1158 n_1157 n_1158_x vdd sky130_fd_pr__pfet_01v8 W=1.4 L=0.15
Xn_1158_p2 n_1158_x n_4 vdd vdd sky130_fd_pr__pfet_01v8 W=1.4 L=0.15
Xn_1158_n1 n_1158 n_1157 vss vss sky130_fd_pr__nfet_01v8 W=0.42 L=0.15
Xn_1158_n2 n_1158 n_4 vss vss sky130_fd_pr__nfet_01v8 W=0.42 L=0.15
Xn_1159_n n_1159 n_1158 vss vss sky130_fd_pr__nfet_01v8 W=0.42 L=0.15
Xn_1159_p n_1159 n_1158 vdd vdd sky130_fd_pr__pfet_01v8 W=0.7 L=0.15
Xn_1162_p1 n_1162 n_1156 n_1162_x vdd sky130_fd_pr__pfet_01v8 W=1.4 L=0.15
Xn_1162_p2 n_1162_x n_202 vdd vdd sky130_fd_pr__pfet_01v8 W=1.4 L=0.15
Xn_1162_n1 n_1162 n_1156 vss vss sky130_fd_pr__nfet_01v8 W=0.42 L=0.15
Xn_1162_n2 n_1162 n_202 vss vss sky130_fd_pr__nfet_01v8 W=0.42 L=0.15
Xn_1161_p1 n_1161 n_1162 n_1161_x vdd sky130_fd_pr__pfet_01v8 W=1.4 L=0.15
Xn_1161_p2 n_1161_x n_1160 vdd vdd sky130_fd_pr__pfet_01v8 W=1.4 L=0.15
Xn_1161_n1 n_1161 n_1162 vss vss sky130_fd_pr__nfet_01v8 W=0.42 L=0.15
Xn_1161_n2 n_1161 n_1160 vss vss sky130_fd_pr__nfet_01v8 W=0.42 L=0.15
Xn_1160_p1 n_1160 n_1159 n_1160_x vdd sky130_fd_pr__pfet_01v8 W=1.4 L=0.15
Xn_1160_p2 n_1160_x n_1161 vdd vdd sky130_fd_pr__pfet_01v8 W=1.4 L=0.15
Xn_1160_n1 n_1160 n_1159 vss vss sky130_fd_pr__nfet_01v8 W=0.42 L=0.15
Xn_1160_n2 n_1160 n_1161 vss vss sky130_fd_pr__nfet_01v8 W=0.42 L=0.15
Xn_1163_p1 n_1163 n_1160 n_1163_x vdd sky130_fd_pr__pfet_01v8 W=1.4 L=0.15
Xn_1163_p2 n_1163_x n_205 vdd vdd sky130_fd_pr__pfet_01v8 W=1.4 L=0.15
Xn_1163_n1 n_1163 n_1160 vss vss sky130_fd_pr__nfet_01v8 W=0.42 L=0.15
Xn_1163_n2 n_1163 n_205 vss vss sky130_fd_pr__nfet_01v8 W=0.42 L=0.15
Xn_1164_p1 n_1164 n_1163 n_1164_x vdd sky130_fd_pr__pfet_01v8 W=1.4 L=0.15
Xn_1164_p2 n_1164_x n_4 vdd vdd sky130_fd_pr__pfet_01v8 W=1.4 L=0.15
Xn_1164_n1 n_1164 n_1163 vss vss sky130_fd_pr__nfet_01v8 W=0.42 L=0.15
Xn_1164_n2 n_1164 n_4 vss vss sky130_fd_pr__nfet_01v8 W=0.42 L=0.15
Xn_1165_n n_1165 n_1164 vss vss sky130_fd_pr__nfet_01v8 W=0.42 L=0.15
Xn_1165_p n_1165 n_1164 vdd vdd sky130_fd_pr__pfet_01v8 W=0.7 L=0.15
Xn_1167_p1 n_1167 n_1161 n_1167_x vdd sky130_fd_pr__pfet_01v8 W=1.4 L=0.15
Xn_1167_p2 n_1167_x n_205 vdd vdd sky130_fd_pr__pfet_01v8 W=1.4 L=0.15
Xn_1167_n1 n_1167 n_1161 vss vss sky130_fd_pr__nfet_01v8 W=0.42 L=0.15
Xn_1167_n2 n_1167 n_205 vss vss sky130_fd_pr__nfet_01v8 W=0.42 L=0.15
Xn_1166_p1 n_1166 n_1167 n_1166_x vdd sky130_fd_pr__pfet_01v8 W=1.4 L=0.15
Xn_1166_p2 n_1166_x env11 vdd vdd sky130_fd_pr__pfet_01v8 W=1.4 L=0.15
Xn_1166_n1 n_1166 n_1167 vss vss sky130_fd_pr__nfet_01v8 W=0.42 L=0.15
Xn_1166_n2 n_1166 env11 vss vss sky130_fd_pr__nfet_01v8 W=0.42 L=0.15
Xenv11_p1 env11 n_1165 env11_x vdd sky130_fd_pr__pfet_01v8 W=1.4 L=0.15
Xenv11_p2 env11_x n_1166 vdd vdd sky130_fd_pr__pfet_01v8 W=1.4 L=0.15
Xenv11_n1 env11 n_1165 vss vss sky130_fd_pr__nfet_01v8 W=0.42 L=0.15
Xenv11_n2 env11 n_1166 vss vss sky130_fd_pr__nfet_01v8 W=0.42 L=0.15
Xn_1168_n n_1168 env11 vss vss sky130_fd_pr__nfet_01v8 W=0.42 L=0.15
Xn_1168_p n_1168 env11 vdd vdd sky130_fd_pr__pfet_01v8 W=0.7 L=0.15
Xn_1169_p1 n_1169 env11 vdd vdd sky130_fd_pr__pfet_01v8 W=0.7 L=0.15
Xn_1169_p2 n_1169 n_594 vdd vdd sky130_fd_pr__pfet_01v8 W=0.7 L=0.15
Xn_1169_n1 n_1169 env11 n_1169_x vss sky130_fd_pr__nfet_01v8 W=0.84 L=0.15
Xn_1169_n2 n_1169_x n_594 vss vss sky130_fd_pr__nfet_01v8 W=0.84 L=0.15
Xn_1170_n n_1170 n_1169 vss vss sky130_fd_pr__nfet_01v8 W=0.42 L=0.15
Xn_1170_p n_1170 n_1169 vdd vdd sky130_fd_pr__pfet_01v8 W=0.7 L=0.15
Xn_1171_p1 n_1171 n_1168 vdd vdd sky130_fd_pr__pfet_01v8 W=0.7 L=0.15
Xn_1171_p2 n_1171 n_594 vdd vdd sky130_fd_pr__pfet_01v8 W=0.7 L=0.15
Xn_1171_n1 n_1171 n_1168 n_1171_x vss sky130_fd_pr__nfet_01v8 W=0.84 L=0.15
Xn_1171_n2 n_1171_x n_594 vss vss sky130_fd_pr__nfet_01v8 W=0.84 L=0.15
Xn_1172_n n_1172 n_1171 vss vss sky130_fd_pr__nfet_01v8 W=0.42 L=0.15
Xn_1172_p n_1172 n_1171 vdd vdd sky130_fd_pr__pfet_01v8 W=0.7 L=0.15
Xn_1173_p1 n_1173 n_1172 n_1173_x vdd sky130_fd_pr__pfet_01v8 W=1.4 L=0.15
Xn_1173_p2 n_1173_x n_4 vdd vdd sky130_fd_pr__pfet_01v8 W=1.4 L=0.15
Xn_1173_n1 n_1173 n_1172 vss vss sky130_fd_pr__nfet_01v8 W=0.42 L=0.15
Xn_1173_n2 n_1173 n_4 vss vss sky130_fd_pr__nfet_01v8 W=0.42 L=0.15
Xn_1174_n n_1174 n_1173 vss vss sky130_fd_pr__nfet_01v8 W=0.42 L=0.15
Xn_1174_p n_1174 n_1173 vdd vdd sky130_fd_pr__pfet_01v8 W=0.7 L=0.15
Xn_1176_p1 n_1176 n_1170 n_1176_x vdd sky130_fd_pr__pfet_01v8 W=1.4 L=0.15
Xn_1176_p2 n_1176_x n_1175 vdd vdd sky130_fd_pr__pfet_01v8 W=1.4 L=0.15
Xn_1176_n1 n_1176 n_1170 vss vss sky130_fd_pr__nfet_01v8 W=0.42 L=0.15
Xn_1176_n2 n_1176 n_1175 vss vss sky130_fd_pr__nfet_01v8 W=0.42 L=0.15
Xn_1175_p1 n_1175 n_1174 n_1175_x vdd sky130_fd_pr__pfet_01v8 W=1.4 L=0.15
Xn_1175_p2 n_1175_x n_1176 vdd vdd sky130_fd_pr__pfet_01v8 W=1.4 L=0.15
Xn_1175_n1 n_1175 n_1174 vss vss sky130_fd_pr__nfet_01v8 W=0.42 L=0.15
Xn_1175_n2 n_1175 n_1176 vss vss sky130_fd_pr__nfet_01v8 W=0.42 L=0.15
Xn_1177_n n_1177 n_1175 vss vss sky130_fd_pr__nfet_01v8 W=0.42 L=0.15
Xn_1177_p n_1177 n_1175 vdd vdd sky130_fd_pr__pfet_01v8 W=0.7 L=0.15
Xn_1178_n n_1178 n_1177 vss vss sky130_fd_pr__nfet_01v8 W=0.42 L=0.15
Xn_1178_p n_1178 n_1177 vdd vdd sky130_fd_pr__pfet_01v8 W=0.7 L=0.15
Xn_1179_n n_1179 x_neg11 vss vss sky130_fd_pr__nfet_01v8 W=0.42 L=0.15
Xn_1179_p n_1179 x_neg11 vdd vdd sky130_fd_pr__pfet_01v8 W=0.7 L=0.15
Xn_1180_p1 n_1180 n_1178 vdd vdd sky130_fd_pr__pfet_01v8 W=0.7 L=0.15
Xn_1180_p2 n_1180 n_1179 vdd vdd sky130_fd_pr__pfet_01v8 W=0.7 L=0.15
Xn_1180_n1 n_1180 n_1178 n_1180_x vss sky130_fd_pr__nfet_01v8 W=0.84 L=0.15
Xn_1180_n2 n_1180_x n_1179 vss vss sky130_fd_pr__nfet_01v8 W=0.84 L=0.15
Xxin_p_r11_n xin_p_r11 n_1180 vss vss sky130_fd_pr__nfet_01v8 W=0.42 L=0.15
Xxin_p_r11_p xin_p_r11 n_1180 vdd vdd sky130_fd_pr__pfet_01v8 W=0.7 L=0.15
Xn_1181_p1 n_1181 n_1178 vdd vdd sky130_fd_pr__pfet_01v8 W=0.7 L=0.15
Xn_1181_p2 n_1181 x_neg11 vdd vdd sky130_fd_pr__pfet_01v8 W=0.7 L=0.15
Xn_1181_n1 n_1181 n_1178 n_1181_x vss sky130_fd_pr__nfet_01v8 W=0.84 L=0.15
Xn_1181_n2 n_1181_x x_neg11 vss vss sky130_fd_pr__nfet_01v8 W=0.84 L=0.15
Xxin_n_r11_n xin_n_r11 n_1181 vss vss sky130_fd_pr__nfet_01v8 W=0.42 L=0.15
Xxin_n_r11_p xin_n_r11 n_1181 vdd vdd sky130_fd_pr__pfet_01v8 W=0.7 L=0.15
Xn_1182_p1 n_1182 n_1178 vdd vdd sky130_fd_pr__pfet_01v8 W=0.7 L=0.15
Xn_1182_p2 n_1182 lora_en vdd vdd sky130_fd_pr__pfet_01v8 W=0.7 L=0.15
Xn_1182_n1 n_1182 n_1178 n_1182_x vss sky130_fd_pr__nfet_01v8 W=0.84 L=0.15
Xn_1182_n2 n_1182_x lora_en vss vss sky130_fd_pr__nfet_01v8 W=0.84 L=0.15
Xxrd_en11_n xrd_en11 n_1182 vss vss sky130_fd_pr__nfet_01v8 W=0.42 L=0.15
Xxrd_en11_p xrd_en11 n_1182 vdd vdd sky130_fd_pr__pfet_01v8 W=0.7 L=0.15
Xn_1183_p1 n_1183 n_587 vdd vdd sky130_fd_pr__pfet_01v8 W=0.7 L=0.15
Xn_1183_p2 n_1183 x_mag48 vdd vdd sky130_fd_pr__pfet_01v8 W=0.7 L=0.15
Xn_1183_n1 n_1183 n_587 n_1183_x vss sky130_fd_pr__nfet_01v8 W=0.84 L=0.15
Xn_1183_n2 n_1183_x x_mag48 vss vss sky130_fd_pr__nfet_01v8 W=0.84 L=0.15
Xn_1184_n n_1184 n_1183 vss vss sky130_fd_pr__nfet_01v8 W=0.42 L=0.15
Xn_1184_p n_1184 n_1183 vdd vdd sky130_fd_pr__pfet_01v8 W=0.7 L=0.15
Xn_1185_p1 n_1185 n_588 vdd vdd sky130_fd_pr__pfet_01v8 W=0.7 L=0.15
Xn_1185_p2 n_1185 x_mag49 vdd vdd sky130_fd_pr__pfet_01v8 W=0.7 L=0.15
Xn_1185_n1 n_1185 n_588 n_1185_x vss sky130_fd_pr__nfet_01v8 W=0.84 L=0.15
Xn_1185_n2 n_1185_x x_mag49 vss vss sky130_fd_pr__nfet_01v8 W=0.84 L=0.15
Xn_1186_p1 n_1186 n_588 n_1186_x vdd sky130_fd_pr__pfet_01v8 W=1.4 L=0.15
Xn_1186_p2 n_1186_x x_mag49 vdd vdd sky130_fd_pr__pfet_01v8 W=1.4 L=0.15
Xn_1186_n1 n_1186 n_588 vss vss sky130_fd_pr__nfet_01v8 W=0.42 L=0.15
Xn_1186_n2 n_1186 x_mag49 vss vss sky130_fd_pr__nfet_01v8 W=0.42 L=0.15
Xn_1187_n n_1187 n_1186 vss vss sky130_fd_pr__nfet_01v8 W=0.42 L=0.15
Xn_1187_p n_1187 n_1186 vdd vdd sky130_fd_pr__pfet_01v8 W=0.7 L=0.15
Xn_1188_p1 n_1188 n_1184 vdd vdd sky130_fd_pr__pfet_01v8 W=0.7 L=0.15
Xn_1188_p2 n_1188 n_1187 vdd vdd sky130_fd_pr__pfet_01v8 W=0.7 L=0.15
Xn_1188_n1 n_1188 n_1184 n_1188_x vss sky130_fd_pr__nfet_01v8 W=0.84 L=0.15
Xn_1188_n2 n_1188_x n_1187 vss vss sky130_fd_pr__nfet_01v8 W=0.84 L=0.15
Xn_1189_p1 n_1189 n_1185 vdd vdd sky130_fd_pr__pfet_01v8 W=0.7 L=0.15
Xn_1189_p2 n_1189 n_1188 vdd vdd sky130_fd_pr__pfet_01v8 W=0.7 L=0.15
Xn_1189_n1 n_1189 n_1185 n_1189_x vss sky130_fd_pr__nfet_01v8 W=0.84 L=0.15
Xn_1189_n2 n_1189_x n_1188 vss vss sky130_fd_pr__nfet_01v8 W=0.84 L=0.15
Xn_1190_p1 n_1190 n_589 vdd vdd sky130_fd_pr__pfet_01v8 W=0.7 L=0.15
Xn_1190_p2 n_1190 x_mag50 vdd vdd sky130_fd_pr__pfet_01v8 W=0.7 L=0.15
Xn_1190_n1 n_1190 n_589 n_1190_x vss sky130_fd_pr__nfet_01v8 W=0.84 L=0.15
Xn_1190_n2 n_1190_x x_mag50 vss vss sky130_fd_pr__nfet_01v8 W=0.84 L=0.15
Xn_1191_p1 n_1191 n_589 n_1191_x vdd sky130_fd_pr__pfet_01v8 W=1.4 L=0.15
Xn_1191_p2 n_1191_x x_mag50 vdd vdd sky130_fd_pr__pfet_01v8 W=1.4 L=0.15
Xn_1191_n1 n_1191 n_589 vss vss sky130_fd_pr__nfet_01v8 W=0.42 L=0.15
Xn_1191_n2 n_1191 x_mag50 vss vss sky130_fd_pr__nfet_01v8 W=0.42 L=0.15
Xn_1192_n n_1192 n_1191 vss vss sky130_fd_pr__nfet_01v8 W=0.42 L=0.15
Xn_1192_p n_1192 n_1191 vdd vdd sky130_fd_pr__pfet_01v8 W=0.7 L=0.15
Xn_1193_p1 n_1193 n_1189 vdd vdd sky130_fd_pr__pfet_01v8 W=0.7 L=0.15
Xn_1193_p2 n_1193 n_1192 vdd vdd sky130_fd_pr__pfet_01v8 W=0.7 L=0.15
Xn_1193_n1 n_1193 n_1189 n_1193_x vss sky130_fd_pr__nfet_01v8 W=0.84 L=0.15
Xn_1193_n2 n_1193_x n_1192 vss vss sky130_fd_pr__nfet_01v8 W=0.84 L=0.15
Xn_1194_p1 n_1194 n_1190 vdd vdd sky130_fd_pr__pfet_01v8 W=0.7 L=0.15
Xn_1194_p2 n_1194 n_1193 vdd vdd sky130_fd_pr__pfet_01v8 W=0.7 L=0.15
Xn_1194_n1 n_1194 n_1190 n_1194_x vss sky130_fd_pr__nfet_01v8 W=0.84 L=0.15
Xn_1194_n2 n_1194_x n_1193 vss vss sky130_fd_pr__nfet_01v8 W=0.84 L=0.15
Xn_1195_p1 n_1195 n_590 vdd vdd sky130_fd_pr__pfet_01v8 W=0.7 L=0.15
Xn_1195_p2 n_1195 x_mag51 vdd vdd sky130_fd_pr__pfet_01v8 W=0.7 L=0.15
Xn_1195_n1 n_1195 n_590 n_1195_x vss sky130_fd_pr__nfet_01v8 W=0.84 L=0.15
Xn_1195_n2 n_1195_x x_mag51 vss vss sky130_fd_pr__nfet_01v8 W=0.84 L=0.15
Xn_1196_p1 n_1196 n_590 n_1196_x vdd sky130_fd_pr__pfet_01v8 W=1.4 L=0.15
Xn_1196_p2 n_1196_x x_mag51 vdd vdd sky130_fd_pr__pfet_01v8 W=1.4 L=0.15
Xn_1196_n1 n_1196 n_590 vss vss sky130_fd_pr__nfet_01v8 W=0.42 L=0.15
Xn_1196_n2 n_1196 x_mag51 vss vss sky130_fd_pr__nfet_01v8 W=0.42 L=0.15
Xn_1197_n n_1197 n_1196 vss vss sky130_fd_pr__nfet_01v8 W=0.42 L=0.15
Xn_1197_p n_1197 n_1196 vdd vdd sky130_fd_pr__pfet_01v8 W=0.7 L=0.15
Xn_1198_p1 n_1198 n_1194 vdd vdd sky130_fd_pr__pfet_01v8 W=0.7 L=0.15
Xn_1198_p2 n_1198 n_1197 vdd vdd sky130_fd_pr__pfet_01v8 W=0.7 L=0.15
Xn_1198_n1 n_1198 n_1194 n_1198_x vss sky130_fd_pr__nfet_01v8 W=0.84 L=0.15
Xn_1198_n2 n_1198_x n_1197 vss vss sky130_fd_pr__nfet_01v8 W=0.84 L=0.15
Xn_1199_p1 n_1199 n_1195 vdd vdd sky130_fd_pr__pfet_01v8 W=0.7 L=0.15
Xn_1199_p2 n_1199 n_1198 vdd vdd sky130_fd_pr__pfet_01v8 W=0.7 L=0.15
Xn_1199_n1 n_1199 n_1195 n_1199_x vss sky130_fd_pr__nfet_01v8 W=0.84 L=0.15
Xn_1199_n2 n_1199_x n_1198 vss vss sky130_fd_pr__nfet_01v8 W=0.84 L=0.15
Xn_1200_p1 n_1200 n_403 vdd vdd sky130_fd_pr__pfet_01v8 W=0.7 L=0.15
Xn_1200_p2 n_1200 n_1199 vdd vdd sky130_fd_pr__pfet_01v8 W=0.7 L=0.15
Xn_1200_n1 n_1200 n_403 n_1200_x vss sky130_fd_pr__nfet_01v8 W=0.84 L=0.15
Xn_1200_n2 n_1200_x n_1199 vss vss sky130_fd_pr__nfet_01v8 W=0.84 L=0.15
Xn_1201_n n_1201 n_1200 vss vss sky130_fd_pr__nfet_01v8 W=0.42 L=0.15
Xn_1201_p n_1201 n_1200 vdd vdd sky130_fd_pr__pfet_01v8 W=0.7 L=0.15
Xn_1202_p1 n_1202 n_440 vdd vdd sky130_fd_pr__pfet_01v8 W=0.7 L=0.15
Xn_1202_p2 n_1202 n_1201 vdd vdd sky130_fd_pr__pfet_01v8 W=0.7 L=0.15
Xn_1202_n1 n_1202 n_440 n_1202_x vss sky130_fd_pr__nfet_01v8 W=0.84 L=0.15
Xn_1202_n2 n_1202_x n_1201 vss vss sky130_fd_pr__nfet_01v8 W=0.84 L=0.15
Xn_1203_p1 n_1203 n_591 vdd vdd sky130_fd_pr__pfet_01v8 W=0.7 L=0.15
Xn_1203_p2 n_1203 env12 vdd vdd sky130_fd_pr__pfet_01v8 W=0.7 L=0.15
Xn_1203_n1 n_1203 n_591 n_1203_x vss sky130_fd_pr__nfet_01v8 W=0.84 L=0.15
Xn_1203_n2 n_1203_x env12 vss vss sky130_fd_pr__nfet_01v8 W=0.84 L=0.15
Xn_1204_p1 n_1204 n_1202 vdd vdd sky130_fd_pr__pfet_01v8 W=0.7 L=0.15
Xn_1204_p2 n_1204 n_1203 vdd vdd sky130_fd_pr__pfet_01v8 W=0.7 L=0.15
Xn_1204_n1 n_1204 n_1202 n_1204_x vss sky130_fd_pr__nfet_01v8 W=0.84 L=0.15
Xn_1204_n2 n_1204_x n_1203 vss vss sky130_fd_pr__nfet_01v8 W=0.84 L=0.15
Xn_1205_n n_1205 n_1204 vss vss sky130_fd_pr__nfet_01v8 W=0.42 L=0.15
Xn_1205_p n_1205 n_1204 vdd vdd sky130_fd_pr__pfet_01v8 W=0.7 L=0.15
Xn_1206_p1 n_1206 n_1204 n_1206_x vdd sky130_fd_pr__pfet_01v8 W=1.4 L=0.15
Xn_1206_p2 n_1206_x n_202 vdd vdd sky130_fd_pr__pfet_01v8 W=1.4 L=0.15
Xn_1206_n1 n_1206 n_1204 vss vss sky130_fd_pr__nfet_01v8 W=0.42 L=0.15
Xn_1206_n2 n_1206 n_202 vss vss sky130_fd_pr__nfet_01v8 W=0.42 L=0.15
Xn_1207_p1 n_1207 n_1206 n_1207_x vdd sky130_fd_pr__pfet_01v8 W=1.4 L=0.15
Xn_1207_p2 n_1207_x n_4 vdd vdd sky130_fd_pr__pfet_01v8 W=1.4 L=0.15
Xn_1207_n1 n_1207 n_1206 vss vss sky130_fd_pr__nfet_01v8 W=0.42 L=0.15
Xn_1207_n2 n_1207 n_4 vss vss sky130_fd_pr__nfet_01v8 W=0.42 L=0.15
Xn_1208_n n_1208 n_1207 vss vss sky130_fd_pr__nfet_01v8 W=0.42 L=0.15
Xn_1208_p n_1208 n_1207 vdd vdd sky130_fd_pr__pfet_01v8 W=0.7 L=0.15
Xn_1211_p1 n_1211 n_1205 n_1211_x vdd sky130_fd_pr__pfet_01v8 W=1.4 L=0.15
Xn_1211_p2 n_1211_x n_202 vdd vdd sky130_fd_pr__pfet_01v8 W=1.4 L=0.15
Xn_1211_n1 n_1211 n_1205 vss vss sky130_fd_pr__nfet_01v8 W=0.42 L=0.15
Xn_1211_n2 n_1211 n_202 vss vss sky130_fd_pr__nfet_01v8 W=0.42 L=0.15
Xn_1210_p1 n_1210 n_1211 n_1210_x vdd sky130_fd_pr__pfet_01v8 W=1.4 L=0.15
Xn_1210_p2 n_1210_x n_1209 vdd vdd sky130_fd_pr__pfet_01v8 W=1.4 L=0.15
Xn_1210_n1 n_1210 n_1211 vss vss sky130_fd_pr__nfet_01v8 W=0.42 L=0.15
Xn_1210_n2 n_1210 n_1209 vss vss sky130_fd_pr__nfet_01v8 W=0.42 L=0.15
Xn_1209_p1 n_1209 n_1208 n_1209_x vdd sky130_fd_pr__pfet_01v8 W=1.4 L=0.15
Xn_1209_p2 n_1209_x n_1210 vdd vdd sky130_fd_pr__pfet_01v8 W=1.4 L=0.15
Xn_1209_n1 n_1209 n_1208 vss vss sky130_fd_pr__nfet_01v8 W=0.42 L=0.15
Xn_1209_n2 n_1209 n_1210 vss vss sky130_fd_pr__nfet_01v8 W=0.42 L=0.15
Xn_1212_p1 n_1212 n_1209 n_1212_x vdd sky130_fd_pr__pfet_01v8 W=1.4 L=0.15
Xn_1212_p2 n_1212_x n_205 vdd vdd sky130_fd_pr__pfet_01v8 W=1.4 L=0.15
Xn_1212_n1 n_1212 n_1209 vss vss sky130_fd_pr__nfet_01v8 W=0.42 L=0.15
Xn_1212_n2 n_1212 n_205 vss vss sky130_fd_pr__nfet_01v8 W=0.42 L=0.15
Xn_1213_p1 n_1213 n_1212 n_1213_x vdd sky130_fd_pr__pfet_01v8 W=1.4 L=0.15
Xn_1213_p2 n_1213_x n_4 vdd vdd sky130_fd_pr__pfet_01v8 W=1.4 L=0.15
Xn_1213_n1 n_1213 n_1212 vss vss sky130_fd_pr__nfet_01v8 W=0.42 L=0.15
Xn_1213_n2 n_1213 n_4 vss vss sky130_fd_pr__nfet_01v8 W=0.42 L=0.15
Xn_1214_n n_1214 n_1213 vss vss sky130_fd_pr__nfet_01v8 W=0.42 L=0.15
Xn_1214_p n_1214 n_1213 vdd vdd sky130_fd_pr__pfet_01v8 W=0.7 L=0.15
Xn_1216_p1 n_1216 n_1210 n_1216_x vdd sky130_fd_pr__pfet_01v8 W=1.4 L=0.15
Xn_1216_p2 n_1216_x n_205 vdd vdd sky130_fd_pr__pfet_01v8 W=1.4 L=0.15
Xn_1216_n1 n_1216 n_1210 vss vss sky130_fd_pr__nfet_01v8 W=0.42 L=0.15
Xn_1216_n2 n_1216 n_205 vss vss sky130_fd_pr__nfet_01v8 W=0.42 L=0.15
Xn_1215_p1 n_1215 n_1216 n_1215_x vdd sky130_fd_pr__pfet_01v8 W=1.4 L=0.15
Xn_1215_p2 n_1215_x env12 vdd vdd sky130_fd_pr__pfet_01v8 W=1.4 L=0.15
Xn_1215_n1 n_1215 n_1216 vss vss sky130_fd_pr__nfet_01v8 W=0.42 L=0.15
Xn_1215_n2 n_1215 env12 vss vss sky130_fd_pr__nfet_01v8 W=0.42 L=0.15
Xenv12_p1 env12 n_1214 env12_x vdd sky130_fd_pr__pfet_01v8 W=1.4 L=0.15
Xenv12_p2 env12_x n_1215 vdd vdd sky130_fd_pr__pfet_01v8 W=1.4 L=0.15
Xenv12_n1 env12 n_1214 vss vss sky130_fd_pr__nfet_01v8 W=0.42 L=0.15
Xenv12_n2 env12 n_1215 vss vss sky130_fd_pr__nfet_01v8 W=0.42 L=0.15
Xn_1217_n n_1217 env12 vss vss sky130_fd_pr__nfet_01v8 W=0.42 L=0.15
Xn_1217_p n_1217 env12 vdd vdd sky130_fd_pr__pfet_01v8 W=0.7 L=0.15
Xn_1218_p1 n_1218 env12 vdd vdd sky130_fd_pr__pfet_01v8 W=0.7 L=0.15
Xn_1218_p2 n_1218 n_594 vdd vdd sky130_fd_pr__pfet_01v8 W=0.7 L=0.15
Xn_1218_n1 n_1218 env12 n_1218_x vss sky130_fd_pr__nfet_01v8 W=0.84 L=0.15
Xn_1218_n2 n_1218_x n_594 vss vss sky130_fd_pr__nfet_01v8 W=0.84 L=0.15
Xn_1219_n n_1219 n_1218 vss vss sky130_fd_pr__nfet_01v8 W=0.42 L=0.15
Xn_1219_p n_1219 n_1218 vdd vdd sky130_fd_pr__pfet_01v8 W=0.7 L=0.15
Xn_1220_p1 n_1220 n_1217 vdd vdd sky130_fd_pr__pfet_01v8 W=0.7 L=0.15
Xn_1220_p2 n_1220 n_594 vdd vdd sky130_fd_pr__pfet_01v8 W=0.7 L=0.15
Xn_1220_n1 n_1220 n_1217 n_1220_x vss sky130_fd_pr__nfet_01v8 W=0.84 L=0.15
Xn_1220_n2 n_1220_x n_594 vss vss sky130_fd_pr__nfet_01v8 W=0.84 L=0.15
Xn_1221_n n_1221 n_1220 vss vss sky130_fd_pr__nfet_01v8 W=0.42 L=0.15
Xn_1221_p n_1221 n_1220 vdd vdd sky130_fd_pr__pfet_01v8 W=0.7 L=0.15
Xn_1222_p1 n_1222 n_1221 n_1222_x vdd sky130_fd_pr__pfet_01v8 W=1.4 L=0.15
Xn_1222_p2 n_1222_x n_4 vdd vdd sky130_fd_pr__pfet_01v8 W=1.4 L=0.15
Xn_1222_n1 n_1222 n_1221 vss vss sky130_fd_pr__nfet_01v8 W=0.42 L=0.15
Xn_1222_n2 n_1222 n_4 vss vss sky130_fd_pr__nfet_01v8 W=0.42 L=0.15
Xn_1223_n n_1223 n_1222 vss vss sky130_fd_pr__nfet_01v8 W=0.42 L=0.15
Xn_1223_p n_1223 n_1222 vdd vdd sky130_fd_pr__pfet_01v8 W=0.7 L=0.15
Xn_1225_p1 n_1225 n_1219 n_1225_x vdd sky130_fd_pr__pfet_01v8 W=1.4 L=0.15
Xn_1225_p2 n_1225_x n_1224 vdd vdd sky130_fd_pr__pfet_01v8 W=1.4 L=0.15
Xn_1225_n1 n_1225 n_1219 vss vss sky130_fd_pr__nfet_01v8 W=0.42 L=0.15
Xn_1225_n2 n_1225 n_1224 vss vss sky130_fd_pr__nfet_01v8 W=0.42 L=0.15
Xn_1224_p1 n_1224 n_1223 n_1224_x vdd sky130_fd_pr__pfet_01v8 W=1.4 L=0.15
Xn_1224_p2 n_1224_x n_1225 vdd vdd sky130_fd_pr__pfet_01v8 W=1.4 L=0.15
Xn_1224_n1 n_1224 n_1223 vss vss sky130_fd_pr__nfet_01v8 W=0.42 L=0.15
Xn_1224_n2 n_1224 n_1225 vss vss sky130_fd_pr__nfet_01v8 W=0.42 L=0.15
Xn_1226_n n_1226 n_1224 vss vss sky130_fd_pr__nfet_01v8 W=0.42 L=0.15
Xn_1226_p n_1226 n_1224 vdd vdd sky130_fd_pr__pfet_01v8 W=0.7 L=0.15
Xn_1227_n n_1227 n_1226 vss vss sky130_fd_pr__nfet_01v8 W=0.42 L=0.15
Xn_1227_p n_1227 n_1226 vdd vdd sky130_fd_pr__pfet_01v8 W=0.7 L=0.15
Xn_1228_n n_1228 x_neg12 vss vss sky130_fd_pr__nfet_01v8 W=0.42 L=0.15
Xn_1228_p n_1228 x_neg12 vdd vdd sky130_fd_pr__pfet_01v8 W=0.7 L=0.15
Xn_1229_p1 n_1229 n_1227 vdd vdd sky130_fd_pr__pfet_01v8 W=0.7 L=0.15
Xn_1229_p2 n_1229 n_1228 vdd vdd sky130_fd_pr__pfet_01v8 W=0.7 L=0.15
Xn_1229_n1 n_1229 n_1227 n_1229_x vss sky130_fd_pr__nfet_01v8 W=0.84 L=0.15
Xn_1229_n2 n_1229_x n_1228 vss vss sky130_fd_pr__nfet_01v8 W=0.84 L=0.15
Xxin_p_r12_n xin_p_r12 n_1229 vss vss sky130_fd_pr__nfet_01v8 W=0.42 L=0.15
Xxin_p_r12_p xin_p_r12 n_1229 vdd vdd sky130_fd_pr__pfet_01v8 W=0.7 L=0.15
Xn_1230_p1 n_1230 n_1227 vdd vdd sky130_fd_pr__pfet_01v8 W=0.7 L=0.15
Xn_1230_p2 n_1230 x_neg12 vdd vdd sky130_fd_pr__pfet_01v8 W=0.7 L=0.15
Xn_1230_n1 n_1230 n_1227 n_1230_x vss sky130_fd_pr__nfet_01v8 W=0.84 L=0.15
Xn_1230_n2 n_1230_x x_neg12 vss vss sky130_fd_pr__nfet_01v8 W=0.84 L=0.15
Xxin_n_r12_n xin_n_r12 n_1230 vss vss sky130_fd_pr__nfet_01v8 W=0.42 L=0.15
Xxin_n_r12_p xin_n_r12 n_1230 vdd vdd sky130_fd_pr__pfet_01v8 W=0.7 L=0.15
Xn_1231_p1 n_1231 n_1227 vdd vdd sky130_fd_pr__pfet_01v8 W=0.7 L=0.15
Xn_1231_p2 n_1231 lora_en vdd vdd sky130_fd_pr__pfet_01v8 W=0.7 L=0.15
Xn_1231_n1 n_1231 n_1227 n_1231_x vss sky130_fd_pr__nfet_01v8 W=0.84 L=0.15
Xn_1231_n2 n_1231_x lora_en vss vss sky130_fd_pr__nfet_01v8 W=0.84 L=0.15
Xxrd_en12_n xrd_en12 n_1231 vss vss sky130_fd_pr__nfet_01v8 W=0.42 L=0.15
Xxrd_en12_p xrd_en12 n_1231 vdd vdd sky130_fd_pr__pfet_01v8 W=0.7 L=0.15
Xn_1232_p1 n_1232 n_587 vdd vdd sky130_fd_pr__pfet_01v8 W=0.7 L=0.15
Xn_1232_p2 n_1232 x_mag52 vdd vdd sky130_fd_pr__pfet_01v8 W=0.7 L=0.15
Xn_1232_n1 n_1232 n_587 n_1232_x vss sky130_fd_pr__nfet_01v8 W=0.84 L=0.15
Xn_1232_n2 n_1232_x x_mag52 vss vss sky130_fd_pr__nfet_01v8 W=0.84 L=0.15
Xn_1233_n n_1233 n_1232 vss vss sky130_fd_pr__nfet_01v8 W=0.42 L=0.15
Xn_1233_p n_1233 n_1232 vdd vdd sky130_fd_pr__pfet_01v8 W=0.7 L=0.15
Xn_1234_p1 n_1234 n_588 vdd vdd sky130_fd_pr__pfet_01v8 W=0.7 L=0.15
Xn_1234_p2 n_1234 x_mag53 vdd vdd sky130_fd_pr__pfet_01v8 W=0.7 L=0.15
Xn_1234_n1 n_1234 n_588 n_1234_x vss sky130_fd_pr__nfet_01v8 W=0.84 L=0.15
Xn_1234_n2 n_1234_x x_mag53 vss vss sky130_fd_pr__nfet_01v8 W=0.84 L=0.15
Xn_1235_p1 n_1235 n_588 n_1235_x vdd sky130_fd_pr__pfet_01v8 W=1.4 L=0.15
Xn_1235_p2 n_1235_x x_mag53 vdd vdd sky130_fd_pr__pfet_01v8 W=1.4 L=0.15
Xn_1235_n1 n_1235 n_588 vss vss sky130_fd_pr__nfet_01v8 W=0.42 L=0.15
Xn_1235_n2 n_1235 x_mag53 vss vss sky130_fd_pr__nfet_01v8 W=0.42 L=0.15
Xn_1236_n n_1236 n_1235 vss vss sky130_fd_pr__nfet_01v8 W=0.42 L=0.15
Xn_1236_p n_1236 n_1235 vdd vdd sky130_fd_pr__pfet_01v8 W=0.7 L=0.15
Xn_1237_p1 n_1237 n_1233 vdd vdd sky130_fd_pr__pfet_01v8 W=0.7 L=0.15
Xn_1237_p2 n_1237 n_1236 vdd vdd sky130_fd_pr__pfet_01v8 W=0.7 L=0.15
Xn_1237_n1 n_1237 n_1233 n_1237_x vss sky130_fd_pr__nfet_01v8 W=0.84 L=0.15
Xn_1237_n2 n_1237_x n_1236 vss vss sky130_fd_pr__nfet_01v8 W=0.84 L=0.15
Xn_1238_p1 n_1238 n_1234 vdd vdd sky130_fd_pr__pfet_01v8 W=0.7 L=0.15
Xn_1238_p2 n_1238 n_1237 vdd vdd sky130_fd_pr__pfet_01v8 W=0.7 L=0.15
Xn_1238_n1 n_1238 n_1234 n_1238_x vss sky130_fd_pr__nfet_01v8 W=0.84 L=0.15
Xn_1238_n2 n_1238_x n_1237 vss vss sky130_fd_pr__nfet_01v8 W=0.84 L=0.15
Xn_1239_p1 n_1239 n_589 vdd vdd sky130_fd_pr__pfet_01v8 W=0.7 L=0.15
Xn_1239_p2 n_1239 x_mag54 vdd vdd sky130_fd_pr__pfet_01v8 W=0.7 L=0.15
Xn_1239_n1 n_1239 n_589 n_1239_x vss sky130_fd_pr__nfet_01v8 W=0.84 L=0.15
Xn_1239_n2 n_1239_x x_mag54 vss vss sky130_fd_pr__nfet_01v8 W=0.84 L=0.15
Xn_1240_p1 n_1240 n_589 n_1240_x vdd sky130_fd_pr__pfet_01v8 W=1.4 L=0.15
Xn_1240_p2 n_1240_x x_mag54 vdd vdd sky130_fd_pr__pfet_01v8 W=1.4 L=0.15
Xn_1240_n1 n_1240 n_589 vss vss sky130_fd_pr__nfet_01v8 W=0.42 L=0.15
Xn_1240_n2 n_1240 x_mag54 vss vss sky130_fd_pr__nfet_01v8 W=0.42 L=0.15
Xn_1241_n n_1241 n_1240 vss vss sky130_fd_pr__nfet_01v8 W=0.42 L=0.15
Xn_1241_p n_1241 n_1240 vdd vdd sky130_fd_pr__pfet_01v8 W=0.7 L=0.15
Xn_1242_p1 n_1242 n_1238 vdd vdd sky130_fd_pr__pfet_01v8 W=0.7 L=0.15
Xn_1242_p2 n_1242 n_1241 vdd vdd sky130_fd_pr__pfet_01v8 W=0.7 L=0.15
Xn_1242_n1 n_1242 n_1238 n_1242_x vss sky130_fd_pr__nfet_01v8 W=0.84 L=0.15
Xn_1242_n2 n_1242_x n_1241 vss vss sky130_fd_pr__nfet_01v8 W=0.84 L=0.15
Xn_1243_p1 n_1243 n_1239 vdd vdd sky130_fd_pr__pfet_01v8 W=0.7 L=0.15
Xn_1243_p2 n_1243 n_1242 vdd vdd sky130_fd_pr__pfet_01v8 W=0.7 L=0.15
Xn_1243_n1 n_1243 n_1239 n_1243_x vss sky130_fd_pr__nfet_01v8 W=0.84 L=0.15
Xn_1243_n2 n_1243_x n_1242 vss vss sky130_fd_pr__nfet_01v8 W=0.84 L=0.15
Xn_1244_p1 n_1244 n_590 vdd vdd sky130_fd_pr__pfet_01v8 W=0.7 L=0.15
Xn_1244_p2 n_1244 x_mag55 vdd vdd sky130_fd_pr__pfet_01v8 W=0.7 L=0.15
Xn_1244_n1 n_1244 n_590 n_1244_x vss sky130_fd_pr__nfet_01v8 W=0.84 L=0.15
Xn_1244_n2 n_1244_x x_mag55 vss vss sky130_fd_pr__nfet_01v8 W=0.84 L=0.15
Xn_1245_p1 n_1245 n_590 n_1245_x vdd sky130_fd_pr__pfet_01v8 W=1.4 L=0.15
Xn_1245_p2 n_1245_x x_mag55 vdd vdd sky130_fd_pr__pfet_01v8 W=1.4 L=0.15
Xn_1245_n1 n_1245 n_590 vss vss sky130_fd_pr__nfet_01v8 W=0.42 L=0.15
Xn_1245_n2 n_1245 x_mag55 vss vss sky130_fd_pr__nfet_01v8 W=0.42 L=0.15
Xn_1246_n n_1246 n_1245 vss vss sky130_fd_pr__nfet_01v8 W=0.42 L=0.15
Xn_1246_p n_1246 n_1245 vdd vdd sky130_fd_pr__pfet_01v8 W=0.7 L=0.15
Xn_1247_p1 n_1247 n_1243 vdd vdd sky130_fd_pr__pfet_01v8 W=0.7 L=0.15
Xn_1247_p2 n_1247 n_1246 vdd vdd sky130_fd_pr__pfet_01v8 W=0.7 L=0.15
Xn_1247_n1 n_1247 n_1243 n_1247_x vss sky130_fd_pr__nfet_01v8 W=0.84 L=0.15
Xn_1247_n2 n_1247_x n_1246 vss vss sky130_fd_pr__nfet_01v8 W=0.84 L=0.15
Xn_1248_p1 n_1248 n_1244 vdd vdd sky130_fd_pr__pfet_01v8 W=0.7 L=0.15
Xn_1248_p2 n_1248 n_1247 vdd vdd sky130_fd_pr__pfet_01v8 W=0.7 L=0.15
Xn_1248_n1 n_1248 n_1244 n_1248_x vss sky130_fd_pr__nfet_01v8 W=0.84 L=0.15
Xn_1248_n2 n_1248_x n_1247 vss vss sky130_fd_pr__nfet_01v8 W=0.84 L=0.15
Xn_1249_p1 n_1249 n_403 vdd vdd sky130_fd_pr__pfet_01v8 W=0.7 L=0.15
Xn_1249_p2 n_1249 n_1248 vdd vdd sky130_fd_pr__pfet_01v8 W=0.7 L=0.15
Xn_1249_n1 n_1249 n_403 n_1249_x vss sky130_fd_pr__nfet_01v8 W=0.84 L=0.15
Xn_1249_n2 n_1249_x n_1248 vss vss sky130_fd_pr__nfet_01v8 W=0.84 L=0.15
Xn_1250_n n_1250 n_1249 vss vss sky130_fd_pr__nfet_01v8 W=0.42 L=0.15
Xn_1250_p n_1250 n_1249 vdd vdd sky130_fd_pr__pfet_01v8 W=0.7 L=0.15
Xn_1251_p1 n_1251 n_440 vdd vdd sky130_fd_pr__pfet_01v8 W=0.7 L=0.15
Xn_1251_p2 n_1251 n_1250 vdd vdd sky130_fd_pr__pfet_01v8 W=0.7 L=0.15
Xn_1251_n1 n_1251 n_440 n_1251_x vss sky130_fd_pr__nfet_01v8 W=0.84 L=0.15
Xn_1251_n2 n_1251_x n_1250 vss vss sky130_fd_pr__nfet_01v8 W=0.84 L=0.15
Xn_1252_p1 n_1252 n_591 vdd vdd sky130_fd_pr__pfet_01v8 W=0.7 L=0.15
Xn_1252_p2 n_1252 env13 vdd vdd sky130_fd_pr__pfet_01v8 W=0.7 L=0.15
Xn_1252_n1 n_1252 n_591 n_1252_x vss sky130_fd_pr__nfet_01v8 W=0.84 L=0.15
Xn_1252_n2 n_1252_x env13 vss vss sky130_fd_pr__nfet_01v8 W=0.84 L=0.15
Xn_1253_p1 n_1253 n_1251 vdd vdd sky130_fd_pr__pfet_01v8 W=0.7 L=0.15
Xn_1253_p2 n_1253 n_1252 vdd vdd sky130_fd_pr__pfet_01v8 W=0.7 L=0.15
Xn_1253_n1 n_1253 n_1251 n_1253_x vss sky130_fd_pr__nfet_01v8 W=0.84 L=0.15
Xn_1253_n2 n_1253_x n_1252 vss vss sky130_fd_pr__nfet_01v8 W=0.84 L=0.15
Xn_1254_n n_1254 n_1253 vss vss sky130_fd_pr__nfet_01v8 W=0.42 L=0.15
Xn_1254_p n_1254 n_1253 vdd vdd sky130_fd_pr__pfet_01v8 W=0.7 L=0.15
Xn_1255_p1 n_1255 n_1253 n_1255_x vdd sky130_fd_pr__pfet_01v8 W=1.4 L=0.15
Xn_1255_p2 n_1255_x n_202 vdd vdd sky130_fd_pr__pfet_01v8 W=1.4 L=0.15
Xn_1255_n1 n_1255 n_1253 vss vss sky130_fd_pr__nfet_01v8 W=0.42 L=0.15
Xn_1255_n2 n_1255 n_202 vss vss sky130_fd_pr__nfet_01v8 W=0.42 L=0.15
Xn_1256_p1 n_1256 n_1255 n_1256_x vdd sky130_fd_pr__pfet_01v8 W=1.4 L=0.15
Xn_1256_p2 n_1256_x n_4 vdd vdd sky130_fd_pr__pfet_01v8 W=1.4 L=0.15
Xn_1256_n1 n_1256 n_1255 vss vss sky130_fd_pr__nfet_01v8 W=0.42 L=0.15
Xn_1256_n2 n_1256 n_4 vss vss sky130_fd_pr__nfet_01v8 W=0.42 L=0.15
Xn_1257_n n_1257 n_1256 vss vss sky130_fd_pr__nfet_01v8 W=0.42 L=0.15
Xn_1257_p n_1257 n_1256 vdd vdd sky130_fd_pr__pfet_01v8 W=0.7 L=0.15
Xn_1260_p1 n_1260 n_1254 n_1260_x vdd sky130_fd_pr__pfet_01v8 W=1.4 L=0.15
Xn_1260_p2 n_1260_x n_202 vdd vdd sky130_fd_pr__pfet_01v8 W=1.4 L=0.15
Xn_1260_n1 n_1260 n_1254 vss vss sky130_fd_pr__nfet_01v8 W=0.42 L=0.15
Xn_1260_n2 n_1260 n_202 vss vss sky130_fd_pr__nfet_01v8 W=0.42 L=0.15
Xn_1259_p1 n_1259 n_1260 n_1259_x vdd sky130_fd_pr__pfet_01v8 W=1.4 L=0.15
Xn_1259_p2 n_1259_x n_1258 vdd vdd sky130_fd_pr__pfet_01v8 W=1.4 L=0.15
Xn_1259_n1 n_1259 n_1260 vss vss sky130_fd_pr__nfet_01v8 W=0.42 L=0.15
Xn_1259_n2 n_1259 n_1258 vss vss sky130_fd_pr__nfet_01v8 W=0.42 L=0.15
Xn_1258_p1 n_1258 n_1257 n_1258_x vdd sky130_fd_pr__pfet_01v8 W=1.4 L=0.15
Xn_1258_p2 n_1258_x n_1259 vdd vdd sky130_fd_pr__pfet_01v8 W=1.4 L=0.15
Xn_1258_n1 n_1258 n_1257 vss vss sky130_fd_pr__nfet_01v8 W=0.42 L=0.15
Xn_1258_n2 n_1258 n_1259 vss vss sky130_fd_pr__nfet_01v8 W=0.42 L=0.15
Xn_1261_p1 n_1261 n_1258 n_1261_x vdd sky130_fd_pr__pfet_01v8 W=1.4 L=0.15
Xn_1261_p2 n_1261_x n_205 vdd vdd sky130_fd_pr__pfet_01v8 W=1.4 L=0.15
Xn_1261_n1 n_1261 n_1258 vss vss sky130_fd_pr__nfet_01v8 W=0.42 L=0.15
Xn_1261_n2 n_1261 n_205 vss vss sky130_fd_pr__nfet_01v8 W=0.42 L=0.15
Xn_1262_p1 n_1262 n_1261 n_1262_x vdd sky130_fd_pr__pfet_01v8 W=1.4 L=0.15
Xn_1262_p2 n_1262_x n_4 vdd vdd sky130_fd_pr__pfet_01v8 W=1.4 L=0.15
Xn_1262_n1 n_1262 n_1261 vss vss sky130_fd_pr__nfet_01v8 W=0.42 L=0.15
Xn_1262_n2 n_1262 n_4 vss vss sky130_fd_pr__nfet_01v8 W=0.42 L=0.15
Xn_1263_n n_1263 n_1262 vss vss sky130_fd_pr__nfet_01v8 W=0.42 L=0.15
Xn_1263_p n_1263 n_1262 vdd vdd sky130_fd_pr__pfet_01v8 W=0.7 L=0.15
Xn_1265_p1 n_1265 n_1259 n_1265_x vdd sky130_fd_pr__pfet_01v8 W=1.4 L=0.15
Xn_1265_p2 n_1265_x n_205 vdd vdd sky130_fd_pr__pfet_01v8 W=1.4 L=0.15
Xn_1265_n1 n_1265 n_1259 vss vss sky130_fd_pr__nfet_01v8 W=0.42 L=0.15
Xn_1265_n2 n_1265 n_205 vss vss sky130_fd_pr__nfet_01v8 W=0.42 L=0.15
Xn_1264_p1 n_1264 n_1265 n_1264_x vdd sky130_fd_pr__pfet_01v8 W=1.4 L=0.15
Xn_1264_p2 n_1264_x env13 vdd vdd sky130_fd_pr__pfet_01v8 W=1.4 L=0.15
Xn_1264_n1 n_1264 n_1265 vss vss sky130_fd_pr__nfet_01v8 W=0.42 L=0.15
Xn_1264_n2 n_1264 env13 vss vss sky130_fd_pr__nfet_01v8 W=0.42 L=0.15
Xenv13_p1 env13 n_1263 env13_x vdd sky130_fd_pr__pfet_01v8 W=1.4 L=0.15
Xenv13_p2 env13_x n_1264 vdd vdd sky130_fd_pr__pfet_01v8 W=1.4 L=0.15
Xenv13_n1 env13 n_1263 vss vss sky130_fd_pr__nfet_01v8 W=0.42 L=0.15
Xenv13_n2 env13 n_1264 vss vss sky130_fd_pr__nfet_01v8 W=0.42 L=0.15
Xn_1266_n n_1266 env13 vss vss sky130_fd_pr__nfet_01v8 W=0.42 L=0.15
Xn_1266_p n_1266 env13 vdd vdd sky130_fd_pr__pfet_01v8 W=0.7 L=0.15
Xn_1267_p1 n_1267 env13 vdd vdd sky130_fd_pr__pfet_01v8 W=0.7 L=0.15
Xn_1267_p2 n_1267 n_594 vdd vdd sky130_fd_pr__pfet_01v8 W=0.7 L=0.15
Xn_1267_n1 n_1267 env13 n_1267_x vss sky130_fd_pr__nfet_01v8 W=0.84 L=0.15
Xn_1267_n2 n_1267_x n_594 vss vss sky130_fd_pr__nfet_01v8 W=0.84 L=0.15
Xn_1268_n n_1268 n_1267 vss vss sky130_fd_pr__nfet_01v8 W=0.42 L=0.15
Xn_1268_p n_1268 n_1267 vdd vdd sky130_fd_pr__pfet_01v8 W=0.7 L=0.15
Xn_1269_p1 n_1269 n_1266 vdd vdd sky130_fd_pr__pfet_01v8 W=0.7 L=0.15
Xn_1269_p2 n_1269 n_594 vdd vdd sky130_fd_pr__pfet_01v8 W=0.7 L=0.15
Xn_1269_n1 n_1269 n_1266 n_1269_x vss sky130_fd_pr__nfet_01v8 W=0.84 L=0.15
Xn_1269_n2 n_1269_x n_594 vss vss sky130_fd_pr__nfet_01v8 W=0.84 L=0.15
Xn_1270_n n_1270 n_1269 vss vss sky130_fd_pr__nfet_01v8 W=0.42 L=0.15
Xn_1270_p n_1270 n_1269 vdd vdd sky130_fd_pr__pfet_01v8 W=0.7 L=0.15
Xn_1271_p1 n_1271 n_1270 n_1271_x vdd sky130_fd_pr__pfet_01v8 W=1.4 L=0.15
Xn_1271_p2 n_1271_x n_4 vdd vdd sky130_fd_pr__pfet_01v8 W=1.4 L=0.15
Xn_1271_n1 n_1271 n_1270 vss vss sky130_fd_pr__nfet_01v8 W=0.42 L=0.15
Xn_1271_n2 n_1271 n_4 vss vss sky130_fd_pr__nfet_01v8 W=0.42 L=0.15
Xn_1272_n n_1272 n_1271 vss vss sky130_fd_pr__nfet_01v8 W=0.42 L=0.15
Xn_1272_p n_1272 n_1271 vdd vdd sky130_fd_pr__pfet_01v8 W=0.7 L=0.15
Xn_1274_p1 n_1274 n_1268 n_1274_x vdd sky130_fd_pr__pfet_01v8 W=1.4 L=0.15
Xn_1274_p2 n_1274_x n_1273 vdd vdd sky130_fd_pr__pfet_01v8 W=1.4 L=0.15
Xn_1274_n1 n_1274 n_1268 vss vss sky130_fd_pr__nfet_01v8 W=0.42 L=0.15
Xn_1274_n2 n_1274 n_1273 vss vss sky130_fd_pr__nfet_01v8 W=0.42 L=0.15
Xn_1273_p1 n_1273 n_1272 n_1273_x vdd sky130_fd_pr__pfet_01v8 W=1.4 L=0.15
Xn_1273_p2 n_1273_x n_1274 vdd vdd sky130_fd_pr__pfet_01v8 W=1.4 L=0.15
Xn_1273_n1 n_1273 n_1272 vss vss sky130_fd_pr__nfet_01v8 W=0.42 L=0.15
Xn_1273_n2 n_1273 n_1274 vss vss sky130_fd_pr__nfet_01v8 W=0.42 L=0.15
Xn_1275_n n_1275 n_1273 vss vss sky130_fd_pr__nfet_01v8 W=0.42 L=0.15
Xn_1275_p n_1275 n_1273 vdd vdd sky130_fd_pr__pfet_01v8 W=0.7 L=0.15
Xn_1276_n n_1276 n_1275 vss vss sky130_fd_pr__nfet_01v8 W=0.42 L=0.15
Xn_1276_p n_1276 n_1275 vdd vdd sky130_fd_pr__pfet_01v8 W=0.7 L=0.15
Xn_1277_n n_1277 x_neg13 vss vss sky130_fd_pr__nfet_01v8 W=0.42 L=0.15
Xn_1277_p n_1277 x_neg13 vdd vdd sky130_fd_pr__pfet_01v8 W=0.7 L=0.15
Xn_1278_p1 n_1278 n_1276 vdd vdd sky130_fd_pr__pfet_01v8 W=0.7 L=0.15
Xn_1278_p2 n_1278 n_1277 vdd vdd sky130_fd_pr__pfet_01v8 W=0.7 L=0.15
Xn_1278_n1 n_1278 n_1276 n_1278_x vss sky130_fd_pr__nfet_01v8 W=0.84 L=0.15
Xn_1278_n2 n_1278_x n_1277 vss vss sky130_fd_pr__nfet_01v8 W=0.84 L=0.15
Xxin_p_r13_n xin_p_r13 n_1278 vss vss sky130_fd_pr__nfet_01v8 W=0.42 L=0.15
Xxin_p_r13_p xin_p_r13 n_1278 vdd vdd sky130_fd_pr__pfet_01v8 W=0.7 L=0.15
Xn_1279_p1 n_1279 n_1276 vdd vdd sky130_fd_pr__pfet_01v8 W=0.7 L=0.15
Xn_1279_p2 n_1279 x_neg13 vdd vdd sky130_fd_pr__pfet_01v8 W=0.7 L=0.15
Xn_1279_n1 n_1279 n_1276 n_1279_x vss sky130_fd_pr__nfet_01v8 W=0.84 L=0.15
Xn_1279_n2 n_1279_x x_neg13 vss vss sky130_fd_pr__nfet_01v8 W=0.84 L=0.15
Xxin_n_r13_n xin_n_r13 n_1279 vss vss sky130_fd_pr__nfet_01v8 W=0.42 L=0.15
Xxin_n_r13_p xin_n_r13 n_1279 vdd vdd sky130_fd_pr__pfet_01v8 W=0.7 L=0.15
Xn_1280_p1 n_1280 n_1276 vdd vdd sky130_fd_pr__pfet_01v8 W=0.7 L=0.15
Xn_1280_p2 n_1280 lora_en vdd vdd sky130_fd_pr__pfet_01v8 W=0.7 L=0.15
Xn_1280_n1 n_1280 n_1276 n_1280_x vss sky130_fd_pr__nfet_01v8 W=0.84 L=0.15
Xn_1280_n2 n_1280_x lora_en vss vss sky130_fd_pr__nfet_01v8 W=0.84 L=0.15
Xxrd_en13_n xrd_en13 n_1280 vss vss sky130_fd_pr__nfet_01v8 W=0.42 L=0.15
Xxrd_en13_p xrd_en13 n_1280 vdd vdd sky130_fd_pr__pfet_01v8 W=0.7 L=0.15
Xn_1281_p1 n_1281 n_587 vdd vdd sky130_fd_pr__pfet_01v8 W=0.7 L=0.15
Xn_1281_p2 n_1281 x_mag56 vdd vdd sky130_fd_pr__pfet_01v8 W=0.7 L=0.15
Xn_1281_n1 n_1281 n_587 n_1281_x vss sky130_fd_pr__nfet_01v8 W=0.84 L=0.15
Xn_1281_n2 n_1281_x x_mag56 vss vss sky130_fd_pr__nfet_01v8 W=0.84 L=0.15
Xn_1282_n n_1282 n_1281 vss vss sky130_fd_pr__nfet_01v8 W=0.42 L=0.15
Xn_1282_p n_1282 n_1281 vdd vdd sky130_fd_pr__pfet_01v8 W=0.7 L=0.15
Xn_1283_p1 n_1283 n_588 vdd vdd sky130_fd_pr__pfet_01v8 W=0.7 L=0.15
Xn_1283_p2 n_1283 x_mag57 vdd vdd sky130_fd_pr__pfet_01v8 W=0.7 L=0.15
Xn_1283_n1 n_1283 n_588 n_1283_x vss sky130_fd_pr__nfet_01v8 W=0.84 L=0.15
Xn_1283_n2 n_1283_x x_mag57 vss vss sky130_fd_pr__nfet_01v8 W=0.84 L=0.15
Xn_1284_p1 n_1284 n_588 n_1284_x vdd sky130_fd_pr__pfet_01v8 W=1.4 L=0.15
Xn_1284_p2 n_1284_x x_mag57 vdd vdd sky130_fd_pr__pfet_01v8 W=1.4 L=0.15
Xn_1284_n1 n_1284 n_588 vss vss sky130_fd_pr__nfet_01v8 W=0.42 L=0.15
Xn_1284_n2 n_1284 x_mag57 vss vss sky130_fd_pr__nfet_01v8 W=0.42 L=0.15
Xn_1285_n n_1285 n_1284 vss vss sky130_fd_pr__nfet_01v8 W=0.42 L=0.15
Xn_1285_p n_1285 n_1284 vdd vdd sky130_fd_pr__pfet_01v8 W=0.7 L=0.15
Xn_1286_p1 n_1286 n_1282 vdd vdd sky130_fd_pr__pfet_01v8 W=0.7 L=0.15
Xn_1286_p2 n_1286 n_1285 vdd vdd sky130_fd_pr__pfet_01v8 W=0.7 L=0.15
Xn_1286_n1 n_1286 n_1282 n_1286_x vss sky130_fd_pr__nfet_01v8 W=0.84 L=0.15
Xn_1286_n2 n_1286_x n_1285 vss vss sky130_fd_pr__nfet_01v8 W=0.84 L=0.15
Xn_1287_p1 n_1287 n_1283 vdd vdd sky130_fd_pr__pfet_01v8 W=0.7 L=0.15
Xn_1287_p2 n_1287 n_1286 vdd vdd sky130_fd_pr__pfet_01v8 W=0.7 L=0.15
Xn_1287_n1 n_1287 n_1283 n_1287_x vss sky130_fd_pr__nfet_01v8 W=0.84 L=0.15
Xn_1287_n2 n_1287_x n_1286 vss vss sky130_fd_pr__nfet_01v8 W=0.84 L=0.15
Xn_1288_p1 n_1288 n_589 vdd vdd sky130_fd_pr__pfet_01v8 W=0.7 L=0.15
Xn_1288_p2 n_1288 x_mag58 vdd vdd sky130_fd_pr__pfet_01v8 W=0.7 L=0.15
Xn_1288_n1 n_1288 n_589 n_1288_x vss sky130_fd_pr__nfet_01v8 W=0.84 L=0.15
Xn_1288_n2 n_1288_x x_mag58 vss vss sky130_fd_pr__nfet_01v8 W=0.84 L=0.15
Xn_1289_p1 n_1289 n_589 n_1289_x vdd sky130_fd_pr__pfet_01v8 W=1.4 L=0.15
Xn_1289_p2 n_1289_x x_mag58 vdd vdd sky130_fd_pr__pfet_01v8 W=1.4 L=0.15
Xn_1289_n1 n_1289 n_589 vss vss sky130_fd_pr__nfet_01v8 W=0.42 L=0.15
Xn_1289_n2 n_1289 x_mag58 vss vss sky130_fd_pr__nfet_01v8 W=0.42 L=0.15
Xn_1290_n n_1290 n_1289 vss vss sky130_fd_pr__nfet_01v8 W=0.42 L=0.15
Xn_1290_p n_1290 n_1289 vdd vdd sky130_fd_pr__pfet_01v8 W=0.7 L=0.15
Xn_1291_p1 n_1291 n_1287 vdd vdd sky130_fd_pr__pfet_01v8 W=0.7 L=0.15
Xn_1291_p2 n_1291 n_1290 vdd vdd sky130_fd_pr__pfet_01v8 W=0.7 L=0.15
Xn_1291_n1 n_1291 n_1287 n_1291_x vss sky130_fd_pr__nfet_01v8 W=0.84 L=0.15
Xn_1291_n2 n_1291_x n_1290 vss vss sky130_fd_pr__nfet_01v8 W=0.84 L=0.15
Xn_1292_p1 n_1292 n_1288 vdd vdd sky130_fd_pr__pfet_01v8 W=0.7 L=0.15
Xn_1292_p2 n_1292 n_1291 vdd vdd sky130_fd_pr__pfet_01v8 W=0.7 L=0.15
Xn_1292_n1 n_1292 n_1288 n_1292_x vss sky130_fd_pr__nfet_01v8 W=0.84 L=0.15
Xn_1292_n2 n_1292_x n_1291 vss vss sky130_fd_pr__nfet_01v8 W=0.84 L=0.15
Xn_1293_p1 n_1293 n_590 vdd vdd sky130_fd_pr__pfet_01v8 W=0.7 L=0.15
Xn_1293_p2 n_1293 x_mag59 vdd vdd sky130_fd_pr__pfet_01v8 W=0.7 L=0.15
Xn_1293_n1 n_1293 n_590 n_1293_x vss sky130_fd_pr__nfet_01v8 W=0.84 L=0.15
Xn_1293_n2 n_1293_x x_mag59 vss vss sky130_fd_pr__nfet_01v8 W=0.84 L=0.15
Xn_1294_p1 n_1294 n_590 n_1294_x vdd sky130_fd_pr__pfet_01v8 W=1.4 L=0.15
Xn_1294_p2 n_1294_x x_mag59 vdd vdd sky130_fd_pr__pfet_01v8 W=1.4 L=0.15
Xn_1294_n1 n_1294 n_590 vss vss sky130_fd_pr__nfet_01v8 W=0.42 L=0.15
Xn_1294_n2 n_1294 x_mag59 vss vss sky130_fd_pr__nfet_01v8 W=0.42 L=0.15
Xn_1295_n n_1295 n_1294 vss vss sky130_fd_pr__nfet_01v8 W=0.42 L=0.15
Xn_1295_p n_1295 n_1294 vdd vdd sky130_fd_pr__pfet_01v8 W=0.7 L=0.15
Xn_1296_p1 n_1296 n_1292 vdd vdd sky130_fd_pr__pfet_01v8 W=0.7 L=0.15
Xn_1296_p2 n_1296 n_1295 vdd vdd sky130_fd_pr__pfet_01v8 W=0.7 L=0.15
Xn_1296_n1 n_1296 n_1292 n_1296_x vss sky130_fd_pr__nfet_01v8 W=0.84 L=0.15
Xn_1296_n2 n_1296_x n_1295 vss vss sky130_fd_pr__nfet_01v8 W=0.84 L=0.15
Xn_1297_p1 n_1297 n_1293 vdd vdd sky130_fd_pr__pfet_01v8 W=0.7 L=0.15
Xn_1297_p2 n_1297 n_1296 vdd vdd sky130_fd_pr__pfet_01v8 W=0.7 L=0.15
Xn_1297_n1 n_1297 n_1293 n_1297_x vss sky130_fd_pr__nfet_01v8 W=0.84 L=0.15
Xn_1297_n2 n_1297_x n_1296 vss vss sky130_fd_pr__nfet_01v8 W=0.84 L=0.15
Xn_1298_p1 n_1298 n_403 vdd vdd sky130_fd_pr__pfet_01v8 W=0.7 L=0.15
Xn_1298_p2 n_1298 n_1297 vdd vdd sky130_fd_pr__pfet_01v8 W=0.7 L=0.15
Xn_1298_n1 n_1298 n_403 n_1298_x vss sky130_fd_pr__nfet_01v8 W=0.84 L=0.15
Xn_1298_n2 n_1298_x n_1297 vss vss sky130_fd_pr__nfet_01v8 W=0.84 L=0.15
Xn_1299_n n_1299 n_1298 vss vss sky130_fd_pr__nfet_01v8 W=0.42 L=0.15
Xn_1299_p n_1299 n_1298 vdd vdd sky130_fd_pr__pfet_01v8 W=0.7 L=0.15
Xn_1300_p1 n_1300 n_440 vdd vdd sky130_fd_pr__pfet_01v8 W=0.7 L=0.15
Xn_1300_p2 n_1300 n_1299 vdd vdd sky130_fd_pr__pfet_01v8 W=0.7 L=0.15
Xn_1300_n1 n_1300 n_440 n_1300_x vss sky130_fd_pr__nfet_01v8 W=0.84 L=0.15
Xn_1300_n2 n_1300_x n_1299 vss vss sky130_fd_pr__nfet_01v8 W=0.84 L=0.15
Xn_1301_p1 n_1301 n_591 vdd vdd sky130_fd_pr__pfet_01v8 W=0.7 L=0.15
Xn_1301_p2 n_1301 env14 vdd vdd sky130_fd_pr__pfet_01v8 W=0.7 L=0.15
Xn_1301_n1 n_1301 n_591 n_1301_x vss sky130_fd_pr__nfet_01v8 W=0.84 L=0.15
Xn_1301_n2 n_1301_x env14 vss vss sky130_fd_pr__nfet_01v8 W=0.84 L=0.15
Xn_1302_p1 n_1302 n_1300 vdd vdd sky130_fd_pr__pfet_01v8 W=0.7 L=0.15
Xn_1302_p2 n_1302 n_1301 vdd vdd sky130_fd_pr__pfet_01v8 W=0.7 L=0.15
Xn_1302_n1 n_1302 n_1300 n_1302_x vss sky130_fd_pr__nfet_01v8 W=0.84 L=0.15
Xn_1302_n2 n_1302_x n_1301 vss vss sky130_fd_pr__nfet_01v8 W=0.84 L=0.15
Xn_1303_n n_1303 n_1302 vss vss sky130_fd_pr__nfet_01v8 W=0.42 L=0.15
Xn_1303_p n_1303 n_1302 vdd vdd sky130_fd_pr__pfet_01v8 W=0.7 L=0.15
Xn_1304_p1 n_1304 n_1302 n_1304_x vdd sky130_fd_pr__pfet_01v8 W=1.4 L=0.15
Xn_1304_p2 n_1304_x n_202 vdd vdd sky130_fd_pr__pfet_01v8 W=1.4 L=0.15
Xn_1304_n1 n_1304 n_1302 vss vss sky130_fd_pr__nfet_01v8 W=0.42 L=0.15
Xn_1304_n2 n_1304 n_202 vss vss sky130_fd_pr__nfet_01v8 W=0.42 L=0.15
Xn_1305_p1 n_1305 n_1304 n_1305_x vdd sky130_fd_pr__pfet_01v8 W=1.4 L=0.15
Xn_1305_p2 n_1305_x n_4 vdd vdd sky130_fd_pr__pfet_01v8 W=1.4 L=0.15
Xn_1305_n1 n_1305 n_1304 vss vss sky130_fd_pr__nfet_01v8 W=0.42 L=0.15
Xn_1305_n2 n_1305 n_4 vss vss sky130_fd_pr__nfet_01v8 W=0.42 L=0.15
Xn_1306_n n_1306 n_1305 vss vss sky130_fd_pr__nfet_01v8 W=0.42 L=0.15
Xn_1306_p n_1306 n_1305 vdd vdd sky130_fd_pr__pfet_01v8 W=0.7 L=0.15
Xn_1309_p1 n_1309 n_1303 n_1309_x vdd sky130_fd_pr__pfet_01v8 W=1.4 L=0.15
Xn_1309_p2 n_1309_x n_202 vdd vdd sky130_fd_pr__pfet_01v8 W=1.4 L=0.15
Xn_1309_n1 n_1309 n_1303 vss vss sky130_fd_pr__nfet_01v8 W=0.42 L=0.15
Xn_1309_n2 n_1309 n_202 vss vss sky130_fd_pr__nfet_01v8 W=0.42 L=0.15
Xn_1308_p1 n_1308 n_1309 n_1308_x vdd sky130_fd_pr__pfet_01v8 W=1.4 L=0.15
Xn_1308_p2 n_1308_x n_1307 vdd vdd sky130_fd_pr__pfet_01v8 W=1.4 L=0.15
Xn_1308_n1 n_1308 n_1309 vss vss sky130_fd_pr__nfet_01v8 W=0.42 L=0.15
Xn_1308_n2 n_1308 n_1307 vss vss sky130_fd_pr__nfet_01v8 W=0.42 L=0.15
Xn_1307_p1 n_1307 n_1306 n_1307_x vdd sky130_fd_pr__pfet_01v8 W=1.4 L=0.15
Xn_1307_p2 n_1307_x n_1308 vdd vdd sky130_fd_pr__pfet_01v8 W=1.4 L=0.15
Xn_1307_n1 n_1307 n_1306 vss vss sky130_fd_pr__nfet_01v8 W=0.42 L=0.15
Xn_1307_n2 n_1307 n_1308 vss vss sky130_fd_pr__nfet_01v8 W=0.42 L=0.15
Xn_1310_p1 n_1310 n_1307 n_1310_x vdd sky130_fd_pr__pfet_01v8 W=1.4 L=0.15
Xn_1310_p2 n_1310_x n_205 vdd vdd sky130_fd_pr__pfet_01v8 W=1.4 L=0.15
Xn_1310_n1 n_1310 n_1307 vss vss sky130_fd_pr__nfet_01v8 W=0.42 L=0.15
Xn_1310_n2 n_1310 n_205 vss vss sky130_fd_pr__nfet_01v8 W=0.42 L=0.15
Xn_1311_p1 n_1311 n_1310 n_1311_x vdd sky130_fd_pr__pfet_01v8 W=1.4 L=0.15
Xn_1311_p2 n_1311_x n_4 vdd vdd sky130_fd_pr__pfet_01v8 W=1.4 L=0.15
Xn_1311_n1 n_1311 n_1310 vss vss sky130_fd_pr__nfet_01v8 W=0.42 L=0.15
Xn_1311_n2 n_1311 n_4 vss vss sky130_fd_pr__nfet_01v8 W=0.42 L=0.15
Xn_1312_n n_1312 n_1311 vss vss sky130_fd_pr__nfet_01v8 W=0.42 L=0.15
Xn_1312_p n_1312 n_1311 vdd vdd sky130_fd_pr__pfet_01v8 W=0.7 L=0.15
Xn_1314_p1 n_1314 n_1308 n_1314_x vdd sky130_fd_pr__pfet_01v8 W=1.4 L=0.15
Xn_1314_p2 n_1314_x n_205 vdd vdd sky130_fd_pr__pfet_01v8 W=1.4 L=0.15
Xn_1314_n1 n_1314 n_1308 vss vss sky130_fd_pr__nfet_01v8 W=0.42 L=0.15
Xn_1314_n2 n_1314 n_205 vss vss sky130_fd_pr__nfet_01v8 W=0.42 L=0.15
Xn_1313_p1 n_1313 n_1314 n_1313_x vdd sky130_fd_pr__pfet_01v8 W=1.4 L=0.15
Xn_1313_p2 n_1313_x env14 vdd vdd sky130_fd_pr__pfet_01v8 W=1.4 L=0.15
Xn_1313_n1 n_1313 n_1314 vss vss sky130_fd_pr__nfet_01v8 W=0.42 L=0.15
Xn_1313_n2 n_1313 env14 vss vss sky130_fd_pr__nfet_01v8 W=0.42 L=0.15
Xenv14_p1 env14 n_1312 env14_x vdd sky130_fd_pr__pfet_01v8 W=1.4 L=0.15
Xenv14_p2 env14_x n_1313 vdd vdd sky130_fd_pr__pfet_01v8 W=1.4 L=0.15
Xenv14_n1 env14 n_1312 vss vss sky130_fd_pr__nfet_01v8 W=0.42 L=0.15
Xenv14_n2 env14 n_1313 vss vss sky130_fd_pr__nfet_01v8 W=0.42 L=0.15
Xn_1315_n n_1315 env14 vss vss sky130_fd_pr__nfet_01v8 W=0.42 L=0.15
Xn_1315_p n_1315 env14 vdd vdd sky130_fd_pr__pfet_01v8 W=0.7 L=0.15
Xn_1316_p1 n_1316 env14 vdd vdd sky130_fd_pr__pfet_01v8 W=0.7 L=0.15
Xn_1316_p2 n_1316 n_594 vdd vdd sky130_fd_pr__pfet_01v8 W=0.7 L=0.15
Xn_1316_n1 n_1316 env14 n_1316_x vss sky130_fd_pr__nfet_01v8 W=0.84 L=0.15
Xn_1316_n2 n_1316_x n_594 vss vss sky130_fd_pr__nfet_01v8 W=0.84 L=0.15
Xn_1317_n n_1317 n_1316 vss vss sky130_fd_pr__nfet_01v8 W=0.42 L=0.15
Xn_1317_p n_1317 n_1316 vdd vdd sky130_fd_pr__pfet_01v8 W=0.7 L=0.15
Xn_1318_p1 n_1318 n_1315 vdd vdd sky130_fd_pr__pfet_01v8 W=0.7 L=0.15
Xn_1318_p2 n_1318 n_594 vdd vdd sky130_fd_pr__pfet_01v8 W=0.7 L=0.15
Xn_1318_n1 n_1318 n_1315 n_1318_x vss sky130_fd_pr__nfet_01v8 W=0.84 L=0.15
Xn_1318_n2 n_1318_x n_594 vss vss sky130_fd_pr__nfet_01v8 W=0.84 L=0.15
Xn_1319_n n_1319 n_1318 vss vss sky130_fd_pr__nfet_01v8 W=0.42 L=0.15
Xn_1319_p n_1319 n_1318 vdd vdd sky130_fd_pr__pfet_01v8 W=0.7 L=0.15
Xn_1320_p1 n_1320 n_1319 n_1320_x vdd sky130_fd_pr__pfet_01v8 W=1.4 L=0.15
Xn_1320_p2 n_1320_x n_4 vdd vdd sky130_fd_pr__pfet_01v8 W=1.4 L=0.15
Xn_1320_n1 n_1320 n_1319 vss vss sky130_fd_pr__nfet_01v8 W=0.42 L=0.15
Xn_1320_n2 n_1320 n_4 vss vss sky130_fd_pr__nfet_01v8 W=0.42 L=0.15
Xn_1321_n n_1321 n_1320 vss vss sky130_fd_pr__nfet_01v8 W=0.42 L=0.15
Xn_1321_p n_1321 n_1320 vdd vdd sky130_fd_pr__pfet_01v8 W=0.7 L=0.15
Xn_1323_p1 n_1323 n_1317 n_1323_x vdd sky130_fd_pr__pfet_01v8 W=1.4 L=0.15
Xn_1323_p2 n_1323_x n_1322 vdd vdd sky130_fd_pr__pfet_01v8 W=1.4 L=0.15
Xn_1323_n1 n_1323 n_1317 vss vss sky130_fd_pr__nfet_01v8 W=0.42 L=0.15
Xn_1323_n2 n_1323 n_1322 vss vss sky130_fd_pr__nfet_01v8 W=0.42 L=0.15
Xn_1322_p1 n_1322 n_1321 n_1322_x vdd sky130_fd_pr__pfet_01v8 W=1.4 L=0.15
Xn_1322_p2 n_1322_x n_1323 vdd vdd sky130_fd_pr__pfet_01v8 W=1.4 L=0.15
Xn_1322_n1 n_1322 n_1321 vss vss sky130_fd_pr__nfet_01v8 W=0.42 L=0.15
Xn_1322_n2 n_1322 n_1323 vss vss sky130_fd_pr__nfet_01v8 W=0.42 L=0.15
Xn_1324_n n_1324 n_1322 vss vss sky130_fd_pr__nfet_01v8 W=0.42 L=0.15
Xn_1324_p n_1324 n_1322 vdd vdd sky130_fd_pr__pfet_01v8 W=0.7 L=0.15
Xn_1325_n n_1325 n_1324 vss vss sky130_fd_pr__nfet_01v8 W=0.42 L=0.15
Xn_1325_p n_1325 n_1324 vdd vdd sky130_fd_pr__pfet_01v8 W=0.7 L=0.15
Xn_1326_n n_1326 x_neg14 vss vss sky130_fd_pr__nfet_01v8 W=0.42 L=0.15
Xn_1326_p n_1326 x_neg14 vdd vdd sky130_fd_pr__pfet_01v8 W=0.7 L=0.15
Xn_1327_p1 n_1327 n_1325 vdd vdd sky130_fd_pr__pfet_01v8 W=0.7 L=0.15
Xn_1327_p2 n_1327 n_1326 vdd vdd sky130_fd_pr__pfet_01v8 W=0.7 L=0.15
Xn_1327_n1 n_1327 n_1325 n_1327_x vss sky130_fd_pr__nfet_01v8 W=0.84 L=0.15
Xn_1327_n2 n_1327_x n_1326 vss vss sky130_fd_pr__nfet_01v8 W=0.84 L=0.15
Xxin_p_r14_n xin_p_r14 n_1327 vss vss sky130_fd_pr__nfet_01v8 W=0.42 L=0.15
Xxin_p_r14_p xin_p_r14 n_1327 vdd vdd sky130_fd_pr__pfet_01v8 W=0.7 L=0.15
Xn_1328_p1 n_1328 n_1325 vdd vdd sky130_fd_pr__pfet_01v8 W=0.7 L=0.15
Xn_1328_p2 n_1328 x_neg14 vdd vdd sky130_fd_pr__pfet_01v8 W=0.7 L=0.15
Xn_1328_n1 n_1328 n_1325 n_1328_x vss sky130_fd_pr__nfet_01v8 W=0.84 L=0.15
Xn_1328_n2 n_1328_x x_neg14 vss vss sky130_fd_pr__nfet_01v8 W=0.84 L=0.15
Xxin_n_r14_n xin_n_r14 n_1328 vss vss sky130_fd_pr__nfet_01v8 W=0.42 L=0.15
Xxin_n_r14_p xin_n_r14 n_1328 vdd vdd sky130_fd_pr__pfet_01v8 W=0.7 L=0.15
Xn_1329_p1 n_1329 n_1325 vdd vdd sky130_fd_pr__pfet_01v8 W=0.7 L=0.15
Xn_1329_p2 n_1329 lora_en vdd vdd sky130_fd_pr__pfet_01v8 W=0.7 L=0.15
Xn_1329_n1 n_1329 n_1325 n_1329_x vss sky130_fd_pr__nfet_01v8 W=0.84 L=0.15
Xn_1329_n2 n_1329_x lora_en vss vss sky130_fd_pr__nfet_01v8 W=0.84 L=0.15
Xxrd_en14_n xrd_en14 n_1329 vss vss sky130_fd_pr__nfet_01v8 W=0.42 L=0.15
Xxrd_en14_p xrd_en14 n_1329 vdd vdd sky130_fd_pr__pfet_01v8 W=0.7 L=0.15
Xn_1330_p1 n_1330 n_587 vdd vdd sky130_fd_pr__pfet_01v8 W=0.7 L=0.15
Xn_1330_p2 n_1330 x_mag60 vdd vdd sky130_fd_pr__pfet_01v8 W=0.7 L=0.15
Xn_1330_n1 n_1330 n_587 n_1330_x vss sky130_fd_pr__nfet_01v8 W=0.84 L=0.15
Xn_1330_n2 n_1330_x x_mag60 vss vss sky130_fd_pr__nfet_01v8 W=0.84 L=0.15
Xn_1331_n n_1331 n_1330 vss vss sky130_fd_pr__nfet_01v8 W=0.42 L=0.15
Xn_1331_p n_1331 n_1330 vdd vdd sky130_fd_pr__pfet_01v8 W=0.7 L=0.15
Xn_1332_p1 n_1332 n_588 vdd vdd sky130_fd_pr__pfet_01v8 W=0.7 L=0.15
Xn_1332_p2 n_1332 x_mag61 vdd vdd sky130_fd_pr__pfet_01v8 W=0.7 L=0.15
Xn_1332_n1 n_1332 n_588 n_1332_x vss sky130_fd_pr__nfet_01v8 W=0.84 L=0.15
Xn_1332_n2 n_1332_x x_mag61 vss vss sky130_fd_pr__nfet_01v8 W=0.84 L=0.15
Xn_1333_p1 n_1333 n_588 n_1333_x vdd sky130_fd_pr__pfet_01v8 W=1.4 L=0.15
Xn_1333_p2 n_1333_x x_mag61 vdd vdd sky130_fd_pr__pfet_01v8 W=1.4 L=0.15
Xn_1333_n1 n_1333 n_588 vss vss sky130_fd_pr__nfet_01v8 W=0.42 L=0.15
Xn_1333_n2 n_1333 x_mag61 vss vss sky130_fd_pr__nfet_01v8 W=0.42 L=0.15
Xn_1334_n n_1334 n_1333 vss vss sky130_fd_pr__nfet_01v8 W=0.42 L=0.15
Xn_1334_p n_1334 n_1333 vdd vdd sky130_fd_pr__pfet_01v8 W=0.7 L=0.15
Xn_1335_p1 n_1335 n_1331 vdd vdd sky130_fd_pr__pfet_01v8 W=0.7 L=0.15
Xn_1335_p2 n_1335 n_1334 vdd vdd sky130_fd_pr__pfet_01v8 W=0.7 L=0.15
Xn_1335_n1 n_1335 n_1331 n_1335_x vss sky130_fd_pr__nfet_01v8 W=0.84 L=0.15
Xn_1335_n2 n_1335_x n_1334 vss vss sky130_fd_pr__nfet_01v8 W=0.84 L=0.15
Xn_1336_p1 n_1336 n_1332 vdd vdd sky130_fd_pr__pfet_01v8 W=0.7 L=0.15
Xn_1336_p2 n_1336 n_1335 vdd vdd sky130_fd_pr__pfet_01v8 W=0.7 L=0.15
Xn_1336_n1 n_1336 n_1332 n_1336_x vss sky130_fd_pr__nfet_01v8 W=0.84 L=0.15
Xn_1336_n2 n_1336_x n_1335 vss vss sky130_fd_pr__nfet_01v8 W=0.84 L=0.15
Xn_1337_p1 n_1337 n_589 vdd vdd sky130_fd_pr__pfet_01v8 W=0.7 L=0.15
Xn_1337_p2 n_1337 x_mag62 vdd vdd sky130_fd_pr__pfet_01v8 W=0.7 L=0.15
Xn_1337_n1 n_1337 n_589 n_1337_x vss sky130_fd_pr__nfet_01v8 W=0.84 L=0.15
Xn_1337_n2 n_1337_x x_mag62 vss vss sky130_fd_pr__nfet_01v8 W=0.84 L=0.15
Xn_1338_p1 n_1338 n_589 n_1338_x vdd sky130_fd_pr__pfet_01v8 W=1.4 L=0.15
Xn_1338_p2 n_1338_x x_mag62 vdd vdd sky130_fd_pr__pfet_01v8 W=1.4 L=0.15
Xn_1338_n1 n_1338 n_589 vss vss sky130_fd_pr__nfet_01v8 W=0.42 L=0.15
Xn_1338_n2 n_1338 x_mag62 vss vss sky130_fd_pr__nfet_01v8 W=0.42 L=0.15
Xn_1339_n n_1339 n_1338 vss vss sky130_fd_pr__nfet_01v8 W=0.42 L=0.15
Xn_1339_p n_1339 n_1338 vdd vdd sky130_fd_pr__pfet_01v8 W=0.7 L=0.15
Xn_1340_p1 n_1340 n_1336 vdd vdd sky130_fd_pr__pfet_01v8 W=0.7 L=0.15
Xn_1340_p2 n_1340 n_1339 vdd vdd sky130_fd_pr__pfet_01v8 W=0.7 L=0.15
Xn_1340_n1 n_1340 n_1336 n_1340_x vss sky130_fd_pr__nfet_01v8 W=0.84 L=0.15
Xn_1340_n2 n_1340_x n_1339 vss vss sky130_fd_pr__nfet_01v8 W=0.84 L=0.15
Xn_1341_p1 n_1341 n_1337 vdd vdd sky130_fd_pr__pfet_01v8 W=0.7 L=0.15
Xn_1341_p2 n_1341 n_1340 vdd vdd sky130_fd_pr__pfet_01v8 W=0.7 L=0.15
Xn_1341_n1 n_1341 n_1337 n_1341_x vss sky130_fd_pr__nfet_01v8 W=0.84 L=0.15
Xn_1341_n2 n_1341_x n_1340 vss vss sky130_fd_pr__nfet_01v8 W=0.84 L=0.15
Xn_1342_p1 n_1342 n_590 vdd vdd sky130_fd_pr__pfet_01v8 W=0.7 L=0.15
Xn_1342_p2 n_1342 x_mag63 vdd vdd sky130_fd_pr__pfet_01v8 W=0.7 L=0.15
Xn_1342_n1 n_1342 n_590 n_1342_x vss sky130_fd_pr__nfet_01v8 W=0.84 L=0.15
Xn_1342_n2 n_1342_x x_mag63 vss vss sky130_fd_pr__nfet_01v8 W=0.84 L=0.15
Xn_1343_p1 n_1343 n_590 n_1343_x vdd sky130_fd_pr__pfet_01v8 W=1.4 L=0.15
Xn_1343_p2 n_1343_x x_mag63 vdd vdd sky130_fd_pr__pfet_01v8 W=1.4 L=0.15
Xn_1343_n1 n_1343 n_590 vss vss sky130_fd_pr__nfet_01v8 W=0.42 L=0.15
Xn_1343_n2 n_1343 x_mag63 vss vss sky130_fd_pr__nfet_01v8 W=0.42 L=0.15
Xn_1344_n n_1344 n_1343 vss vss sky130_fd_pr__nfet_01v8 W=0.42 L=0.15
Xn_1344_p n_1344 n_1343 vdd vdd sky130_fd_pr__pfet_01v8 W=0.7 L=0.15
Xn_1345_p1 n_1345 n_1341 vdd vdd sky130_fd_pr__pfet_01v8 W=0.7 L=0.15
Xn_1345_p2 n_1345 n_1344 vdd vdd sky130_fd_pr__pfet_01v8 W=0.7 L=0.15
Xn_1345_n1 n_1345 n_1341 n_1345_x vss sky130_fd_pr__nfet_01v8 W=0.84 L=0.15
Xn_1345_n2 n_1345_x n_1344 vss vss sky130_fd_pr__nfet_01v8 W=0.84 L=0.15
Xn_1346_p1 n_1346 n_1342 vdd vdd sky130_fd_pr__pfet_01v8 W=0.7 L=0.15
Xn_1346_p2 n_1346 n_1345 vdd vdd sky130_fd_pr__pfet_01v8 W=0.7 L=0.15
Xn_1346_n1 n_1346 n_1342 n_1346_x vss sky130_fd_pr__nfet_01v8 W=0.84 L=0.15
Xn_1346_n2 n_1346_x n_1345 vss vss sky130_fd_pr__nfet_01v8 W=0.84 L=0.15
Xn_1347_p1 n_1347 n_403 vdd vdd sky130_fd_pr__pfet_01v8 W=0.7 L=0.15
Xn_1347_p2 n_1347 n_1346 vdd vdd sky130_fd_pr__pfet_01v8 W=0.7 L=0.15
Xn_1347_n1 n_1347 n_403 n_1347_x vss sky130_fd_pr__nfet_01v8 W=0.84 L=0.15
Xn_1347_n2 n_1347_x n_1346 vss vss sky130_fd_pr__nfet_01v8 W=0.84 L=0.15
Xn_1348_n n_1348 n_1347 vss vss sky130_fd_pr__nfet_01v8 W=0.42 L=0.15
Xn_1348_p n_1348 n_1347 vdd vdd sky130_fd_pr__pfet_01v8 W=0.7 L=0.15
Xn_1349_p1 n_1349 n_440 vdd vdd sky130_fd_pr__pfet_01v8 W=0.7 L=0.15
Xn_1349_p2 n_1349 n_1348 vdd vdd sky130_fd_pr__pfet_01v8 W=0.7 L=0.15
Xn_1349_n1 n_1349 n_440 n_1349_x vss sky130_fd_pr__nfet_01v8 W=0.84 L=0.15
Xn_1349_n2 n_1349_x n_1348 vss vss sky130_fd_pr__nfet_01v8 W=0.84 L=0.15
Xn_1350_p1 n_1350 n_591 vdd vdd sky130_fd_pr__pfet_01v8 W=0.7 L=0.15
Xn_1350_p2 n_1350 env15 vdd vdd sky130_fd_pr__pfet_01v8 W=0.7 L=0.15
Xn_1350_n1 n_1350 n_591 n_1350_x vss sky130_fd_pr__nfet_01v8 W=0.84 L=0.15
Xn_1350_n2 n_1350_x env15 vss vss sky130_fd_pr__nfet_01v8 W=0.84 L=0.15
Xn_1351_p1 n_1351 n_1349 vdd vdd sky130_fd_pr__pfet_01v8 W=0.7 L=0.15
Xn_1351_p2 n_1351 n_1350 vdd vdd sky130_fd_pr__pfet_01v8 W=0.7 L=0.15
Xn_1351_n1 n_1351 n_1349 n_1351_x vss sky130_fd_pr__nfet_01v8 W=0.84 L=0.15
Xn_1351_n2 n_1351_x n_1350 vss vss sky130_fd_pr__nfet_01v8 W=0.84 L=0.15
Xn_1352_n n_1352 n_1351 vss vss sky130_fd_pr__nfet_01v8 W=0.42 L=0.15
Xn_1352_p n_1352 n_1351 vdd vdd sky130_fd_pr__pfet_01v8 W=0.7 L=0.15
Xn_1353_p1 n_1353 n_1351 n_1353_x vdd sky130_fd_pr__pfet_01v8 W=1.4 L=0.15
Xn_1353_p2 n_1353_x n_202 vdd vdd sky130_fd_pr__pfet_01v8 W=1.4 L=0.15
Xn_1353_n1 n_1353 n_1351 vss vss sky130_fd_pr__nfet_01v8 W=0.42 L=0.15
Xn_1353_n2 n_1353 n_202 vss vss sky130_fd_pr__nfet_01v8 W=0.42 L=0.15
Xn_1354_p1 n_1354 n_1353 n_1354_x vdd sky130_fd_pr__pfet_01v8 W=1.4 L=0.15
Xn_1354_p2 n_1354_x n_4 vdd vdd sky130_fd_pr__pfet_01v8 W=1.4 L=0.15
Xn_1354_n1 n_1354 n_1353 vss vss sky130_fd_pr__nfet_01v8 W=0.42 L=0.15
Xn_1354_n2 n_1354 n_4 vss vss sky130_fd_pr__nfet_01v8 W=0.42 L=0.15
Xn_1355_n n_1355 n_1354 vss vss sky130_fd_pr__nfet_01v8 W=0.42 L=0.15
Xn_1355_p n_1355 n_1354 vdd vdd sky130_fd_pr__pfet_01v8 W=0.7 L=0.15
Xn_1358_p1 n_1358 n_1352 n_1358_x vdd sky130_fd_pr__pfet_01v8 W=1.4 L=0.15
Xn_1358_p2 n_1358_x n_202 vdd vdd sky130_fd_pr__pfet_01v8 W=1.4 L=0.15
Xn_1358_n1 n_1358 n_1352 vss vss sky130_fd_pr__nfet_01v8 W=0.42 L=0.15
Xn_1358_n2 n_1358 n_202 vss vss sky130_fd_pr__nfet_01v8 W=0.42 L=0.15
Xn_1357_p1 n_1357 n_1358 n_1357_x vdd sky130_fd_pr__pfet_01v8 W=1.4 L=0.15
Xn_1357_p2 n_1357_x n_1356 vdd vdd sky130_fd_pr__pfet_01v8 W=1.4 L=0.15
Xn_1357_n1 n_1357 n_1358 vss vss sky130_fd_pr__nfet_01v8 W=0.42 L=0.15
Xn_1357_n2 n_1357 n_1356 vss vss sky130_fd_pr__nfet_01v8 W=0.42 L=0.15
Xn_1356_p1 n_1356 n_1355 n_1356_x vdd sky130_fd_pr__pfet_01v8 W=1.4 L=0.15
Xn_1356_p2 n_1356_x n_1357 vdd vdd sky130_fd_pr__pfet_01v8 W=1.4 L=0.15
Xn_1356_n1 n_1356 n_1355 vss vss sky130_fd_pr__nfet_01v8 W=0.42 L=0.15
Xn_1356_n2 n_1356 n_1357 vss vss sky130_fd_pr__nfet_01v8 W=0.42 L=0.15
Xn_1359_p1 n_1359 n_1356 n_1359_x vdd sky130_fd_pr__pfet_01v8 W=1.4 L=0.15
Xn_1359_p2 n_1359_x n_205 vdd vdd sky130_fd_pr__pfet_01v8 W=1.4 L=0.15
Xn_1359_n1 n_1359 n_1356 vss vss sky130_fd_pr__nfet_01v8 W=0.42 L=0.15
Xn_1359_n2 n_1359 n_205 vss vss sky130_fd_pr__nfet_01v8 W=0.42 L=0.15
Xn_1360_p1 n_1360 n_1359 n_1360_x vdd sky130_fd_pr__pfet_01v8 W=1.4 L=0.15
Xn_1360_p2 n_1360_x n_4 vdd vdd sky130_fd_pr__pfet_01v8 W=1.4 L=0.15
Xn_1360_n1 n_1360 n_1359 vss vss sky130_fd_pr__nfet_01v8 W=0.42 L=0.15
Xn_1360_n2 n_1360 n_4 vss vss sky130_fd_pr__nfet_01v8 W=0.42 L=0.15
Xn_1361_n n_1361 n_1360 vss vss sky130_fd_pr__nfet_01v8 W=0.42 L=0.15
Xn_1361_p n_1361 n_1360 vdd vdd sky130_fd_pr__pfet_01v8 W=0.7 L=0.15
Xn_1363_p1 n_1363 n_1357 n_1363_x vdd sky130_fd_pr__pfet_01v8 W=1.4 L=0.15
Xn_1363_p2 n_1363_x n_205 vdd vdd sky130_fd_pr__pfet_01v8 W=1.4 L=0.15
Xn_1363_n1 n_1363 n_1357 vss vss sky130_fd_pr__nfet_01v8 W=0.42 L=0.15
Xn_1363_n2 n_1363 n_205 vss vss sky130_fd_pr__nfet_01v8 W=0.42 L=0.15
Xn_1362_p1 n_1362 n_1363 n_1362_x vdd sky130_fd_pr__pfet_01v8 W=1.4 L=0.15
Xn_1362_p2 n_1362_x env15 vdd vdd sky130_fd_pr__pfet_01v8 W=1.4 L=0.15
Xn_1362_n1 n_1362 n_1363 vss vss sky130_fd_pr__nfet_01v8 W=0.42 L=0.15
Xn_1362_n2 n_1362 env15 vss vss sky130_fd_pr__nfet_01v8 W=0.42 L=0.15
Xenv15_p1 env15 n_1361 env15_x vdd sky130_fd_pr__pfet_01v8 W=1.4 L=0.15
Xenv15_p2 env15_x n_1362 vdd vdd sky130_fd_pr__pfet_01v8 W=1.4 L=0.15
Xenv15_n1 env15 n_1361 vss vss sky130_fd_pr__nfet_01v8 W=0.42 L=0.15
Xenv15_n2 env15 n_1362 vss vss sky130_fd_pr__nfet_01v8 W=0.42 L=0.15
Xn_1364_n n_1364 env15 vss vss sky130_fd_pr__nfet_01v8 W=0.42 L=0.15
Xn_1364_p n_1364 env15 vdd vdd sky130_fd_pr__pfet_01v8 W=0.7 L=0.15
Xn_1365_p1 n_1365 env15 vdd vdd sky130_fd_pr__pfet_01v8 W=0.7 L=0.15
Xn_1365_p2 n_1365 n_594 vdd vdd sky130_fd_pr__pfet_01v8 W=0.7 L=0.15
Xn_1365_n1 n_1365 env15 n_1365_x vss sky130_fd_pr__nfet_01v8 W=0.84 L=0.15
Xn_1365_n2 n_1365_x n_594 vss vss sky130_fd_pr__nfet_01v8 W=0.84 L=0.15
Xn_1366_n n_1366 n_1365 vss vss sky130_fd_pr__nfet_01v8 W=0.42 L=0.15
Xn_1366_p n_1366 n_1365 vdd vdd sky130_fd_pr__pfet_01v8 W=0.7 L=0.15
Xn_1367_p1 n_1367 n_1364 vdd vdd sky130_fd_pr__pfet_01v8 W=0.7 L=0.15
Xn_1367_p2 n_1367 n_594 vdd vdd sky130_fd_pr__pfet_01v8 W=0.7 L=0.15
Xn_1367_n1 n_1367 n_1364 n_1367_x vss sky130_fd_pr__nfet_01v8 W=0.84 L=0.15
Xn_1367_n2 n_1367_x n_594 vss vss sky130_fd_pr__nfet_01v8 W=0.84 L=0.15
Xn_1368_n n_1368 n_1367 vss vss sky130_fd_pr__nfet_01v8 W=0.42 L=0.15
Xn_1368_p n_1368 n_1367 vdd vdd sky130_fd_pr__pfet_01v8 W=0.7 L=0.15
Xn_1369_p1 n_1369 n_1368 n_1369_x vdd sky130_fd_pr__pfet_01v8 W=1.4 L=0.15
Xn_1369_p2 n_1369_x n_4 vdd vdd sky130_fd_pr__pfet_01v8 W=1.4 L=0.15
Xn_1369_n1 n_1369 n_1368 vss vss sky130_fd_pr__nfet_01v8 W=0.42 L=0.15
Xn_1369_n2 n_1369 n_4 vss vss sky130_fd_pr__nfet_01v8 W=0.42 L=0.15
Xn_1370_n n_1370 n_1369 vss vss sky130_fd_pr__nfet_01v8 W=0.42 L=0.15
Xn_1370_p n_1370 n_1369 vdd vdd sky130_fd_pr__pfet_01v8 W=0.7 L=0.15
Xn_1372_p1 n_1372 n_1366 n_1372_x vdd sky130_fd_pr__pfet_01v8 W=1.4 L=0.15
Xn_1372_p2 n_1372_x n_1371 vdd vdd sky130_fd_pr__pfet_01v8 W=1.4 L=0.15
Xn_1372_n1 n_1372 n_1366 vss vss sky130_fd_pr__nfet_01v8 W=0.42 L=0.15
Xn_1372_n2 n_1372 n_1371 vss vss sky130_fd_pr__nfet_01v8 W=0.42 L=0.15
Xn_1371_p1 n_1371 n_1370 n_1371_x vdd sky130_fd_pr__pfet_01v8 W=1.4 L=0.15
Xn_1371_p2 n_1371_x n_1372 vdd vdd sky130_fd_pr__pfet_01v8 W=1.4 L=0.15
Xn_1371_n1 n_1371 n_1370 vss vss sky130_fd_pr__nfet_01v8 W=0.42 L=0.15
Xn_1371_n2 n_1371 n_1372 vss vss sky130_fd_pr__nfet_01v8 W=0.42 L=0.15
Xn_1373_n n_1373 n_1371 vss vss sky130_fd_pr__nfet_01v8 W=0.42 L=0.15
Xn_1373_p n_1373 n_1371 vdd vdd sky130_fd_pr__pfet_01v8 W=0.7 L=0.15
Xn_1374_n n_1374 n_1373 vss vss sky130_fd_pr__nfet_01v8 W=0.42 L=0.15
Xn_1374_p n_1374 n_1373 vdd vdd sky130_fd_pr__pfet_01v8 W=0.7 L=0.15
Xn_1375_n n_1375 x_neg15 vss vss sky130_fd_pr__nfet_01v8 W=0.42 L=0.15
Xn_1375_p n_1375 x_neg15 vdd vdd sky130_fd_pr__pfet_01v8 W=0.7 L=0.15
Xn_1376_p1 n_1376 n_1374 vdd vdd sky130_fd_pr__pfet_01v8 W=0.7 L=0.15
Xn_1376_p2 n_1376 n_1375 vdd vdd sky130_fd_pr__pfet_01v8 W=0.7 L=0.15
Xn_1376_n1 n_1376 n_1374 n_1376_x vss sky130_fd_pr__nfet_01v8 W=0.84 L=0.15
Xn_1376_n2 n_1376_x n_1375 vss vss sky130_fd_pr__nfet_01v8 W=0.84 L=0.15
Xxin_p_r15_n xin_p_r15 n_1376 vss vss sky130_fd_pr__nfet_01v8 W=0.42 L=0.15
Xxin_p_r15_p xin_p_r15 n_1376 vdd vdd sky130_fd_pr__pfet_01v8 W=0.7 L=0.15
Xn_1377_p1 n_1377 n_1374 vdd vdd sky130_fd_pr__pfet_01v8 W=0.7 L=0.15
Xn_1377_p2 n_1377 x_neg15 vdd vdd sky130_fd_pr__pfet_01v8 W=0.7 L=0.15
Xn_1377_n1 n_1377 n_1374 n_1377_x vss sky130_fd_pr__nfet_01v8 W=0.84 L=0.15
Xn_1377_n2 n_1377_x x_neg15 vss vss sky130_fd_pr__nfet_01v8 W=0.84 L=0.15
Xxin_n_r15_n xin_n_r15 n_1377 vss vss sky130_fd_pr__nfet_01v8 W=0.42 L=0.15
Xxin_n_r15_p xin_n_r15 n_1377 vdd vdd sky130_fd_pr__pfet_01v8 W=0.7 L=0.15
Xn_1378_p1 n_1378 n_1374 vdd vdd sky130_fd_pr__pfet_01v8 W=0.7 L=0.15
Xn_1378_p2 n_1378 lora_en vdd vdd sky130_fd_pr__pfet_01v8 W=0.7 L=0.15
Xn_1378_n1 n_1378 n_1374 n_1378_x vss sky130_fd_pr__nfet_01v8 W=0.84 L=0.15
Xn_1378_n2 n_1378_x lora_en vss vss sky130_fd_pr__nfet_01v8 W=0.84 L=0.15
Xxrd_en15_n xrd_en15 n_1378 vss vss sky130_fd_pr__nfet_01v8 W=0.42 L=0.15
Xxrd_en15_p xrd_en15 n_1378 vdd vdd sky130_fd_pr__pfet_01v8 W=0.7 L=0.15
Xn_1379_p1 n_1379 w vdd vdd sky130_fd_pr__pfet_01v8 W=0.7 L=0.15
Xn_1379_p2 n_1379 t_phi1 vdd vdd sky130_fd_pr__pfet_01v8 W=0.7 L=0.15
Xn_1379_n1 n_1379 w n_1379_x vss sky130_fd_pr__nfet_01v8 W=0.84 L=0.15
Xn_1379_n2 n_1379_x t_phi1 vss vss sky130_fd_pr__nfet_01v8 W=0.84 L=0.15
Xn_1380_n n_1380 n_1379 vss vss sky130_fd_pr__nfet_01v8 W=0.42 L=0.15
Xn_1380_p n_1380 n_1379 vdd vdd sky130_fd_pr__pfet_01v8 W=0.7 L=0.15
Xn_1381_n n_1381 w vss vss sky130_fd_pr__nfet_01v8 W=0.42 L=0.15
Xn_1381_p n_1381 w vdd vdd sky130_fd_pr__pfet_01v8 W=0.7 L=0.15
Xn_1382_p1 n_1382 n_1380 n_1382_x vdd sky130_fd_pr__pfet_01v8 W=1.4 L=0.15
Xn_1382_p2 n_1382_x w2 vdd vdd sky130_fd_pr__pfet_01v8 W=1.4 L=0.15
Xn_1382_n1 n_1382 n_1380 vss vss sky130_fd_pr__nfet_01v8 W=0.42 L=0.15
Xn_1382_n2 n_1382 w2 vss vss sky130_fd_pr__nfet_01v8 W=0.42 L=0.15
Xw2_p1 w2 n_1381 w2_x vdd sky130_fd_pr__pfet_01v8 W=1.4 L=0.15
Xw2_p2 w2_x n_1382 vdd vdd sky130_fd_pr__pfet_01v8 W=1.4 L=0.15
Xw2_n1 w2 n_1381 vss vss sky130_fd_pr__nfet_01v8 W=0.42 L=0.15
Xw2_n2 w2 n_1382 vss vss sky130_fd_pr__nfet_01v8 W=0.42 L=0.15
Xn_1383_n n_1383 w2 vss vss sky130_fd_pr__nfet_01v8 W=0.42 L=0.15
Xn_1383_p n_1383 w2 vdd vdd sky130_fd_pr__pfet_01v8 W=0.7 L=0.15
Xn_1384_p1 n_1384 n_1383 n_1384_x vdd sky130_fd_pr__pfet_01v8 W=1.4 L=0.15
Xn_1384_p2 n_1384_x t_phi1 vdd vdd sky130_fd_pr__pfet_01v8 W=1.4 L=0.15
Xn_1384_n1 n_1384 n_1383 vss vss sky130_fd_pr__nfet_01v8 W=0.42 L=0.15
Xn_1384_n2 n_1384 t_phi1 vss vss sky130_fd_pr__nfet_01v8 W=0.42 L=0.15
Xn_1385_n n_1385 n_1384 vss vss sky130_fd_pr__nfet_01v8 W=0.42 L=0.15
Xn_1385_p n_1385 n_1384 vdd vdd sky130_fd_pr__pfet_01v8 W=0.7 L=0.15
Xn_1386_n n_1386 n_1385 vss vss sky130_fd_pr__nfet_01v8 W=1.26 L=0.15
Xn_1386_p n_1386 n_1385 vdd vdd sky130_fd_pr__pfet_01v8 W=2.1 L=0.15
Xtphi1_n tphi1 n_1386 vss vss sky130_fd_pr__nfet_01v8 W=5.04 L=0.15
Xtphi1_p tphi1 n_1386 vdd vdd sky130_fd_pr__pfet_01v8 W=8.4 L=0.15
Xn_1387_p1 n_1387 n_1383 n_1387_x vdd sky130_fd_pr__pfet_01v8 W=1.4 L=0.15
Xn_1387_p2 n_1387_x t_phi1e vdd vdd sky130_fd_pr__pfet_01v8 W=1.4 L=0.15
Xn_1387_n1 n_1387 n_1383 vss vss sky130_fd_pr__nfet_01v8 W=0.42 L=0.15
Xn_1387_n2 n_1387 t_phi1e vss vss sky130_fd_pr__nfet_01v8 W=0.42 L=0.15
Xn_1388_n n_1388 n_1387 vss vss sky130_fd_pr__nfet_01v8 W=0.42 L=0.15
Xn_1388_p n_1388 n_1387 vdd vdd sky130_fd_pr__pfet_01v8 W=0.7 L=0.15
Xn_1389_n n_1389 n_1388 vss vss sky130_fd_pr__nfet_01v8 W=1.26 L=0.15
Xn_1389_p n_1389 n_1388 vdd vdd sky130_fd_pr__pfet_01v8 W=2.1 L=0.15
Xtphi1e_n tphi1e n_1389 vss vss sky130_fd_pr__nfet_01v8 W=3.36 L=0.15
Xtphi1e_p tphi1e n_1389 vdd vdd sky130_fd_pr__pfet_01v8 W=5.6 L=0.15
Xn_1390_p1 n_1390 w2 vdd vdd sky130_fd_pr__pfet_01v8 W=0.7 L=0.15
Xn_1390_p2 n_1390 t_phi2 vdd vdd sky130_fd_pr__pfet_01v8 W=0.7 L=0.15
Xn_1390_n1 n_1390 w2 n_1390_x vss sky130_fd_pr__nfet_01v8 W=0.84 L=0.15
Xn_1390_n2 n_1390_x t_phi2 vss vss sky130_fd_pr__nfet_01v8 W=0.84 L=0.15
Xn_1391_n n_1391 n_1390 vss vss sky130_fd_pr__nfet_01v8 W=0.42 L=0.15
Xn_1391_p n_1391 n_1390 vdd vdd sky130_fd_pr__pfet_01v8 W=0.7 L=0.15
Xn_1392_n n_1392 n_1391 vss vss sky130_fd_pr__nfet_01v8 W=0.42 L=0.15
Xn_1392_p n_1392 n_1391 vdd vdd sky130_fd_pr__pfet_01v8 W=0.7 L=0.15
Xtphi2_n tphi2 n_1392 vss vss sky130_fd_pr__nfet_01v8 W=0.42 L=0.15
Xtphi2_p tphi2 n_1392 vdd vdd sky130_fd_pr__pfet_01v8 W=0.7 L=0.15
.ends tile_seq

.subckt async_ctrl go adc_done xbar_rst adc_go latch_out done vdd vss
Xrst_dly go_buf rst_dly_raw vdd vss rst_delay
Xsettle_dly rst_delayed stl_dly_raw vdd vss settle_delay
Xinv_go1_n go_b go vss vss sky130_fd_pr__nfet_01v8 W=0.42 L=0.15
Xinv_go1_p go_b go vdd vdd sky130_fd_pr__pfet_01v8 W=0.7 L=0.15
Xinv_go2_n go_buf go_b vss vss sky130_fd_pr__nfet_01v8 W=0.42 L=0.15
Xinv_go2_p go_buf go_b vdd vdd sky130_fd_pr__pfet_01v8 W=0.7 L=0.15
Xinv_rd1_n rst_dly_b rst_dly_raw vss vss sky130_fd_pr__nfet_01v8 W=0.42 L=0.15
Xinv_rd1_p rst_dly_b rst_dly_raw vdd vdd sky130_fd_pr__pfet_01v8 W=0.7 L=0.15
Xinv_rd2_n rst_delayed rst_dly_b vss vss sky130_fd_pr__nfet_01v8 W=0.42 L=0.15
Xinv_rd2_p rst_delayed rst_dly_b vdd vdd sky130_fd_pr__pfet_01v8 W=0.7 L=0.15
Xnand_rst_p1 rst_nand go_buf vdd vdd sky130_fd_pr__pfet_01v8 W=0.7 L=0.15
Xnand_rst_p2 rst_nand rst_dly_b vdd vdd sky130_fd_pr__pfet_01v8 W=0.7 L=0.15
Xnand_rst_n1 rst_nand go_buf nand_rst_mid vss sky130_fd_pr__nfet_01v8 W=0.84 L=0.15
Xnand_rst_n2 nand_rst_mid rst_dly_b vss vss sky130_fd_pr__nfet_01v8 W=0.84 L=0.15
Xinv_rst_n xbar_rst rst_nand vss vss sky130_fd_pr__nfet_01v8 W=0.42 L=0.15
Xinv_rst_p xbar_rst rst_nand vdd vdd sky130_fd_pr__pfet_01v8 W=0.7 L=0.15
Xinv_sd1_n stl_dly_b stl_dly_raw vss vss sky130_fd_pr__nfet_01v8 W=0.42 L=0.15
Xinv_sd1_p stl_dly_b stl_dly_raw vdd vdd sky130_fd_pr__pfet_01v8 W=0.7 L=0.15
Xinv_sd2_n settle_delayed stl_dly_b vss vss sky130_fd_pr__nfet_01v8 W=0.42 L=0.15
Xinv_sd2_p settle_delayed stl_dly_b vdd vdd sky130_fd_pr__pfet_01v8 W=0.7 L=0.15
Xinv_ag1_n adc_go_b settle_delayed vss vss sky130_fd_pr__nfet_01v8 W=0.42 L=0.15
Xinv_ag1_p adc_go_b settle_delayed vdd vdd sky130_fd_pr__pfet_01v8 W=0.7 L=0.15
Xinv_ag2_n adc_go adc_go_b vss vss sky130_fd_pr__nfet_01v8 W=0.42 L=0.15
Xinv_ag2_p adc_go adc_go_b vdd vdd sky130_fd_pr__pfet_01v8 W=0.7 L=0.15
Xinv_ld1_n latch_b adc_done vss vss sky130_fd_pr__nfet_01v8 W=0.42 L=0.15
Xinv_ld1_p latch_b adc_done vdd vdd sky130_fd_pr__pfet_01v8 W=0.7 L=0.15
Xinv_ld2_n latch_out latch_b vss vss sky130_fd_pr__nfet_01v8 W=0.42 L=0.15
Xinv_ld2_p latch_out latch_b vdd vdd sky130_fd_pr__pfet_01v8 W=0.7 L=0.15
Xinv_dn1_n done_b latch_out vss vss sky130_fd_pr__nfet_01v8 W=0.42 L=0.15
Xinv_dn1_p done_b latch_out vdd vdd sky130_fd_pr__pfet_01v8 W=0.7 L=0.15
Xinv_dn2_n done done_b vss vss sky130_fd_pr__nfet_01v8 W=0.42 L=0.15
Xinv_dn2_p done done_b vdd vdd sky130_fd_pr__pfet_01v8 W=0.7 L=0.15
.ends async_ctrl
