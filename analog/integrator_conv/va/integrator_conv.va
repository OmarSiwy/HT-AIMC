// Column converter — behavioural golden model, ports 1:1 with netlist/integrator_conv
// (contract order, analog/analogioc/docs/INTERFACE.md §5).
//
//   integrator  OTA as a transconductor (gm, rout) from vcm - vg into out, C_int out->vg,
//               reset switch across C_int; awake = 0 cuts gm (out holds).
//   packet      switched-cap bank: c_pkt from tpk to the driver line pk_a; tpk to vcm on
//               phi1&run, to vg on phi2&run; pk_a = vdd * (fire&!sign & phi1e&run |
//               fire&sign & !(phi1&run)) — pwm_driver's outa.
//   SA1         out through r_kf/c_kf vs vinn = sgd ? (sign ? thr_p : thr_n) : vcm.
//   CDAC + SA2  acq samples vs = vcm + acq_gain*(out - vcm) (acq_gain: the measured OTA
//               droop under the CDAC load, specs.fine_ref_trim); in hold
//               ct - vcm = DAC - (vs - vcm), DAC = (sum b_k 2^k (vref - vcm)
//               + 0.5 (vref_o - vcm)) / 16, vref = sign ? sar_p : sar_n, vref_o the other.
//   outputs     c?p = vdd (1 - clk (1 + d)/2), c?n = vdd (1 - clk (1 - d)/2) through an RC
//               (td) and rout: both 1 in precharge, d = tanh(vinp - vinn) picks the rail
//               that falls (vinp > vinn -> c?p falls, the StrongARM convention).
// Continuous OpenVAF subset: tanh logic, RC delays, no events.
`include "disciplines.vams"
`include "constants.vams"

module integrator_conv(vg, out, rst, phi1, phi1e, phi2, run, fire, sign, sgd, clk_c,
                       c1p, c1n, acq, clk_f, b3, b2, b1, b0, c2p, c2n, awake, thr_p,
                       thr_n, sar_p, sar_n, vcm, vb_nc, vb_pc, vb_tail, vdd_ota, vdd_cmp,
                       vdd_pkt, vdd, vss);
    inout vg, out, rst, phi1, phi1e, phi2, run, fire, sign, sgd, clk_c, c1p, c1n, acq,
          clk_f, b3, b2, b1, b0, c2p, c2n, awake, thr_p, thr_n, sar_p, sar_n, vcm, vb_nc,
          vb_pc, vb_tail, vdd_ota, vdd_cmp, vdd_pkt, vdd, vss;
    electrical vg, out, rst, phi1, phi1e, phi2, run, fire, sign, sgd, clk_c, c1p, c1n, acq,
               clk_f, b3, b2, b1, b0, c2p, c2n, awake, thr_p, thr_n, sar_p, sar_n, vcm,
               vb_nc, vb_pc, vb_tail, vdd_ota, vdd_cmp, vdd_pkt, vdd, vss;
    electrical tpk, pka, f1, vs, d1p, d1n, d2p, d2n;

    parameter real c_int = 200e-15 from (0:inf);
    parameter real c_pkt = 2.377e-15 from (0:inf);
    parameter real c_ball = 3.75e-15 from [0:inf);
    parameter real gm = 1e-3 from (0:inf);         // OTA transconductance (S)
    parameter real rout = 1e9 from (0:inf);        // OTA output resistance (ohm)
    parameter real r_kf = 3.19e3 from (0:inf);     // SA1 anti-kick filter
    parameter real c_kf = 138e-15 from (0:inf);
    parameter real acq_gain = 0.8 from (0:1];      // sampled residue / held residue
    parameter real vres = 100e-6 from (0:inf);     // comparator resolution (V)
    parameter real td = 0.5e-9 from (0:inf);       // clk -> decision (s)
    parameter real gsw = 1e-3 from (0:inf);        // on-switch conductance (S)

    real vd, h_rst, h_aw, h_run, h_p1, h_p1e, h_p2, h_fire, h_sign, h_sgd, h_acq, h_ckc,
         h_ckf, vinn, fp, fn, pk, vref, vref_o, dac, d1, d2, ct, rf, cf, kb;

    analog function real hi;                         // 0/1 logic level of v
        input v, vdd_;
        real v, vdd_;
        hi = 0.5 * (1.0 + tanh((v - vdd_ / 2) / 0.02));
    endfunction

    analog begin
        vd = V(vdd, vss);
        h_rst = hi(V(rst, vss), vd);
        h_aw = hi(V(awake, vss), vd);
        h_run = hi(V(run, vss), vd);
        h_p1 = hi(V(phi1, vss), vd) * h_run;
        h_p1e = hi(V(phi1e, vss), vd) * h_run;
        h_p2 = hi(V(phi2, vss), vd) * h_run;
        h_fire = hi(V(fire, vss), vd);
        h_sign = hi(V(sign, vss), vd);
        h_sgd = hi(V(sgd, vss), vd);
        h_acq = hi(V(acq, vss), vd);
        h_ckc = hi(V(clk_c, vss), vd);
        h_ckf = hi(V(clk_f, vss), vd);
        // integrator
        I(out, vss) <+ -gm * h_aw * V(vcm, vg) + V(out, vcm) / rout;
        I(out, vss) <+ 10e-15 * ddt(V(out, vss));
        I(out, vg) <+ c_int * ddt(V(out, vg)) + gsw * h_rst * V(out, vg);
        // packet bank
        fp = h_fire * h_sign;
        fn = h_fire * (1.0 - h_sign);
        pk = 1.0 - (1.0 - fn * h_p1e) * (1.0 - fp * (1.0 - h_p1));
        I(pka, vss) <+ (V(pka, vss) - pk * vd) * gsw;
        I(tpk, pka) <+ c_pkt * ddt(V(tpk, pka));
        I(tpk, vss) <+ c_ball * ddt(V(tpk, vss));
        I(tpk, vcm) <+ gsw * h_p1 * V(tpk, vcm);
        I(tpk, vg) <+ gsw * h_p2 * V(tpk, vg);
        // SA1
        I(out, f1) <+ V(out, f1) / r_kf;
        I(f1, vss) <+ c_kf * ddt(V(f1, vss));
        vinn = (1.0 - h_sgd) * V(vcm, vss)
               + h_sgd * (h_sign * V(thr_p, vss) + (1.0 - h_sign) * V(thr_n, vss));
        d1 = tanh((V(f1, vss) - vinn) / vres);
        // CDAC sample and SA2
        I(vs, vss) <+ gsw * h_acq * (V(vs, vss) - V(vcm, vss) - acq_gain * V(out, vcm));
        I(vs, vss) <+ 100e-15 * ddt(V(vs, vss));
        vref = h_sign * V(sar_p, vss) + (1.0 - h_sign) * V(sar_n, vss);
        vref_o = h_sign * V(sar_n, vss) + (1.0 - h_sign) * V(sar_p, vss);
        kb = 1.0 - h_acq;
        dac = (8.0 * hi(V(b3, vss), vd) + 4.0 * hi(V(b2, vss), vd) + 2.0 * hi(V(b1, vss), vd)
               + hi(V(b0, vss), vd)) * (vref - V(vcm, vss)) + 0.5 * (vref_o - V(vcm, vss));
        ct = kb * (dac / 16.0 - V(vs, vcm));
        d2 = tanh(ct / vres);
        // outputs: RC delay (50 % at td), Thevenin out
        rf = 1e3;
        cf = td / (rf * ln(2.0));
        I(d1p, vss) <+ (V(d1p, vss) - vd * (1.0 - h_ckc * (1.0 + d1) / 2)) / rf
                       + cf * ddt(V(d1p, vss));
        I(d1n, vss) <+ (V(d1n, vss) - vd * (1.0 - h_ckc * (1.0 - d1) / 2)) / rf
                       + cf * ddt(V(d1n, vss));
        I(d2p, vss) <+ (V(d2p, vss) - vd * (1.0 - h_ckf * (1.0 + d2) / 2)) / rf
                       + cf * ddt(V(d2p, vss));
        I(d2n, vss) <+ (V(d2n, vss) - vd * (1.0 - h_ckf * (1.0 - d2) / 2)) / rf
                       + cf * ddt(V(d2n, vss));
        I(c1p, vss) <+ (V(c1p, vss) - V(d1p, vss)) / rf;
        I(c1n, vss) <+ (V(c1n, vss) - V(d1n, vss)) / rf;
        I(c2p, vss) <+ (V(c2p, vss) - V(d2p, vss)) / rf;
        I(c2n, vss) <+ (V(c2n, vss) - V(d2n, vss)) / rf;
    end
endmodule
