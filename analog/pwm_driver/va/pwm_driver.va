// PWM row driver — behavioural golden model, ports 1:1 with netlist/pwm_driver.
//   outa = (inp & phi1e) | (inn & !phi1)
//   outb = (inp & !phi1) | (inn & phi1e)
//
// Continuous form (OpenVAF subset: no @(cross), no transition()): tanh logic levels
// (threshold VDD/2, soft width vs), an internal RC per line for the gate delay (50 %
// crossing at td), a tanh regenerator on that node for a sharp edge, and a Thevenin
// output (rout) into the row load. Combinational, so nothing sequential is lost; not
// modelled: supply current, input capacitance, delay dependence on input slope/corner.
`include "disciplines.vams"
`include "constants.vams"

module pwm_driver(inp, inn, phi1, phi1e, outa, outb, vdd, vss);
    inout inp, inn, phi1, phi1e, outa, outb, vdd, vss;
    electrical inp, inn, phi1, phi1e, outa, outb, vdd, vss;
    electrical fa, fb;                              // delayed internal logic values

    parameter real td = 0.25e-9 from (0:inf);       // input -> line 50 % delay (s)
    parameter real rout = 300 from (0:inf);         // line driver resistance (ohm)
    parameter real vs = 0.05 from (0:inf);          // logic soft-threshold width (V)

    real vh, p, n, c1, ce, a, b, rf, cf;

    analog begin
        vh = V(vdd, vss) / 2;
        p = 0.5 * (1.0 + tanh((V(inp, vss) - vh) / vs));
        n = 0.5 * (1.0 + tanh((V(inn, vss) - vh) / vs));
        c1 = 0.5 * (1.0 + tanh((V(phi1, vss) - vh) / vs));
        ce = 0.5 * (1.0 + tanh((V(phi1e, vss) - vh) / vs));
        a = p * ce + n * (1.0 - c1) - p * ce * n * (1.0 - c1);   // x | y = x + y - xy
        b = p * (1.0 - c1) + n * ce - p * (1.0 - c1) * n * ce;
        rf = 1e3;
        cf = td / (rf * ln(2.0));                   // node crosses vh at td
        I(fa, vss) <+ (V(fa, vss) - a * V(vdd, vss)) / rf;
        I(fa, vss) <+ cf * ddt(V(fa, vss));
        I(fb, vss) <+ (V(fb, vss) - b * V(vdd, vss)) / rf;
        I(fb, vss) <+ cf * ddt(V(fb, vss));
        I(outa, vss) <+ (V(outa, vss) - V(vdd, vss) * 0.5 * (1.0 + tanh((V(fa, vss) - vh) / vs))) / rout;
        I(outb, vss) <+ (V(outb, vss) - V(vdd, vss) * 0.5 * (1.0 + tanh((V(fb, vss) - vh) / vs))) / rout;
    end
endmodule
