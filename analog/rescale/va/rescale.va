// Translinear rescale ratio pair — behavioural golden model, ports 1:1 with
// netlist/rescale.
// Tail sink: ib = ib0 * e^((V(vb_tail) - vb0) / (nt*vt)) (weak inversion).
// Split:     ihi : ilo = e^(beta*vhi) : e^(beta*vlo), beta = 1/(n*vt), so
//            g = ilo/ihi = e^(beta*(vlo - vhi)).
// Outputs:   each branch current, delayed by a first-order pole (tau: the mirror's
//            diode node), sourced from vdd into ihi/ilo with a tanh compliance knee.
// Supply:    2*ib (branch side + mirrored outputs).
// Not modelled: the fixed per-branch pole (the real one slows as the branch current
// falls), Early effect of the outputs, strong-inversion bending of the law at large dV.
`include "disciplines.vams"
`include "constants.vams"

module rescale(vhi, vlo, ihi, ilo, vb_tail, vdd, vss);
    inout vhi, vlo, ihi, ilo, vb_tail, vdd, vss;
    electrical vhi, vlo, ihi, ilo, vb_tail, vdd, vss;
    electrical xh, xl;                              // delayed branch currents (1 V = 1 uA)

    parameter real ib0 = 500e-9 from (0:inf);       // tail current at vb0 (A)
    parameter real vb0 = 0.446 from (0:inf);        // vb_tail for ib0 (V)
    parameter real nt = 1.43 from (1:inf);          // tail slope factor
    parameter real n = 1.43 from (1:inf);           // branch slope factor: beta = 1/(n*vt)
    parameter real tau = 100e-9 from (0:inf);       // output pole (s)
    parameter real vknee = 0.1 from (0:inf);        // output compliance knee (V)

    real vt, ib, flo, r;

    analog begin
        vt = $vt;
        ib = ib0 * limexp((V(vb_tail, vss) - vb0) / (nt * vt));
        flo = 1.0 / (1.0 + limexp((V(vhi, vss) - V(vlo, vss)) / (n * vt)));
        r = 1e3;
        I(xh, vss) <+ (V(xh, vss) - ib * (1.0 - flo) * 1e6) / r;
        I(xh, vss) <+ tau / r * ddt(V(xh, vss));
        I(xl, vss) <+ (V(xl, vss) - ib * flo * 1e6) / r;
        I(xl, vss) <+ tau / r * ddt(V(xl, vss));
        I(vdd, ihi) <+ V(xh, vss) * 1e-6 * tanh(V(vdd, ihi) / vknee);
        I(vdd, ilo) <+ V(xl, vss) * 1e-6 * tanh(V(vdd, ilo) / vknee);
        I(vdd, vss) <+ ib;
    end
endmodule
